* NGSPICE file created from cordic_neuron.ext - technology: sky130A

* Black-box entry subcircuit for sky130_ef_sc_hd__decap_12 abstract view
.subckt sky130_ef_sc_hd__decap_12 VPWR VGND VPB VNB
.ends

* Black-box entry subcircuit for sky130_fd_sc_hd__or2_2 abstract view
.subckt sky130_fd_sc_hd__or2_2 A B VGND VNB VPB VPWR X
.ends

* Black-box entry subcircuit for sky130_fd_sc_hd__nand2_2 abstract view
.subckt sky130_fd_sc_hd__nand2_2 A B VGND VNB VPB VPWR Y
.ends

* Black-box entry subcircuit for sky130_fd_sc_hd__o211a_2 abstract view
.subckt sky130_fd_sc_hd__o211a_2 A1 A2 B1 C1 VGND VNB VPB VPWR X
.ends

* Black-box entry subcircuit for sky130_fd_sc_hd__decap_6 abstract view
.subckt sky130_fd_sc_hd__decap_6 VGND VNB VPB VPWR
.ends

* Black-box entry subcircuit for sky130_fd_sc_hd__decap_4 abstract view
.subckt sky130_fd_sc_hd__decap_4 VGND VNB VPB VPWR
.ends

* Black-box entry subcircuit for sky130_fd_sc_hd__a21bo_2 abstract view
.subckt sky130_fd_sc_hd__a21bo_2 A1 A2 B1_N VGND VNB VPB VPWR X
.ends

* Black-box entry subcircuit for sky130_fd_sc_hd__and2b_2 abstract view
.subckt sky130_fd_sc_hd__and2b_2 A_N B VGND VNB VPB VPWR X
.ends

* Black-box entry subcircuit for sky130_fd_sc_hd__mux4_2 abstract view
.subckt sky130_fd_sc_hd__mux4_2 A0 A1 A2 A3 S0 S1 VGND VNB VPB VPWR X
.ends

* Black-box entry subcircuit for sky130_fd_sc_hd__tapvpwrvgnd_1 abstract view
.subckt sky130_fd_sc_hd__tapvpwrvgnd_1 VGND VPWR
.ends

* Black-box entry subcircuit for sky130_fd_sc_hd__decap_8 abstract view
.subckt sky130_fd_sc_hd__decap_8 VGND VNB VPB VPWR
.ends

* Black-box entry subcircuit for sky130_fd_sc_hd__o21a_2 abstract view
.subckt sky130_fd_sc_hd__o21a_2 A1 A2 B1 VGND VNB VPB VPWR X
.ends

* Black-box entry subcircuit for sky130_fd_sc_hd__or3b_2 abstract view
.subckt sky130_fd_sc_hd__or3b_2 A B C_N VGND VNB VPB VPWR X
.ends

* Black-box entry subcircuit for sky130_fd_sc_hd__fill_1 abstract view
.subckt sky130_fd_sc_hd__fill_1 VGND VNB VPB VPWR
.ends

* Black-box entry subcircuit for sky130_fd_sc_hd__decap_3 abstract view
.subckt sky130_fd_sc_hd__decap_3 VGND VNB VPB VPWR
.ends

* Black-box entry subcircuit for sky130_fd_sc_hd__o211ai_2 abstract view
.subckt sky130_fd_sc_hd__o211ai_2 A1 A2 B1 C1 VGND VNB VPB VPWR Y
.ends

* Black-box entry subcircuit for sky130_fd_sc_hd__xnor2_2 abstract view
.subckt sky130_fd_sc_hd__xnor2_2 A B VGND VNB VPB VPWR Y
.ends

* Black-box entry subcircuit for sky130_fd_sc_hd__a21oi_2 abstract view
.subckt sky130_fd_sc_hd__a21oi_2 A1 A2 B1 VGND VNB VPB VPWR Y
.ends

* Black-box entry subcircuit for sky130_fd_sc_hd__fill_2 abstract view
.subckt sky130_fd_sc_hd__fill_2 VGND VNB VPB VPWR
.ends

* Black-box entry subcircuit for sky130_fd_sc_hd__mux2_1 abstract view
.subckt sky130_fd_sc_hd__mux2_1 A0 A1 S VGND VNB VPB VPWR X
.ends

* Black-box entry subcircuit for sky130_fd_sc_hd__o21ai_2 abstract view
.subckt sky130_fd_sc_hd__o21ai_2 A1 A2 B1 VGND VNB VPB VPWR Y
.ends

* Black-box entry subcircuit for sky130_fd_sc_hd__or4_2 abstract view
.subckt sky130_fd_sc_hd__or4_2 A B C D VGND VNB VPB VPWR X
.ends

* Black-box entry subcircuit for sky130_fd_sc_hd__a21o_2 abstract view
.subckt sky130_fd_sc_hd__a21o_2 A1 A2 B1 VGND VNB VPB VPWR X
.ends

* Black-box entry subcircuit for sky130_fd_sc_hd__a211oi_2 abstract view
.subckt sky130_fd_sc_hd__a211oi_2 A1 A2 B1 C1 VGND VNB VPB VPWR Y
.ends

* Black-box entry subcircuit for sky130_fd_sc_hd__and2_2 abstract view
.subckt sky130_fd_sc_hd__and2_2 A B VGND VNB VPB VPWR X
.ends

* Black-box entry subcircuit for sky130_fd_sc_hd__a221o_2 abstract view
.subckt sky130_fd_sc_hd__a221o_2 A1 A2 B1 B2 C1 VGND VNB VPB VPWR X
.ends

* Black-box entry subcircuit for sky130_fd_sc_hd__nor2_2 abstract view
.subckt sky130_fd_sc_hd__nor2_2 A B VGND VNB VPB VPWR Y
.ends

* Black-box entry subcircuit for sky130_fd_sc_hd__inv_2 abstract view
.subckt sky130_fd_sc_hd__inv_2 A VGND VNB VPB VPWR Y
.ends

* Black-box entry subcircuit for sky130_fd_sc_hd__or3_2 abstract view
.subckt sky130_fd_sc_hd__or3_2 A B C VGND VNB VPB VPWR X
.ends

* Black-box entry subcircuit for sky130_fd_sc_hd__dfxtp_2 abstract view
.subckt sky130_fd_sc_hd__dfxtp_2 CLK D VGND VNB VPB VPWR Q
.ends

* Black-box entry subcircuit for sky130_fd_sc_hd__a311o_2 abstract view
.subckt sky130_fd_sc_hd__a311o_2 A1 A2 A3 B1 C1 VGND VNB VPB VPWR X
.ends

* Black-box entry subcircuit for sky130_fd_sc_hd__and3_2 abstract view
.subckt sky130_fd_sc_hd__and3_2 A B C VGND VNB VPB VPWR X
.ends

* Black-box entry subcircuit for sky130_fd_sc_hd__o221a_2 abstract view
.subckt sky130_fd_sc_hd__o221a_2 A1 A2 B1 B2 C1 VGND VNB VPB VPWR X
.ends

* Black-box entry subcircuit for sky130_fd_sc_hd__dfrtp_2 abstract view
.subckt sky130_fd_sc_hd__dfrtp_2 CLK D RESET_B VGND VNB VPB VPWR Q
.ends

* Black-box entry subcircuit for sky130_fd_sc_hd__xor2_2 abstract view
.subckt sky130_fd_sc_hd__xor2_2 A B VGND VNB VPB VPWR X
.ends

* Black-box entry subcircuit for sky130_fd_sc_hd__a31oi_2 abstract view
.subckt sky130_fd_sc_hd__a31oi_2 A1 A2 A3 B1 VGND VNB VPB VPWR Y
.ends

* Black-box entry subcircuit for sky130_fd_sc_hd__a31o_2 abstract view
.subckt sky130_fd_sc_hd__a31o_2 A1 A2 A3 B1 VGND VNB VPB VPWR X
.ends

* Black-box entry subcircuit for sky130_fd_sc_hd__nand4_2 abstract view
.subckt sky130_fd_sc_hd__nand4_2 A B C D VGND VNB VPB VPWR Y
.ends

* Black-box entry subcircuit for sky130_fd_sc_hd__dlxtn_1 abstract view
.subckt sky130_fd_sc_hd__dlxtn_1 D GATE_N VGND VNB VPB VPWR Q
.ends

* Black-box entry subcircuit for sky130_fd_sc_hd__a211o_2 abstract view
.subckt sky130_fd_sc_hd__a211o_2 A1 A2 B1 C1 VGND VNB VPB VPWR X
.ends

* Black-box entry subcircuit for sky130_fd_sc_hd__o311a_2 abstract view
.subckt sky130_fd_sc_hd__o311a_2 A1 A2 A3 B1 C1 VGND VNB VPB VPWR X
.ends

* Black-box entry subcircuit for sky130_fd_sc_hd__a21boi_2 abstract view
.subckt sky130_fd_sc_hd__a21boi_2 A1 A2 B1_N VGND VNB VPB VPWR Y
.ends

* Black-box entry subcircuit for sky130_fd_sc_hd__a22o_2 abstract view
.subckt sky130_fd_sc_hd__a22o_2 A1 A2 B1 B2 VGND VNB VPB VPWR X
.ends

* Black-box entry subcircuit for sky130_fd_sc_hd__or4b_2 abstract view
.subckt sky130_fd_sc_hd__or4b_2 A B C D_N VGND VNB VPB VPWR X
.ends

* Black-box entry subcircuit for sky130_fd_sc_hd__nand2b_2 abstract view
.subckt sky130_fd_sc_hd__nand2b_2 A_N B VGND VNB VPB VPWR Y
.ends

* Black-box entry subcircuit for sky130_fd_sc_hd__o31a_2 abstract view
.subckt sky130_fd_sc_hd__o31a_2 A1 A2 A3 B1 VGND VNB VPB VPWR X
.ends

* Black-box entry subcircuit for sky130_fd_sc_hd__a32o_2 abstract view
.subckt sky130_fd_sc_hd__a32o_2 A1 A2 A3 B1 B2 VGND VNB VPB VPWR X
.ends

* Black-box entry subcircuit for sky130_fd_sc_hd__and4_2 abstract view
.subckt sky130_fd_sc_hd__and4_2 A B C D VGND VNB VPB VPWR X
.ends

* Black-box entry subcircuit for sky130_fd_sc_hd__a32oi_2 abstract view
.subckt sky130_fd_sc_hd__a32oi_2 A1 A2 A3 B1 B2 VGND VNB VPB VPWR Y
.ends

* Black-box entry subcircuit for sky130_fd_sc_hd__nor3_2 abstract view
.subckt sky130_fd_sc_hd__nor3_2 A B C VGND VNB VPB VPWR Y
.ends

* Black-box entry subcircuit for sky130_fd_sc_hd__and3b_2 abstract view
.subckt sky130_fd_sc_hd__and3b_2 A_N B C VGND VNB VPB VPWR X
.ends

* Black-box entry subcircuit for sky130_fd_sc_hd__o32a_2 abstract view
.subckt sky130_fd_sc_hd__o32a_2 A1 A2 A3 B1 B2 VGND VNB VPB VPWR X
.ends

* Black-box entry subcircuit for sky130_fd_sc_hd__o21ba_2 abstract view
.subckt sky130_fd_sc_hd__o21ba_2 A1 A2 B1_N VGND VNB VPB VPWR X
.ends

* Black-box entry subcircuit for sky130_fd_sc_hd__o21bai_2 abstract view
.subckt sky130_fd_sc_hd__o21bai_2 A1 A2 B1_N VGND VNB VPB VPWR Y
.ends

* Black-box entry subcircuit for sky130_fd_sc_hd__o31ai_2 abstract view
.subckt sky130_fd_sc_hd__o31ai_2 A1 A2 A3 B1 VGND VNB VPB VPWR Y
.ends

* Black-box entry subcircuit for sky130_fd_sc_hd__o2bb2a_2 abstract view
.subckt sky130_fd_sc_hd__o2bb2a_2 A1_N A2_N B1 B2 VGND VNB VPB VPWR X
.ends

* Black-box entry subcircuit for sky130_fd_sc_hd__o311ai_2 abstract view
.subckt sky130_fd_sc_hd__o311ai_2 A1 A2 A3 B1 C1 VGND VNB VPB VPWR Y
.ends

* Black-box entry subcircuit for sky130_fd_sc_hd__clkbuf_8 abstract view
.subckt sky130_fd_sc_hd__clkbuf_8 A VGND VNB VPB VPWR X
.ends

* Black-box entry subcircuit for sky130_fd_sc_hd__o41a_2 abstract view
.subckt sky130_fd_sc_hd__o41a_2 A1 A2 A3 A4 B1 VGND VNB VPB VPWR X
.ends

* Black-box entry subcircuit for sky130_fd_sc_hd__o221ai_2 abstract view
.subckt sky130_fd_sc_hd__o221ai_2 A1 A2 B1 B2 C1 VGND VNB VPB VPWR Y
.ends

* Black-box entry subcircuit for sky130_fd_sc_hd__o22a_2 abstract view
.subckt sky130_fd_sc_hd__o22a_2 A1 A2 B1 B2 VGND VNB VPB VPWR X
.ends

* Black-box entry subcircuit for sky130_fd_sc_hd__inv_12 abstract view
.subckt sky130_fd_sc_hd__inv_12 A VGND VNB VPB VPWR Y
.ends

* Black-box entry subcircuit for sky130_fd_sc_hd__a22oi_2 abstract view
.subckt sky130_fd_sc_hd__a22oi_2 A1 A2 B1 B2 VGND VNB VPB VPWR Y
.ends

* Black-box entry subcircuit for sky130_fd_sc_hd__o2111a_2 abstract view
.subckt sky130_fd_sc_hd__o2111a_2 A1 A2 B1 C1 D1 VGND VNB VPB VPWR X
.ends

* Black-box entry subcircuit for sky130_fd_sc_hd__nand3_2 abstract view
.subckt sky130_fd_sc_hd__nand3_2 A B C VGND VNB VPB VPWR Y
.ends

* Black-box entry subcircuit for sky130_fd_sc_hd__a221oi_2 abstract view
.subckt sky130_fd_sc_hd__a221oi_2 A1 A2 B1 B2 C1 VGND VNB VPB VPWR Y
.ends

* Black-box entry subcircuit for sky130_fd_sc_hd__a41o_2 abstract view
.subckt sky130_fd_sc_hd__a41o_2 A1 A2 A3 A4 B1 VGND VNB VPB VPWR X
.ends

* Black-box entry subcircuit for sky130_fd_sc_hd__clkinv_8 abstract view
.subckt sky130_fd_sc_hd__clkinv_8 A VGND VNB VPB VPWR Y
.ends

* Black-box entry subcircuit for sky130_fd_sc_hd__inv_8 abstract view
.subckt sky130_fd_sc_hd__inv_8 A VGND VNB VPB VPWR Y
.ends

* Black-box entry subcircuit for sky130_fd_sc_hd__and4b_2 abstract view
.subckt sky130_fd_sc_hd__and4b_2 A_N B C D VGND VNB VPB VPWR X
.ends

* Black-box entry subcircuit for sky130_fd_sc_hd__a2bb2o_2 abstract view
.subckt sky130_fd_sc_hd__a2bb2o_2 A1_N A2_N B1 B2 VGND VNB VPB VPWR X
.ends

* Black-box entry subcircuit for sky130_fd_sc_hd__inv_6 abstract view
.subckt sky130_fd_sc_hd__inv_6 A VGND VNB VPB VPWR Y
.ends

* Black-box entry subcircuit for sky130_fd_sc_hd__inv_4 abstract view
.subckt sky130_fd_sc_hd__inv_4 A VGND VNB VPB VPWR Y
.ends

* Black-box entry subcircuit for sky130_fd_sc_hd__a2111oi_2 abstract view
.subckt sky130_fd_sc_hd__a2111oi_2 A1 A2 B1 C1 D1 VGND VNB VPB VPWR Y
.ends

* Black-box entry subcircuit for sky130_fd_sc_hd__clkbuf_16 abstract view
.subckt sky130_fd_sc_hd__clkbuf_16 A VGND VNB VPB VPWR X
.ends

* Black-box entry subcircuit for sky130_fd_sc_hd__nor4_2 abstract view
.subckt sky130_fd_sc_hd__nor4_2 A B C D VGND VNB VPB VPWR Y
.ends

* Black-box entry subcircuit for sky130_fd_sc_hd__clkinv_4 abstract view
.subckt sky130_fd_sc_hd__clkinv_4 A VGND VNB VPB VPWR Y
.ends

* Black-box entry subcircuit for sky130_fd_sc_hd__clkbuf_4 abstract view
.subckt sky130_fd_sc_hd__clkbuf_4 A VGND VNB VPB VPWR X
.ends

* Black-box entry subcircuit for sky130_fd_sc_hd__o2111ai_2 abstract view
.subckt sky130_fd_sc_hd__o2111ai_2 A1 A2 B1 C1 D1 VGND VNB VPB VPWR Y
.ends

* Black-box entry subcircuit for sky130_fd_sc_hd__clkinvlp_4 abstract view
.subckt sky130_fd_sc_hd__clkinvlp_4 A VGND VNB VPB VPWR Y
.ends

* Black-box entry subcircuit for sky130_fd_sc_hd__a311oi_2 abstract view
.subckt sky130_fd_sc_hd__a311oi_2 A1 A2 A3 B1 C1 VGND VNB VPB VPWR Y
.ends

* Black-box entry subcircuit for sky130_fd_sc_hd__o2bb2ai_2 abstract view
.subckt sky130_fd_sc_hd__o2bb2ai_2 A1_N A2_N B1 B2 VGND VNB VPB VPWR Y
.ends

* Black-box entry subcircuit for sky130_fd_sc_hd__nor3b_2 abstract view
.subckt sky130_fd_sc_hd__nor3b_2 A B C_N VGND VNB VPB VPWR Y
.ends

* Black-box entry subcircuit for sky130_fd_sc_hd__o41ai_2 abstract view
.subckt sky130_fd_sc_hd__o41ai_2 A1 A2 A3 A4 B1 VGND VNB VPB VPWR Y
.ends

* Black-box entry subcircuit for sky130_fd_sc_hd__inv_16 abstract view
.subckt sky130_fd_sc_hd__inv_16 A VGND VNB VPB VPWR Y
.ends

* Black-box entry subcircuit for sky130_fd_sc_hd__and4bb_2 abstract view
.subckt sky130_fd_sc_hd__and4bb_2 A_N B_N C D VGND VNB VPB VPWR X
.ends

* Black-box entry subcircuit for sky130_fd_sc_hd__a2111o_2 abstract view
.subckt sky130_fd_sc_hd__a2111o_2 A1 A2 B1 C1 D1 VGND VNB VPB VPWR X
.ends

* Black-box entry subcircuit for sky130_fd_sc_hd__nor4b_2 abstract view
.subckt sky130_fd_sc_hd__nor4b_2 A B C D_N VGND VNB VPB VPWR Y
.ends

* Black-box entry subcircuit for sky130_fd_sc_hd__nand3b_2 abstract view
.subckt sky130_fd_sc_hd__nand3b_2 A_N B C VGND VNB VPB VPWR Y
.ends

* Black-box entry subcircuit for sky130_fd_sc_hd__o22ai_2 abstract view
.subckt sky130_fd_sc_hd__o22ai_2 A1 A2 B1 B2 VGND VNB VPB VPWR Y
.ends

* Black-box entry subcircuit for sky130_fd_sc_hd__or4bb_2 abstract view
.subckt sky130_fd_sc_hd__or4bb_2 A B C_N D_N VGND VNB VPB VPWR X
.ends

* Black-box entry subcircuit for sky130_fd_sc_hd__a41oi_2 abstract view
.subckt sky130_fd_sc_hd__a41oi_2 A1 A2 A3 A4 B1 VGND VNB VPB VPWR Y
.ends

* Black-box entry subcircuit for sky130_fd_sc_hd__nand4b_2 abstract view
.subckt sky130_fd_sc_hd__nand4b_2 A_N B C D VGND VNB VPB VPWR Y
.ends

.subckt cordic_neuron VGND VPWR clk done mac_x_out[0] mac_x_out[10] mac_x_out[11]
+ mac_x_out[12] mac_x_out[13] mac_x_out[14] mac_x_out[15] mac_x_out[16] mac_x_out[17]
+ mac_x_out[18] mac_x_out[19] mac_x_out[1] mac_x_out[20] mac_x_out[21] mac_x_out[22]
+ mac_x_out[23] mac_x_out[24] mac_x_out[25] mac_x_out[26] mac_x_out[27] mac_x_out[28]
+ mac_x_out[29] mac_x_out[2] mac_x_out[30] mac_x_out[31] mac_x_out[3] mac_x_out[4]
+ mac_x_out[5] mac_x_out[6] mac_x_out[7] mac_x_out[8] mac_x_out[9] mac_y_out[0] mac_y_out[10]
+ mac_y_out[11] mac_y_out[12] mac_y_out[13] mac_y_out[14] mac_y_out[15] mac_y_out[16]
+ mac_y_out[17] mac_y_out[18] mac_y_out[19] mac_y_out[1] mac_y_out[20] mac_y_out[21]
+ mac_y_out[22] mac_y_out[23] mac_y_out[24] mac_y_out[25] mac_y_out[26] mac_y_out[27]
+ mac_y_out[28] mac_y_out[29] mac_y_out[2] mac_y_out[30] mac_y_out[31] mac_y_out[3]
+ mac_y_out[4] mac_y_out[5] mac_y_out[6] mac_y_out[7] mac_y_out[8] mac_y_out[9] rst
+ start tanh_out[0] tanh_out[10] tanh_out[11] tanh_out[12] tanh_out[13] tanh_out[14]
+ tanh_out[15] tanh_out[16] tanh_out[17] tanh_out[18] tanh_out[19] tanh_out[1] tanh_out[20]
+ tanh_out[21] tanh_out[22] tanh_out[23] tanh_out[24] tanh_out[25] tanh_out[26] tanh_out[27]
+ tanh_out[28] tanh_out[29] tanh_out[2] tanh_out[30] tanh_out[31] tanh_out[3] tanh_out[4]
+ tanh_out[5] tanh_out[6] tanh_out[7] tanh_out[8] tanh_out[9] x_in[0] x_in[10] x_in[11]
+ x_in[12] x_in[13] x_in[14] x_in[15] x_in[16] x_in[17] x_in[18] x_in[19] x_in[1]
+ x_in[20] x_in[21] x_in[22] x_in[23] x_in[24] x_in[25] x_in[26] x_in[27] x_in[28]
+ x_in[29] x_in[2] x_in[30] x_in[31] x_in[3] x_in[4] x_in[5] x_in[6] x_in[7] x_in[8]
+ x_in[9] y_in[0] y_in[10] y_in[11] y_in[12] y_in[13] y_in[14] y_in[15] y_in[16] y_in[17]
+ y_in[18] y_in[19] y_in[1] y_in[20] y_in[21] y_in[22] y_in[23] y_in[24] y_in[25]
+ y_in[26] y_in[27] y_in[28] y_in[29] y_in[2] y_in[30] y_in[31] y_in[3] y_in[4] y_in[5]
+ y_in[6] y_in[7] y_in[8] y_in[9] z_in[0] z_in[10] z_in[11] z_in[12] z_in[13] z_in[14]
+ z_in[15] z_in[16] z_in[17] z_in[18] z_in[19] z_in[1] z_in[20] z_in[21] z_in[22]
+ z_in[23] z_in[24] z_in[25] z_in[26] z_in[27] z_in[28] z_in[29] z_in[2] z_in[30]
+ z_in[31] z_in[3] z_in[4] z_in[5] z_in[6] z_in[7] z_in[8] z_in[9]
XFILLER_0_94_66 VPWR VGND VPWR VGND sky130_ef_sc_hd__decap_12
X_05903_ _00666_ _00847_ VGND VGND VPWR VPWR _00865_ sky130_fd_sc_hd__or2_2
X_06883_ tanh_inst.divider.i\[1\] tanh_inst.divider.i\[0\] VGND VGND VPWR VPWR _01765_
+ sky130_fd_sc_hd__nand2_2
X_09671_ _04324_ _04344_ VGND VGND VPWR VPWR _04397_ sky130_fd_sc_hd__or2_2
X_08622_ tanh_inst.divider.x\[4\] _02014_ _03403_ _01470_ VGND VGND VPWR VPWR _00261_
+ sky130_fd_sc_hd__o211a_2
X_05834_ mac_inst.z\[12\] _00800_ VGND VGND VPWR VPWR _00801_ sky130_fd_sc_hd__or2_2
XFILLER_0_27_93 VGND VGND VPWR VPWR sky130_fd_sc_hd__decap_6
XFILLER_0_77_612 VGND VGND VPWR VPWR sky130_fd_sc_hd__decap_4
X_05765_ _00712_ _00713_ _00725_ _00711_ VGND VGND VPWR VPWR _00738_ sky130_fd_sc_hd__o211a_2
X_08553_ _03317_ _03321_ _03316_ VGND VGND VPWR VPWR _03336_ sky130_fd_sc_hd__a21bo_2
X_08484_ _03267_ _03268_ VGND VGND VPWR VPWR _03269_ sky130_fd_sc_hd__and2b_2
X_07504_ tanh_inst.divider.y\[-1\] tanh_inst.divider.y\[0\] tanh_inst.divider.y\[1\]
+ tanh_inst.divider.y\[2\] tanh_inst.LOOKUP.index\[0\] tanh_inst.LOOKUP.index\[1\]
+ VGND VGND VPWR VPWR _02311_ sky130_fd_sc_hd__mux4_2
XTAP_TAPCELL_ROW_53_927 VGND VPWR sky130_fd_sc_hd__tapvpwrvgnd_1
XFILLER_0_91_103 VGND VGND VPWR VPWR sky130_fd_sc_hd__decap_8
X_07435_ _02241_ _02242_ _02019_ VGND VGND VPWR VPWR _02243_ sky130_fd_sc_hd__o21a_2
X_05696_ _04796_ _04980_ _00672_ VGND VGND VPWR VPWR _00674_ sky130_fd_sc_hd__or3b_2
XFILLER_0_37_509 VGND VGND VPWR VPWR sky130_fd_sc_hd__fill_1
XPHY_EDGE_ROW_99_Left_221 VGND VGND VPWR VPWR sky130_fd_sc_hd__decap_3
XTAP_TAPCELL_ROW_33_673 VGND VPWR sky130_fd_sc_hd__tapvpwrvgnd_1
XFILLER_0_119_279 VGND VGND VPWR VPWR sky130_fd_sc_hd__fill_1
X_07366_ _02169_ _02171_ _02173_ _02100_ VGND VGND VPWR VPWR _02175_ sky130_fd_sc_hd__o211ai_2
X_06317_ _01249_ _01251_ VGND VGND VPWR VPWR _01252_ sky130_fd_sc_hd__xnor2_2
X_09105_ _03795_ _03798_ _03845_ VGND VGND VPWR VPWR _03846_ sky130_fd_sc_hd__a21oi_2
X_07297_ tanh_inst.divider.y\[-20\] tanh_inst.divider.y\[-19\] tanh_inst.divider.y\[-18\]
+ tanh_inst.divider.y\[-17\] tanh_inst.LOOKUP.index\[0\] tanh_inst.LOOKUP.index\[1\]
+ VGND VGND VPWR VPWR _02107_ sky130_fd_sc_hd__mux4_2
XFILLER_0_60_512 VGND VGND VPWR VPWR sky130_fd_sc_hd__fill_1
XFILLER_0_45_597 VGND VGND VPWR VPWR sky130_fd_sc_hd__fill_2
X_06248_ _01116_ _01119_ tanh_inst.divider.i\[2\] VGND VGND VPWR VPWR _01188_ sky130_fd_sc_hd__mux2_1
X_09036_ _02018_ _03778_ _02015_ VGND VGND VPWR VPWR _03779_ sky130_fd_sc_hd__a21oi_2
XFILLER_0_32_225 VGND VGND VPWR VPWR sky130_fd_sc_hd__decap_6
X_06179_ tanh_inst.divider.x\[-21\] tanh_inst.divider.x\[-20\] tanh_inst.divider.x\[-19\]
+ tanh_inst.divider.x\[-18\] tanh_inst.divider.i\[0\] tanh_inst.divider.i\[1\] VGND
+ VGND VPWR VPWR _01123_ sky130_fd_sc_hd__mux4_2
XFILLER_0_7_81 VPWR VGND VPWR VGND sky130_ef_sc_hd__decap_12
XFILLER_0_110_190 VGND VGND VPWR VPWR sky130_fd_sc_hd__fill_1
X_09938_ _04615_ _04618_ _04655_ VGND VGND VPWR VPWR _04656_ sky130_fd_sc_hd__o21ai_2
XTAP_TAPCELL_ROW_5_321 VGND VPWR sky130_fd_sc_hd__tapvpwrvgnd_1
X_09869_ _03256_ _04546_ _04538_ VGND VGND VPWR VPWR _04589_ sky130_fd_sc_hd__o21a_2
XFILLER_0_87_409 VGND VGND VPWR VPWR sky130_fd_sc_hd__fill_1
XFILLER_0_67_133 VGND VGND VPWR VPWR sky130_fd_sc_hd__fill_2
XFILLER_0_83_615 VGND VGND VPWR VPWR sky130_fd_sc_hd__fill_1
XFILLER_0_67_177 VPWR VGND VPWR VGND sky130_ef_sc_hd__decap_12
XFILLER_0_70_309 VGND VGND VPWR VPWR sky130_fd_sc_hd__decap_4
XFILLER_0_36_531 VGND VGND VPWR VPWR sky130_fd_sc_hd__fill_1
XFILLER_0_106_430 VGND VGND VPWR VPWR sky130_fd_sc_hd__decap_8
XFILLER_0_91_670 VGND VGND VPWR VPWR sky130_fd_sc_hd__fill_2
XFILLER_0_63_350 VPWR VGND VPWR VGND sky130_ef_sc_hd__decap_12
XFILLER_0_106_452 VGND VGND VPWR VPWR sky130_fd_sc_hd__fill_1
XFILLER_0_90_180 VPWR VGND VPWR VGND sky130_ef_sc_hd__decap_12
XFILLER_0_23_225 VPWR VGND VPWR VGND sky130_ef_sc_hd__decap_12
XFILLER_0_121_477 VGND VGND VPWR VPWR sky130_fd_sc_hd__decap_8
XFILLER_0_48_15 VGND VGND VPWR VPWR sky130_fd_sc_hd__decap_3
XFILLER_0_3_39 VPWR VGND VPWR VGND sky130_ef_sc_hd__decap_12
XTAP_TAPCELL_ROW_108_1616 VGND VPWR sky130_fd_sc_hd__tapvpwrvgnd_1
X_10009_ _04722_ _04723_ VGND VGND VPWR VPWR _04725_ sky130_fd_sc_hd__xnor2_2
X_05550_ _00539_ _00542_ VGND VGND VPWR VPWR _00543_ sky130_fd_sc_hd__xnor2_2
XFILLER_0_80_24 VGND VGND VPWR VPWR sky130_fd_sc_hd__decap_4
XFILLER_0_104_53 VGND VGND VPWR VPWR sky130_fd_sc_hd__fill_2
XFILLER_0_73_103 VGND VGND VPWR VPWR sky130_fd_sc_hd__decap_8
XFILLER_0_13_51 VGND VGND VPWR VPWR sky130_fd_sc_hd__decap_4
X_05481_ _04836_ _00479_ _05021_ VGND VGND VPWR VPWR _00480_ sky130_fd_sc_hd__o21ai_2
XFILLER_0_46_328 VPWR VGND VPWR VGND sky130_ef_sc_hd__decap_12
X_07220_ tanh_inst.divider.y\[-9\] _02028_ _02029_ VGND VGND VPWR VPWR _02030_ sky130_fd_sc_hd__o21a_2
XFILLER_0_73_169 VGND VGND VPWR VPWR sky130_fd_sc_hd__fill_2
X_07151_ _01968_ _01972_ VGND VGND VPWR VPWR _01973_ sky130_fd_sc_hd__nand2_2
XTAP_TAPCELL_ROW_30_632 VGND VPWR sky130_fd_sc_hd__tapvpwrvgnd_1
XTAP_TAPCELL_ROW_30_643 VGND VPWR sky130_fd_sc_hd__tapvpwrvgnd_1
XFILLER_0_42_501 VPWR VGND VPWR VGND sky130_ef_sc_hd__decap_12
XFILLER_0_120_41 VPWR VGND VPWR VGND sky130_ef_sc_hd__decap_12
XTAP_TAPCELL_ROW_119_1745 VGND VPWR sky130_fd_sc_hd__tapvpwrvgnd_1
X_06102_ tanh_inst.divider.y_\[-11\] tanh_inst.divider.y_\[-12\] tanh_inst.divider.y_\[-9\]
+ tanh_inst.divider.y_\[-10\] VGND VGND VPWR VPWR _01049_ sky130_fd_sc_hd__or4_2
XFILLER_0_82_692 VGND VGND VPWR VPWR sky130_fd_sc_hd__decap_8
XFILLER_0_112_411 VGND VGND VPWR VPWR sky130_fd_sc_hd__decap_8
X_07082_ _01908_ _01909_ tanh_inst.divider.z_\[-7\] VGND VGND VPWR VPWR _01911_ sky130_fd_sc_hd__a21o_2
XFILLER_0_42_589 VGND VGND VPWR VPWR sky130_fd_sc_hd__fill_1
XFILLER_0_120_85 VPWR VGND VPWR VGND sky130_ef_sc_hd__decap_12
X_06033_ _00981_ _00985_ VGND VGND VPWR VPWR _06033_/Y sky130_fd_sc_hd__xnor2_2
XFILLER_0_112_499 VGND VGND VPWR VPWR sky130_fd_sc_hd__decap_4
XFILLER_0_10_442 VGND VGND VPWR VPWR sky130_fd_sc_hd__decap_6
XFILLER_0_2_697 VGND VGND VPWR VPWR sky130_fd_sc_hd__decap_3
X_07984_ _02778_ _02780_ VGND VGND VPWR VPWR _02781_ sky130_fd_sc_hd__nand2_2
X_06935_ tanh_inst.divider.y_\[7\] _01777_ _01778_ tanh_inst.divider.z_\[-23\] VGND
+ VGND VPWR VPWR _01780_ sky130_fd_sc_hd__a211oi_2
X_09723_ _02053_ _03875_ _04193_ VGND VGND VPWR VPWR _04447_ sky130_fd_sc_hd__o21a_2
X_06866_ tanh_inst.z_\[5\] _01667_ VGND VGND VPWR VPWR _01752_ sky130_fd_sc_hd__nand2_2
X_09654_ _03057_ _04378_ VGND VGND VPWR VPWR _04380_ sky130_fd_sc_hd__xnor2_2
X_08605_ _03385_ _03386_ VGND VGND VPWR VPWR _03387_ sky130_fd_sc_hd__or2_2
X_05817_ _00773_ _00784_ VGND VGND VPWR VPWR _00785_ sky130_fd_sc_hd__and2_2
XTAP_TAPCELL_ROW_38_732 VGND VPWR sky130_fd_sc_hd__tapvpwrvgnd_1
XTAP_TAPCELL_ROW_38_743 VGND VPWR sky130_fd_sc_hd__tapvpwrvgnd_1
X_06797_ tanh_inst.z_\[-5\] _01683_ _01691_ _01678_ _01690_ VGND VGND VPWR VPWR _01692_
+ sky130_fd_sc_hd__a221o_2
XFILLER_0_54_80 VGND VGND VPWR VPWR sky130_fd_sc_hd__decap_4
X_09585_ _04247_ _04272_ VGND VGND VPWR VPWR _04313_ sky130_fd_sc_hd__nor2_2
XFILLER_0_77_464 VGND VGND VPWR VPWR sky130_fd_sc_hd__decap_4
X_05748_ mac_inst.z\[31\] _00721_ _00718_ VGND VGND VPWR VPWR _00722_ sky130_fd_sc_hd__o21ai_2
X_08536_ _03319_ VGND VGND VPWR VPWR _03320_ sky130_fd_sc_hd__inv_2
X_05679_ _00652_ _00653_ mac_inst.z\[31\] VGND VGND VPWR VPWR _00659_ sky130_fd_sc_hd__a21oi_2
X_08467_ tanh_inst.divider.y\[1\] tanh_inst.divider.x\[1\] VGND VGND VPWR VPWR _03252_
+ sky130_fd_sc_hd__and2_2
XFILLER_0_92_467 VGND VGND VPWR VPWR sky130_fd_sc_hd__decap_4
X_07418_ tanh_inst.divider.y\[-22\] _02225_ VGND VGND VPWR VPWR _02226_ sky130_fd_sc_hd__nor2_2
X_08398_ _03150_ _03158_ _03184_ VGND VGND VPWR VPWR _03185_ sky130_fd_sc_hd__o21ai_2
XFILLER_0_52_309 VGND VGND VPWR VPWR sky130_fd_sc_hd__decap_4
X_07349_ tanh_inst.divider.y\[-23\] _02156_ _02157_ VGND VGND VPWR VPWR _02158_ sky130_fd_sc_hd__or3_2
XFILLER_0_45_372 VGND VGND VPWR VPWR sky130_fd_sc_hd__fill_1
XFILLER_0_33_545 VGND VGND VPWR VPWR sky130_fd_sc_hd__fill_1
XFILLER_0_103_422 VGND VGND VPWR VPWR sky130_fd_sc_hd__fill_2
X_10360_ clknet_leaf_18_clk _00217_ VGND VGND VPWR VPWR tanh_inst.divider.z_\[-4\]
+ sky130_fd_sc_hd__dfxtp_2
XTAP_TAPCELL_ROW_94_1439 VGND VPWR sky130_fd_sc_hd__tapvpwrvgnd_1
XFILLER_0_60_353 VGND VGND VPWR VPWR sky130_fd_sc_hd__decap_8
X_09019_ tanh_inst.LOOKUP.index\[2\] _03761_ _03760_ VGND VGND VPWR VPWR _03762_ sky130_fd_sc_hd__o21a_2
X_10291_ clknet_leaf_28_clk _00148_ VGND VGND VPWR VPWR tanh_inst.z_\[-4\] sky130_fd_sc_hd__dfxtp_2
XFILLER_0_18_29 VPWR VGND VPWR VGND sky130_ef_sc_hd__decap_12
XTAP_TAPCELL_ROW_103_1546 VGND VPWR sky130_fd_sc_hd__tapvpwrvgnd_1
XTAP_TAPCELL_ROW_16_459 VGND VPWR sky130_fd_sc_hd__tapvpwrvgnd_1
XFILLER_0_28_317 VGND VGND VPWR VPWR sky130_fd_sc_hd__decap_8
XFILLER_0_28_339 VGND VGND VPWR VPWR sky130_fd_sc_hd__decap_3
XFILLER_0_50_27 VGND VGND VPWR VPWR sky130_fd_sc_hd__fill_1
XFILLER_0_71_629 VGND VGND VPWR VPWR sky130_fd_sc_hd__decap_4
XFILLER_0_70_106 VGND VGND VPWR VPWR sky130_fd_sc_hd__fill_1
XFILLER_0_55_169 VGND VGND VPWR VPWR sky130_fd_sc_hd__decap_4
XFILLER_0_3_417 VGND VGND VPWR VPWR sky130_fd_sc_hd__decap_3
XFILLER_0_24_545 VPWR VGND VPWR VGND sky130_ef_sc_hd__decap_12
XFILLER_0_106_260 VPWR VGND VPWR VGND sky130_ef_sc_hd__decap_12
XFILLER_0_24_589 VGND VGND VPWR VPWR sky130_fd_sc_hd__fill_2
XFILLER_0_11_217 VGND VGND VPWR VPWR sky130_fd_sc_hd__decap_6
XTAP_TAPCELL_ROW_114_1686 VGND VPWR sky130_fd_sc_hd__tapvpwrvgnd_1
XTAP_TAPCELL_ROW_69_1121 VGND VPWR sky130_fd_sc_hd__tapvpwrvgnd_1
X_06720_ tanh_inst.z_\[-12\] _01622_ VGND VGND VPWR VPWR _01623_ sky130_fd_sc_hd__and2_2
X_06651_ _01560_ _01561_ VGND VGND VPWR VPWR _01562_ sky130_fd_sc_hd__xnor2_2
XTAP_TAPCELL_ROW_35_702 VGND VPWR sky130_fd_sc_hd__tapvpwrvgnd_1
X_05602_ _00588_ _00589_ VGND VGND VPWR VPWR _00590_ sky130_fd_sc_hd__xnor2_2
X_09370_ _04064_ _04067_ _04102_ VGND VGND VPWR VPWR _04104_ sky130_fd_sc_hd__or3_2
XFILLER_0_91_89 VGND VGND VPWR VPWR sky130_fd_sc_hd__fill_1
X_06582_ tanh_inst.z_\[-15\] tanh_inst.z_\[-16\] tanh_inst.z_\[-13\] tanh_inst.z_\[-14\]
+ VGND VGND VPWR VPWR _01497_ sky130_fd_sc_hd__or4_2
XFILLER_0_19_317 VPWR VGND VPWR VGND sky130_ef_sc_hd__decap_12
XFILLER_0_24_83 VGND VGND VPWR VPWR sky130_fd_sc_hd__fill_1
X_08321_ _03108_ _03109_ VGND VGND VPWR VPWR _03110_ sky130_fd_sc_hd__xnor2_2
X_05533_ _00501_ _00516_ _00517_ VGND VGND VPWR VPWR _00528_ sky130_fd_sc_hd__a21o_2
XFILLER_0_46_114 VGND VGND VPWR VPWR sky130_fd_sc_hd__decap_8
XFILLER_0_7_723 VGND VGND VPWR VPWR sky130_fd_sc_hd__fill_1
XFILLER_0_7_701 VGND VGND VPWR VPWR sky130_fd_sc_hd__fill_1
X_05464_ mac_inst.i\[3\] _00352_ _00412_ VGND VGND VPWR VPWR _00464_ sky130_fd_sc_hd__o21a_2
X_08252_ _03041_ VGND VGND VPWR VPWR _03042_ sky130_fd_sc_hd__inv_2
XFILLER_0_46_136 VGND VGND VPWR VPWR sky130_fd_sc_hd__decap_4
X_07203_ _02013_ _02012_ VGND VGND VPWR VPWR _02014_ sky130_fd_sc_hd__and2b_2
XFILLER_0_62_618 VGND VGND VPWR VPWR sky130_fd_sc_hd__decap_4
XFILLER_0_6_233 VPWR VGND VPWR VGND sky130_ef_sc_hd__decap_12
XFILLER_0_61_128 VGND VGND VPWR VPWR sky130_fd_sc_hd__decap_4
XFILLER_0_6_277 VPWR VGND VPWR VGND sky130_ef_sc_hd__decap_12
X_05395_ mac_inst.x\[31\] _05013_ _05014_ _05017_ _04781_ _04782_ VGND VGND VPWR VPWR
+ _00400_ sky130_fd_sc_hd__mux4_2
XFILLER_0_40_71 VPWR VGND VPWR VGND sky130_ef_sc_hd__decap_12
X_08183_ _02888_ _02890_ _02926_ _02972_ _02925_ VGND VGND VPWR VPWR _02975_ sky130_fd_sc_hd__a311o_2
X_07134_ _01956_ _01957_ VGND VGND VPWR VPWR _01958_ sky130_fd_sc_hd__nor2_2
XFILLER_0_70_662 VGND VGND VPWR VPWR sky130_fd_sc_hd__fill_1
XFILLER_0_15_556 VGND VGND VPWR VPWR sky130_fd_sc_hd__decap_4
XFILLER_0_30_504 VPWR VGND VPWR VGND sky130_ef_sc_hd__decap_12
X_07065_ tanh_inst.divider.z_\[-9\] _01893_ _01895_ VGND VGND VPWR VPWR _01896_ sky130_fd_sc_hd__and3_2
XFILLER_0_71_3 VPWR VGND VPWR VGND sky130_ef_sc_hd__decap_12
XFILLER_0_70_684 VGND VGND VPWR VPWR sky130_fd_sc_hd__fill_1
X_06016_ mac_inst.i\[29\] _00969_ VGND VGND VPWR VPWR _00970_ sky130_fd_sc_hd__and2_2
XFILLER_0_30_559 VGND VGND VPWR VPWR sky130_fd_sc_hd__fill_2
X_07967_ _02762_ _02763_ VGND VGND VPWR VPWR _02764_ sky130_fd_sc_hd__or2_2
X_06918_ tanh_inst.div_en tanh_inst.divider.z_\[0\] VGND VGND VPWR VPWR _00189_ sky130_fd_sc_hd__and2b_2
X_09706_ tanh_inst.divider.y\[-3\] _04428_ VGND VGND VPWR VPWR _04431_ sky130_fd_sc_hd__xnor2_2
X_07898_ tanh_inst.divider.y\[-12\] _02694_ VGND VGND VPWR VPWR _02696_ sky130_fd_sc_hd__and2_2
X_06849_ _01734_ _01737_ VGND VGND VPWR VPWR _01738_ sky130_fd_sc_hd__and2_2
XPHY_EDGE_ROW_27_Left_149 VGND VGND VPWR VPWR sky130_fd_sc_hd__decap_3
X_09637_ _04757_ _03811_ _04212_ VGND VGND VPWR VPWR _04363_ sky130_fd_sc_hd__a21oi_2
XFILLER_0_84_209 VPWR VGND VPWR VGND sky130_ef_sc_hd__decap_12
X_09568_ tanh_inst.divider.y\[-7\] _02014_ _04287_ _04296_ _01470_ VGND VGND VPWR
+ VPWR _00314_ sky130_fd_sc_hd__o221a_2
XFILLER_0_93_721 VGND VGND VPWR VPWR sky130_fd_sc_hd__decap_3
X_08519_ _03296_ _03302_ VGND VGND VPWR VPWR _03303_ sky130_fd_sc_hd__nor2_2
XFILLER_0_92_231 VGND VGND VPWR VPWR sky130_fd_sc_hd__decap_4
XFILLER_0_65_445 VGND VGND VPWR VPWR sky130_fd_sc_hd__decap_3
XTAP_TAPCELL_ROW_13_429 VGND VPWR sky130_fd_sc_hd__tapvpwrvgnd_1
X_09499_ _04161_ _04214_ VGND VGND VPWR VPWR _04229_ sky130_fd_sc_hd__nor2_2
XFILLER_0_65_478 VGND VGND VPWR VPWR sky130_fd_sc_hd__decap_6
X_10412_ clknet_leaf_36_clk _00269_ _00000_ VGND VGND VPWR VPWR mac_inst.i\[4\] sky130_fd_sc_hd__dfrtp_2
XPHY_EDGE_ROW_36_Left_158 VGND VGND VPWR VPWR sky130_fd_sc_hd__decap_3
X_10343_ clknet_leaf_15_clk _00200_ VGND VGND VPWR VPWR tanh_inst.divider.z_\[-21\]
+ sky130_fd_sc_hd__dfxtp_2
X_10274_ clknet_leaf_24_clk _00131_ VGND VGND VPWR VPWR tanh_inst.z_\[-21\] sky130_fd_sc_hd__dfxtp_2
XFILLER_0_29_39 VPWR VGND VPWR VGND sky130_ef_sc_hd__decap_12
XFILLER_0_88_526 VGND VGND VPWR VPWR sky130_fd_sc_hd__decap_6
XPHY_EDGE_ROW_45_Left_167 VGND VGND VPWR VPWR sky130_fd_sc_hd__decap_3
XFILLER_0_0_29 VPWR VGND VPWR VGND sky130_ef_sc_hd__decap_12
XFILLER_0_61_26 VGND VGND VPWR VPWR sky130_fd_sc_hd__fill_1
XTAP_TAPCELL_ROW_64_1062 VGND VPWR sky130_fd_sc_hd__tapvpwrvgnd_1
XFILLER_0_29_648 VPWR VGND VPWR VGND sky130_ef_sc_hd__decap_12
XFILLER_0_83_264 VPWR VGND VPWR VGND sky130_ef_sc_hd__decap_12
XFILLER_0_16_309 VPWR VGND VPWR VGND sky130_ef_sc_hd__decap_12
XFILLER_0_37_670 VGND VGND VPWR VPWR sky130_fd_sc_hd__fill_2
XPHY_EDGE_ROW_104_Right_104 VGND VGND VPWR VPWR sky130_fd_sc_hd__decap_3
XPHY_EDGE_ROW_54_Left_176 VGND VGND VPWR VPWR sky130_fd_sc_hd__decap_3
XFILLER_0_9_27 VPWR VGND VPWR VGND sky130_ef_sc_hd__decap_12
XFILLER_0_36_180 VGND VGND VPWR VPWR sky130_fd_sc_hd__decap_4
XTAP_TAPCELL_ROW_40_760 VGND VPWR sky130_fd_sc_hd__tapvpwrvgnd_1
XTAP_TAPCELL_ROW_116_1715 VGND VPWR sky130_fd_sc_hd__tapvpwrvgnd_1
XFILLER_0_114_528 VGND VGND VPWR VPWR sky130_fd_sc_hd__decap_4
XFILLER_0_52_640 VGND VGND VPWR VPWR sky130_fd_sc_hd__decap_4
XFILLER_0_3_225 VPWR VGND VPWR VGND sky130_ef_sc_hd__decap_12
X_05180_ mac_inst.x\[9\] _04852_ _04853_ VGND VGND VPWR VPWR _04884_ sky130_fd_sc_hd__a21oi_2
XFILLER_0_10_41 VPWR VGND VPWR VGND sky130_ef_sc_hd__decap_12
XFILLER_0_24_386 VGND VGND VPWR VPWR sky130_fd_sc_hd__fill_1
XFILLER_0_110_701 VGND VGND VPWR VPWR sky130_fd_sc_hd__decap_6
XFILLER_0_10_85 VPWR VGND VPWR VGND sky130_ef_sc_hd__decap_12
X_08870_ _04768_ _03612_ _03613_ VGND VGND VPWR VPWR _03615_ sky130_fd_sc_hd__and3_2
X_07821_ _02542_ _02544_ _02596_ VGND VGND VPWR VPWR _02621_ sky130_fd_sc_hd__and3_2
XFILLER_0_43_7 VGND VGND VPWR VPWR sky130_fd_sc_hd__fill_1
XPHY_EDGE_ROW_63_Left_185 VGND VGND VPWR VPWR sky130_fd_sc_hd__decap_3
X_07752_ _02552_ _02553_ VGND VGND VPWR VPWR _02554_ sky130_fd_sc_hd__and2b_2
X_07683_ _02270_ _02283_ _02024_ VGND VGND VPWR VPWR _02486_ sky130_fd_sc_hd__mux2_1
X_06703_ tanh_inst.z_\[-14\] _01606_ VGND VGND VPWR VPWR _01608_ sky130_fd_sc_hd__or2_2
XTAP_TAPCELL_ROW_48_860 VGND VPWR sky130_fd_sc_hd__tapvpwrvgnd_1
X_09422_ tanh_inst.divider.y\[-11\] _04153_ VGND VGND VPWR VPWR _04155_ sky130_fd_sc_hd__xnor2_2
X_06634_ _01472_ _01480_ _01484_ _01486_ _01531_ VGND VGND VPWR VPWR _01546_ sky130_fd_sc_hd__o221a_2
XFILLER_0_35_71 VGND VGND VPWR VPWR sky130_fd_sc_hd__fill_2
X_09353_ tanh_inst.divider.x\[7\] _03785_ _03786_ _03783_ _02023_ _02052_ VGND VGND
+ VPWR VPWR _04087_ sky130_fd_sc_hd__mux4_2
XFILLER_0_74_231 VGND VGND VPWR VPWR sky130_fd_sc_hd__fill_1
X_06565_ _04759_ _01476_ VGND VGND VPWR VPWR _01480_ sky130_fd_sc_hd__nand2_2
XFILLER_0_19_125 VPWR VGND VPWR VGND sky130_ef_sc_hd__decap_12
X_08304_ _03090_ _03092_ VGND VGND VPWR VPWR _03093_ sky130_fd_sc_hd__nor2_2
X_06496_ _01390_ _01404_ _01405_ VGND VGND VPWR VPWR _01417_ sky130_fd_sc_hd__o21ai_2
X_09284_ _02022_ _03668_ _02052_ VGND VGND VPWR VPWR _04020_ sky130_fd_sc_hd__o21ai_2
XPHY_EDGE_ROW_72_Left_194 VGND VGND VPWR VPWR sky130_fd_sc_hd__decap_3
XFILLER_0_19_169 VPWR VGND VPWR VGND sky130_ef_sc_hd__decap_12
X_05516_ _04911_ _00511_ _00509_ VGND VGND VPWR VPWR _00512_ sky130_fd_sc_hd__a21o_2
X_05447_ _00447_ _00448_ VGND VGND VPWR VPWR _05447_/X sky130_fd_sc_hd__xor2_2
X_08235_ _02990_ _02996_ _03024_ _02019_ VGND VGND VPWR VPWR _03026_ sky130_fd_sc_hd__a31oi_2
X_05378_ _04985_ _04989_ mac_inst.i\[2\] VGND VGND VPWR VPWR _00384_ sky130_fd_sc_hd__mux2_1
X_08166_ _04765_ _02956_ VGND VGND VPWR VPWR _02958_ sky130_fd_sc_hd__xnor2_2
X_07117_ _01923_ _01932_ _01941_ tanh_inst.divider.y_\[7\] VGND VGND VPWR VPWR _01942_
+ sky130_fd_sc_hd__a31o_2
XFILLER_0_113_561 VGND VGND VPWR VPWR sky130_fd_sc_hd__decap_8
X_08097_ _02882_ _02884_ _02886_ _02889_ VGND VGND VPWR VPWR _02891_ sky130_fd_sc_hd__nand4_2
X_07048_ _01877_ _01879_ tanh_inst.divider.z_\[-11\] VGND VGND VPWR VPWR _01881_ sky130_fd_sc_hd__a21o_2
X_08999_ tanh_inst.divider.x\[-21\] _03741_ VGND VGND VPWR VPWR _03742_ sky130_fd_sc_hd__xor2_2
XFILLER_0_97_389 VGND VGND VPWR VPWR sky130_fd_sc_hd__decap_3
XFILLER_0_85_529 VPWR VGND VPWR VGND sky130_ef_sc_hd__decap_12
XFILLER_0_38_412 VGND VGND VPWR VPWR sky130_fd_sc_hd__decap_8
XTAP_TAPCELL_ROW_100_1516 VGND VPWR sky130_fd_sc_hd__tapvpwrvgnd_1
XTAP_TAPCELL_ROW_26_587 VGND VPWR sky130_fd_sc_hd__tapvpwrvgnd_1
XFILLER_0_19_670 VGND VGND VPWR VPWR sky130_fd_sc_hd__fill_2
XFILLER_0_80_289 VPWR VGND VPWR VGND sky130_ef_sc_hd__decap_12
XFILLER_0_33_161 VGND VGND VPWR VPWR sky130_fd_sc_hd__decap_6
X_10326_ clknet_leaf_18_clk _00183_ VGND VGND VPWR VPWR tanh_out[18] sky130_fd_sc_hd__dfxtp_2
XTAP_TAPCELL_ROW_111_1645 VGND VPWR sky130_fd_sc_hd__tapvpwrvgnd_1
X_10257_ clknet_leaf_32_clk mac_inst.x\[19\] _00000_ VGND VGND VPWR VPWR mac_x_out[19]
+ sky130_fd_sc_hd__dfrtp_2
XFILLER_0_56_15 VGND VGND VPWR VPWR sky130_fd_sc_hd__decap_4
X_10188_ x_in[14] _00000_ VGND VGND VPWR VPWR mac_inst.x\[14\] sky130_fd_sc_hd__dlxtn_1
XTAP_TAPCELL_ROW_45_830 VGND VPWR sky130_fd_sc_hd__tapvpwrvgnd_1
X_06350_ tanh_inst.divider.y_\[-10\] _01281_ VGND VGND VPWR VPWR _01283_ sky130_fd_sc_hd__or2_2
XFILLER_0_84_584 VGND VGND VPWR VPWR sky130_fd_sc_hd__decap_4
XFILLER_0_84_573 VGND VGND VPWR VPWR sky130_fd_sc_hd__decap_4
XFILLER_0_56_275 VGND VGND VPWR VPWR sky130_fd_sc_hd__fill_1
X_06281_ _01217_ _01218_ VGND VGND VPWR VPWR _01219_ sky130_fd_sc_hd__xnor2_2
XFILLER_0_112_53 VPWR VGND VPWR VGND sky130_ef_sc_hd__decap_12
XFILLER_0_71_223 VGND VGND VPWR VPWR sky130_fd_sc_hd__fill_1
XFILLER_0_16_139 VGND VGND VPWR VPWR sky130_fd_sc_hd__fill_1
X_05301_ mac_inst.x\[3\] _04852_ _04853_ mac_inst.i\[0\] VGND VGND VPWR VPWR _05001_
+ sky130_fd_sc_hd__a211o_2
X_08020_ _02812_ _02814_ tanh_inst.z_\[7\] VGND VGND VPWR VPWR _02816_ sky130_fd_sc_hd__a21oi_2
X_05232_ _04782_ _04932_ VGND VGND VPWR VPWR _04933_ sky130_fd_sc_hd__and2_2
XFILLER_0_21_51 VGND VGND VPWR VPWR sky130_fd_sc_hd__decap_4
XFILLER_0_112_97 VPWR VGND VPWR VGND sky130_ef_sc_hd__decap_12
XTAP_TAPCELL_ROW_77_1220 VGND VPWR sky130_fd_sc_hd__tapvpwrvgnd_1
XFILLER_0_71_278 VGND VGND VPWR VPWR sky130_fd_sc_hd__fill_2
XFILLER_0_12_301 VGND VGND VPWR VPWR sky130_fd_sc_hd__decap_6
XFILLER_0_25_673 VGND VGND VPWR VPWR sky130_fd_sc_hd__decap_8
XFILLER_0_25_695 VGND VGND VPWR VPWR sky130_fd_sc_hd__decap_8
XFILLER_0_97_55 VGND VGND VPWR VPWR sky130_fd_sc_hd__fill_1
XFILLER_0_12_345 VPWR VGND VPWR VGND sky130_ef_sc_hd__decap_12
X_05163_ _04863_ _04864_ _04865_ _04866_ _04783_ mac_inst.i\[1\] VGND VGND VPWR VPWR
+ _04867_ sky130_fd_sc_hd__mux4_2
XFILLER_0_110_531 VGND VGND VPWR VPWR sky130_fd_sc_hd__fill_1
X_09971_ tanh_inst.divider.x\[5\] _04686_ VGND VGND VPWR VPWR _04688_ sky130_fd_sc_hd__and2_2
X_05094_ tanh_counter\[4\] _04806_ _00000_ VGND VGND VPWR VPWR _04813_ sky130_fd_sc_hd__o21ai_2
XFILLER_0_40_698 VGND VGND VPWR VPWR sky130_fd_sc_hd__fill_2
X_08922_ _03511_ _03558_ _03560_ _03512_ _04760_ tanh_inst.LOOKUP.index\[0\] VGND
+ VGND VPWR VPWR _03666_ sky130_fd_sc_hd__mux4_2
X_08853_ _02027_ _03595_ VGND VGND VPWR VPWR _03598_ sky130_fd_sc_hd__or2_2
XFILLER_0_34_3 VPWR VGND VPWR VGND sky130_ef_sc_hd__decap_12
XFILLER_0_98_109 VGND VGND VPWR VPWR sky130_fd_sc_hd__fill_2
X_08784_ tanh_inst.LOOKUP.index\[0\] _03508_ _03528_ VGND VGND VPWR VPWR _03530_ sky130_fd_sc_hd__and3_2
X_07804_ tanh_inst.divider.x\[-15\] _02604_ VGND VGND VPWR VPWR _02605_ sky130_fd_sc_hd__nand2_2
X_05996_ _00864_ _00905_ _00943_ _00949_ _00950_ VGND VGND VPWR VPWR _00951_ sky130_fd_sc_hd__o311a_2
X_07735_ tanh_inst.divider.y\[-16\] _02536_ VGND VGND VPWR VPWR _02537_ sky130_fd_sc_hd__nor2_2
XTAP_TAPCELL_ROW_88_1360 VGND VPWR sky130_fd_sc_hd__tapvpwrvgnd_1
XFILLER_0_79_312 VPWR VGND VPWR VGND sky130_ef_sc_hd__decap_12
XFILLER_0_79_345 VGND VGND VPWR VPWR sky130_fd_sc_hd__fill_2
X_09405_ _04135_ _04136_ VGND VGND VPWR VPWR _04138_ sky130_fd_sc_hd__nand2_2
XFILLER_0_67_529 VGND VGND VPWR VPWR sky130_fd_sc_hd__fill_1
X_07666_ _04758_ _02467_ _02468_ _02469_ VGND VGND VPWR VPWR _02470_ sky130_fd_sc_hd__o211a_2
XFILLER_0_48_721 VGND VGND VPWR VPWR sky130_fd_sc_hd__decap_3
X_07597_ _02400_ _02401_ _04791_ VGND VGND VPWR VPWR _02402_ sky130_fd_sc_hd__a21oi_2
XPHY_EDGE_ROW_80_Left_202 VGND VGND VPWR VPWR sky130_fd_sc_hd__decap_3
X_06617_ tanh_inst.LOOKUP.index\[0\] _01479_ _01529_ _01475_ VGND VGND VPWR VPWR _01530_
+ sky130_fd_sc_hd__a211o_2
XFILLER_0_62_91 VGND VGND VPWR VPWR sky130_fd_sc_hd__fill_1
X_09336_ _04070_ _04069_ VGND VGND VPWR VPWR _04071_ sky130_fd_sc_hd__and2b_2
X_06548_ tanh_inst.divider.y_\[6\] _01456_ _01460_ VGND VGND VPWR VPWR _01464_ sky130_fd_sc_hd__a21oi_2
XTAP_TAPCELL_ROW_23_546 VGND VPWR sky130_fd_sc_hd__tapvpwrvgnd_1
X_09267_ _04002_ _04003_ VGND VGND VPWR VPWR _04004_ sky130_fd_sc_hd__xnor2_2
XTAP_TAPCELL_ROW_51_899 VGND VPWR sky130_fd_sc_hd__tapvpwrvgnd_1
X_06479_ _04776_ _01215_ _01289_ VGND VGND VPWR VPWR _01401_ sky130_fd_sc_hd__a21boi_2
XFILLER_0_62_267 VGND VGND VPWR VPWR sky130_fd_sc_hd__fill_2
XFILLER_0_7_361 VPWR VGND VPWR VGND sky130_ef_sc_hd__decap_12
XFILLER_0_16_651 VGND VGND VPWR VPWR sky130_fd_sc_hd__fill_1
X_08218_ tanh_inst.divider.x\[-5\] _02999_ VGND VGND VPWR VPWR _03009_ sky130_fd_sc_hd__or2_2
X_09198_ _04791_ _03929_ _03935_ _03936_ _02019_ VGND VGND VPWR VPWR _03937_ sky130_fd_sc_hd__o221a_2
XFILLER_0_15_161 VGND VGND VPWR VPWR sky130_fd_sc_hd__decap_6
XFILLER_0_22_109 VPWR VGND VPWR VGND sky130_ef_sc_hd__decap_12
XFILLER_0_43_481 VGND VGND VPWR VPWR sky130_fd_sc_hd__decap_3
XFILLER_0_50_418 VGND VGND VPWR VPWR sky130_fd_sc_hd__fill_2
X_08149_ _02940_ _02941_ VGND VGND VPWR VPWR _02942_ sky130_fd_sc_hd__xnor2_2
XFILLER_0_30_153 VGND VGND VPWR VPWR sky130_fd_sc_hd__decap_6
X_10042_ tanh_inst.LOOKUP.index\[2\] _04752_ VGND VGND VPWR VPWR _04754_ sky130_fd_sc_hd__nor2_2
XFILLER_0_26_29 VPWR VGND VPWR VGND sky130_ef_sc_hd__decap_12
XTAP_TAPCELL_ROW_59_999 VGND VPWR sky130_fd_sc_hd__tapvpwrvgnd_1
XPHY_EDGE_ROW_119_Left_241 VGND VGND VPWR VPWR sky130_fd_sc_hd__decap_3
XFILLER_0_98_676 VGND VGND VPWR VPWR sky130_fd_sc_hd__decap_8
XTAP_TAPCELL_ROW_61_1021 VGND VPWR sky130_fd_sc_hd__tapvpwrvgnd_1
XFILLER_0_108_141 VGND VGND VPWR VPWR sky130_fd_sc_hd__decap_6
XFILLER_0_26_448 VGND VGND VPWR VPWR sky130_fd_sc_hd__decap_4
XFILLER_0_53_256 VGND VGND VPWR VPWR sky130_fd_sc_hd__fill_1
XFILLER_0_53_289 VGND VGND VPWR VPWR sky130_fd_sc_hd__fill_2
XFILLER_0_22_621 VGND VGND VPWR VPWR sky130_fd_sc_hd__fill_2
XFILLER_0_22_632 VPWR VGND VPWR VGND sky130_ef_sc_hd__decap_12
XFILLER_0_104_380 VGND VGND VPWR VPWR sky130_fd_sc_hd__decap_3
X_10309_ clknet_leaf_18_clk _00166_ VGND VGND VPWR VPWR tanh_out[1] sky130_fd_sc_hd__dfxtp_2
XTAP_TAPCELL_ROW_72_1161 VGND VPWR sky130_fd_sc_hd__tapvpwrvgnd_1
X_05850_ _00813_ _00815_ VGND VGND VPWR VPWR _00816_ sky130_fd_sc_hd__nand2_2
X_07520_ tanh_inst.divider.x\[-21\] _02326_ VGND VGND VPWR VPWR _02327_ sky130_fd_sc_hd__and2_2
X_05781_ mac_inst.z\[8\] _00751_ VGND VGND VPWR VPWR _00752_ sky130_fd_sc_hd__or2_2
XFILLER_0_88_153 VGND VGND VPWR VPWR sky130_fd_sc_hd__fill_1
XFILLER_0_76_304 VGND VGND VPWR VPWR sky130_fd_sc_hd__decap_4
XFILLER_0_88_197 VGND VGND VPWR VPWR sky130_fd_sc_hd__decap_4
XFILLER_0_76_337 VGND VGND VPWR VPWR sky130_fd_sc_hd__fill_1
X_07451_ _04757_ _02251_ _02258_ VGND VGND VPWR VPWR _02259_ sky130_fd_sc_hd__o21ai_2
XFILLER_0_29_220 VGND VGND VPWR VPWR sky130_fd_sc_hd__decap_4
X_06402_ tanh_inst.divider.y\[-6\] tanh_inst.div_en tanh_inst.divider.y_\[-6\] _01092_
+ VGND VGND VPWR VPWR _01331_ sky130_fd_sc_hd__a22o_2
X_07382_ _02189_ _02190_ tanh_inst.LOOKUP.index\[2\] VGND VGND VPWR VPWR _02191_ sky130_fd_sc_hd__mux2_1
X_06333_ _01229_ _01240_ _01249_ _01230_ VGND VGND VPWR VPWR _01267_ sky130_fd_sc_hd__or4b_2
XFILLER_0_84_381 VGND VGND VPWR VPWR sky130_fd_sc_hd__fill_1
X_09121_ tanh_inst.divider.y\[-19\] _03861_ VGND VGND VPWR VPWR _03862_ sky130_fd_sc_hd__and2_2
XFILLER_0_57_595 VGND VGND VPWR VPWR sky130_fd_sc_hd__decap_8
XTAP_TAPCELL_ROW_20_516 VGND VPWR sky130_fd_sc_hd__tapvpwrvgnd_1
X_06264_ tanh_inst.divider.y\[-17\] tanh_inst.div_en tanh_inst.divider.y_\[-17\] _01092_
+ _01203_ VGND VGND VPWR VPWR _00093_ sky130_fd_sc_hd__a221o_2
XFILLER_0_114_133 VGND VGND VPWR VPWR sky130_fd_sc_hd__decap_6
X_09052_ tanh_inst.divider.x\[-21\] _03741_ _03740_ VGND VGND VPWR VPWR _03794_ sky130_fd_sc_hd__o21ai_2
XFILLER_0_72_587 VGND VGND VPWR VPWR sky130_fd_sc_hd__fill_1
X_06195_ _01020_ _01022_ tanh_inst.divider.i\[2\] VGND VGND VPWR VPWR _01138_ sky130_fd_sc_hd__mux2_1
X_08003_ _02795_ _02798_ VGND VGND VPWR VPWR _02799_ sky130_fd_sc_hd__xnor2_2
X_05215_ mac_inst.x\[7\] _04852_ _04853_ VGND VGND VPWR VPWR _04919_ sky130_fd_sc_hd__a21oi_2
XFILLER_0_25_481 VGND VGND VPWR VPWR sky130_fd_sc_hd__fill_1
XFILLER_0_102_339 VPWR VGND VPWR VGND sky130_ef_sc_hd__decap_12
XFILLER_0_12_153 VPWR VGND VPWR VGND sky130_ef_sc_hd__decap_12
X_05146_ _04846_ _04847_ _04849_ VGND VGND VPWR VPWR _04850_ sky130_fd_sc_hd__or3_2
XFILLER_0_40_451 VPWR VGND VPWR VGND sky130_ef_sc_hd__decap_12
XFILLER_0_12_197 VPWR VGND VPWR VGND sky130_ef_sc_hd__decap_12
X_09954_ _04670_ _04671_ VGND VGND VPWR VPWR _04672_ sky130_fd_sc_hd__nor2_2
X_05077_ mac_inst.z\[11\] VGND VGND VPWR VPWR _04801_ sky130_fd_sc_hd__inv_2
XFILLER_0_110_394 VGND VGND VPWR VPWR sky130_fd_sc_hd__fill_2
XFILLER_0_57_80 VPWR VGND VPWR VGND sky130_ef_sc_hd__decap_12
X_09885_ _04603_ _04604_ VGND VGND VPWR VPWR _04605_ sky130_fd_sc_hd__nand2_2
X_08905_ tanh_inst.divider.x\[2\] tanh_inst.divider.x\[3\] tanh_inst.LOOKUP.index\[0\]
+ VGND VGND VPWR VPWR _03650_ sky130_fd_sc_hd__mux2_1
X_08836_ _02018_ _03572_ _03581_ _02014_ VGND VGND VPWR VPWR _03582_ sky130_fd_sc_hd__o211a_2
X_08767_ tanh_inst.divider.x\[-9\] _02028_ _03508_ VGND VGND VPWR VPWR _03513_ sky130_fd_sc_hd__o21ai_2
X_05979_ _00925_ _00928_ _00924_ VGND VGND VPWR VPWR _00935_ sky130_fd_sc_hd__a21bo_2
XTAP_TAPCELL_ROW_28_616 VGND VPWR sky130_fd_sc_hd__tapvpwrvgnd_1
X_08698_ _03461_ _03464_ _03476_ VGND VGND VPWR VPWR _03477_ sky130_fd_sc_hd__or3_2
X_07718_ _02519_ _02520_ VGND VGND VPWR VPWR _02521_ sky130_fd_sc_hd__nand2b_2
XTAP_TAPCELL_ROW_56_958 VGND VPWR sky130_fd_sc_hd__tapvpwrvgnd_1
XTAP_TAPCELL_ROW_0_252 VGND VPWR sky130_fd_sc_hd__tapvpwrvgnd_1
XTAP_TAPCELL_ROW_0_263 VGND VPWR sky130_fd_sc_hd__tapvpwrvgnd_1
XFILLER_0_95_668 VGND VGND VPWR VPWR sky130_fd_sc_hd__decap_4
X_07649_ _02449_ _02451_ _02452_ VGND VGND VPWR VPWR _02453_ sky130_fd_sc_hd__a21o_2
XFILLER_0_67_348 VPWR VGND VPWR VGND sky130_ef_sc_hd__decap_12
XFILLER_0_67_337 VGND VGND VPWR VPWR sky130_fd_sc_hd__fill_2
XFILLER_0_94_178 VGND VGND VPWR VPWR sky130_fd_sc_hd__decap_3
XFILLER_0_48_562 VPWR VGND VPWR VGND sky130_ef_sc_hd__decap_12
X_09319_ _04052_ _04053_ VGND VGND VPWR VPWR _04055_ sky130_fd_sc_hd__or2_2
XFILLER_0_105_111 VGND VGND VPWR VPWR sky130_fd_sc_hd__fill_1
XFILLER_0_50_215 VGND VGND VPWR VPWR sky130_fd_sc_hd__fill_1
XTAP_TAPCELL_ROW_8_363 VGND VPWR sky130_fd_sc_hd__tapvpwrvgnd_1
X_10025_ _04724_ _04729_ _04738_ _04791_ VGND VGND VPWR VPWR _04740_ sky130_fd_sc_hd__a31o_2
XFILLER_0_86_613 VGND VGND VPWR VPWR sky130_fd_sc_hd__decap_4
XTAP_TAPCELL_ROW_106_1588 VGND VPWR sky130_fd_sc_hd__tapvpwrvgnd_1
XFILLER_0_66_392 VGND VGND VPWR VPWR sky130_fd_sc_hd__decap_3
XFILLER_0_81_384 VGND VGND VPWR VPWR sky130_fd_sc_hd__decap_8
XFILLER_0_26_289 VPWR VGND VPWR VGND sky130_ef_sc_hd__decap_12
XFILLER_0_41_204 VPWR VGND VPWR VGND sky130_ef_sc_hd__decap_12
XFILLER_0_111_125 VPWR VGND VPWR VGND sky130_ef_sc_hd__decap_12
XFILLER_0_111_169 VGND VGND VPWR VPWR sky130_fd_sc_hd__fill_2
XFILLER_0_78_79 VGND VGND VPWR VPWR sky130_fd_sc_hd__decap_4
X_06951_ tanh_inst.divider.z_\[-21\] _01793_ VGND VGND VPWR VPWR _01794_ sky130_fd_sc_hd__and2_2
XFILLER_0_118_41 VPWR VGND VPWR VGND sky130_ef_sc_hd__decap_12
XFILLER_0_94_78 VGND VGND VPWR VPWR sky130_fd_sc_hd__decap_6
X_05902_ _00856_ _00864_ VGND VGND VPWR VPWR _05902_/Y sky130_fd_sc_hd__xnor2_2
X_09670_ _04394_ _04395_ VGND VGND VPWR VPWR _04396_ sky130_fd_sc_hd__and2_2
XFILLER_0_118_85 VPWR VGND VPWR VGND sky130_ef_sc_hd__decap_12
X_06882_ tanh_inst.divider.i\[0\] _01060_ tanh_inst.divider.i\[1\] VGND VGND VPWR
+ VPWR _01764_ sky130_fd_sc_hd__a21oi_2
X_08621_ _02014_ _03402_ VGND VGND VPWR VPWR _03403_ sky130_fd_sc_hd__nand2_2
X_05833_ mac_inst.z\[31\] _00799_ _00795_ VGND VGND VPWR VPWR _00800_ sky130_fd_sc_hd__o21ai_2
XTAP_TAPCELL_ROW_85_1330 VGND VPWR sky130_fd_sc_hd__tapvpwrvgnd_1
X_05764_ _00735_ _00736_ VGND VGND VPWR VPWR _00737_ sky130_fd_sc_hd__nand2_2
X_08552_ _03333_ _03334_ VGND VGND VPWR VPWR _03335_ sky130_fd_sc_hd__nor2_2
X_08483_ _03200_ _03203_ _03266_ VGND VGND VPWR VPWR _03268_ sky130_fd_sc_hd__o21ai_2
X_07503_ tanh_inst.divider.y\[-5\] tanh_inst.divider.y\[-4\] tanh_inst.divider.y\[-3\]
+ tanh_inst.divider.y\[-2\] tanh_inst.LOOKUP.index\[0\] tanh_inst.LOOKUP.index\[1\]
+ VGND VGND VPWR VPWR _02310_ sky130_fd_sc_hd__mux4_2
XTAP_TAPCELL_ROW_53_928 VGND VPWR sky130_fd_sc_hd__tapvpwrvgnd_1
XFILLER_0_119_225 VPWR VGND VPWR VGND sky130_ef_sc_hd__decap_12
X_07434_ _02170_ _02174_ _02240_ tanh_inst.z_\[7\] VGND VGND VPWR VPWR _02242_ sky130_fd_sc_hd__a31o_2
X_05695_ _00663_ _00672_ VGND VGND VPWR VPWR _00673_ sky130_fd_sc_hd__or2_2
X_07365_ _02100_ _02173_ _02171_ _02169_ VGND VGND VPWR VPWR _02174_ sky130_fd_sc_hd__a211o_2
XFILLER_0_17_223 VGND VGND VPWR VPWR sky130_fd_sc_hd__fill_1
XTAP_TAPCELL_ROW_33_674 VGND VPWR sky130_fd_sc_hd__tapvpwrvgnd_1
X_06316_ _04793_ _01250_ VGND VGND VPWR VPWR _01251_ sky130_fd_sc_hd__nand2_2
X_09104_ _03843_ _03844_ VGND VGND VPWR VPWR _03845_ sky130_fd_sc_hd__nand2_2
X_07296_ _02104_ _02105_ tanh_inst.LOOKUP.index\[2\] VGND VGND VPWR VPWR _02106_ sky130_fd_sc_hd__mux2_1
X_06247_ _04769_ tanh_inst.divider.i\[3\] VGND VGND VPWR VPWR _01187_ sky130_fd_sc_hd__nand2_2
XFILLER_0_103_615 VGND VGND VPWR VPWR sky130_fd_sc_hd__fill_1
X_09035_ _03776_ _03777_ VGND VGND VPWR VPWR _03778_ sky130_fd_sc_hd__xnor2_2
XFILLER_0_103_637 VGND VGND VPWR VPWR sky130_fd_sc_hd__fill_1
X_06178_ tanh_inst.divider.x\[-17\] tanh_inst.divider.x\[-16\] tanh_inst.divider.x\[-15\]
+ tanh_inst.divider.x\[-14\] tanh_inst.divider.i\[0\] tanh_inst.divider.i\[1\] VGND
+ VGND VPWR VPWR _01122_ sky130_fd_sc_hd__mux4_2
XFILLER_0_40_281 VGND VGND VPWR VPWR sky130_fd_sc_hd__fill_1
X_05129_ _04833_ _04834_ VGND VGND VPWR VPWR _00119_ sky130_fd_sc_hd__nor2_2
XFILLER_0_7_93 VPWR VGND VPWR VGND sky130_ef_sc_hd__decap_12
X_09937_ _04653_ _04654_ VGND VGND VPWR VPWR _04655_ sky130_fd_sc_hd__nor2_2
XTAP_TAPCELL_ROW_5_322 VGND VPWR sky130_fd_sc_hd__tapvpwrvgnd_1
X_09868_ _04587_ VGND VGND VPWR VPWR _04588_ sky130_fd_sc_hd__inv_2
X_08819_ tanh_inst.divider.x\[-5\] _02028_ _03508_ VGND VGND VPWR VPWR _03565_ sky130_fd_sc_hd__o21ai_2
X_09799_ tanh_inst.divider.x\[0\] _04519_ VGND VGND VPWR VPWR _04521_ sky130_fd_sc_hd__and2_2
XFILLER_0_67_101 VGND VGND VPWR VPWR sky130_fd_sc_hd__decap_8
XFILLER_0_82_104 VGND VGND VPWR VPWR sky130_fd_sc_hd__decap_8
XFILLER_0_67_189 VGND VGND VPWR VPWR sky130_fd_sc_hd__fill_1
XFILLER_0_55_318 VPWR VGND VPWR VGND sky130_ef_sc_hd__decap_12
XFILLER_0_118_280 VPWR VGND VPWR VGND sky130_ef_sc_hd__decap_12
XFILLER_0_63_362 VGND VGND VPWR VPWR sky130_fd_sc_hd__fill_2
XFILLER_0_51_502 VGND VGND VPWR VPWR sky130_fd_sc_hd__fill_2
XFILLER_0_90_192 VGND VGND VPWR VPWR sky130_fd_sc_hd__decap_4
XFILLER_0_90_170 VGND VGND VPWR VPWR sky130_fd_sc_hd__decap_3
XFILLER_0_2_109 VPWR VGND VPWR VGND sky130_ef_sc_hd__decap_12
XFILLER_0_23_237 VPWR VGND VPWR VGND sky130_ef_sc_hd__decap_12
XFILLER_0_48_27 VGND VGND VPWR VPWR sky130_fd_sc_hd__fill_1
XTAP_TAPCELL_ROW_108_1617 VGND VPWR sky130_fd_sc_hd__tapvpwrvgnd_1
XTAP_TAPCELL_ROW_108_1606 VGND VPWR sky130_fd_sc_hd__tapvpwrvgnd_1
X_10008_ _04720_ _04721_ _04723_ VGND VGND VPWR VPWR _04724_ sky130_fd_sc_hd__or3_2
XFILLER_0_86_421 VPWR VGND VPWR VGND sky130_ef_sc_hd__decap_12
XFILLER_0_67_690 VGND VGND VPWR VPWR sky130_fd_sc_hd__decap_4
X_05480_ mac_inst.i\[3\] _00370_ _00412_ VGND VGND VPWR VPWR _00479_ sky130_fd_sc_hd__o21a_2
XFILLER_0_39_381 VGND VGND VPWR VPWR sky130_fd_sc_hd__decap_8
XTAP_TAPCELL_ROW_80_1260 VGND VPWR sky130_fd_sc_hd__tapvpwrvgnd_1
XFILLER_0_6_415 VGND VGND VPWR VPWR sky130_fd_sc_hd__decap_4
XFILLER_0_116_239 VGND VGND VPWR VPWR sky130_fd_sc_hd__fill_1
X_07150_ _01938_ _01953_ _01970_ _01971_ VGND VGND VPWR VPWR _01972_ sky130_fd_sc_hd__o31a_2
XFILLER_0_82_671 VPWR VGND VPWR VGND sky130_ef_sc_hd__decap_12
XTAP_TAPCELL_ROW_30_633 VGND VPWR sky130_fd_sc_hd__tapvpwrvgnd_1
XFILLER_0_42_513 VGND VGND VPWR VPWR sky130_fd_sc_hd__decap_4
XTAP_TAPCELL_ROW_119_1746 VGND VPWR sky130_fd_sc_hd__tapvpwrvgnd_1
X_06101_ tanh_inst.divider.y_\[1\] tanh_inst.divider.y_\[0\] tanh_inst.divider.y_\[3\]
+ tanh_inst.divider.y_\[2\] VGND VGND VPWR VPWR _01048_ sky130_fd_sc_hd__or4_2
X_07081_ tanh_inst.divider.z_\[-7\] _01908_ _01909_ VGND VGND VPWR VPWR _01910_ sky130_fd_sc_hd__and3_2
XFILLER_0_81_181 VPWR VGND VPWR VGND sky130_ef_sc_hd__decap_12
XFILLER_0_42_546 VGND VGND VPWR VPWR sky130_fd_sc_hd__decap_3
XFILLER_0_120_53 VPWR VGND VPWR VGND sky130_ef_sc_hd__decap_12
XFILLER_0_112_434 VGND VGND VPWR VPWR sky130_fd_sc_hd__decap_4
XFILLER_0_42_557 VPWR VGND VPWR VGND sky130_ef_sc_hd__decap_12
XFILLER_0_120_97 VPWR VGND VPWR VGND sky130_ef_sc_hd__decap_12
X_06032_ _00940_ _00946_ _00975_ _00983_ VGND VGND VPWR VPWR _00985_ sky130_fd_sc_hd__a31o_2
XTAP_TAPCELL_ROW_10_390 VGND VPWR sky130_fd_sc_hd__tapvpwrvgnd_1
X_07983_ tanh_inst.divider.x\[-11\] _02777_ VGND VGND VPWR VPWR _02780_ sky130_fd_sc_hd__nand2_2
X_09722_ _04444_ _04445_ VGND VGND VPWR VPWR _04446_ sky130_fd_sc_hd__nor2_2
X_06934_ tanh_inst.divider.y_\[7\] _01773_ _01777_ tanh_inst.divider.z_\[-23\] VGND
+ VGND VPWR VPWR _01779_ sky130_fd_sc_hd__o211a_2
X_06865_ _01502_ _01750_ _01751_ _01469_ mac_y_out[28] VGND VGND VPWR VPWR _00156_
+ sky130_fd_sc_hd__a32o_2
X_09653_ _03057_ _04378_ VGND VGND VPWR VPWR _04379_ sky130_fd_sc_hd__or2_2
X_08604_ _03357_ _03384_ VGND VGND VPWR VPWR _03386_ sky130_fd_sc_hd__and2_2
X_05816_ _00741_ _00748_ _00761_ _00783_ VGND VGND VPWR VPWR _00784_ sky130_fd_sc_hd__and4_2
XTAP_TAPCELL_ROW_38_733 VGND VPWR sky130_fd_sc_hd__tapvpwrvgnd_1
X_09584_ _04270_ _04311_ VGND VGND VPWR VPWR _04312_ sky130_fd_sc_hd__nor2_2
XPHY_EDGE_ROW_118_Right_118 VGND VGND VPWR VPWR sky130_fd_sc_hd__decap_3
XFILLER_0_89_281 VGND VGND VPWR VPWR sky130_fd_sc_hd__fill_1
X_06796_ _01676_ _01684_ VGND VGND VPWR VPWR _01691_ sky130_fd_sc_hd__nor2_2
X_08535_ _03207_ _03267_ _03268_ VGND VGND VPWR VPWR _03319_ sky130_fd_sc_hd__o21a_2
X_05747_ _00705_ _00709_ VGND VGND VPWR VPWR _00721_ sky130_fd_sc_hd__nor2_2
XTAP_TAPCELL_ROW_18_490 VGND VPWR sky130_fd_sc_hd__tapvpwrvgnd_1
X_05678_ _00649_ _00655_ _00656_ _00654_ mac_inst.y\[30\] VGND VGND VPWR VPWR _00658_
+ sky130_fd_sc_hd__a32oi_2
X_08466_ tanh_inst.divider.y\[1\] tanh_inst.divider.x\[1\] VGND VGND VPWR VPWR _03251_
+ sky130_fd_sc_hd__or2_2
XFILLER_0_49_178 VPWR VGND VPWR VGND sky130_ef_sc_hd__decap_12
X_07417_ _04773_ _02223_ VGND VGND VPWR VPWR _02225_ sky130_fd_sc_hd__xnor2_2
X_08397_ _03182_ _03183_ VGND VGND VPWR VPWR _03184_ sky130_fd_sc_hd__nor2_2
XFILLER_0_107_239 VGND VGND VPWR VPWR sky130_fd_sc_hd__fill_2
X_07348_ _04774_ _02139_ _02155_ VGND VGND VPWR VPWR _02157_ sky130_fd_sc_hd__and3_2
X_07279_ tanh_inst.divider.y\[-5\] _02028_ _02029_ VGND VGND VPWR VPWR _02089_ sky130_fd_sc_hd__o21ai_2
XFILLER_0_60_365 VPWR VGND VPWR VGND sky130_ef_sc_hd__decap_12
XFILLER_0_115_294 VGND VGND VPWR VPWR sky130_fd_sc_hd__fill_1
XFILLER_0_103_445 VGND VGND VPWR VPWR sky130_fd_sc_hd__decap_3
X_10290_ clknet_leaf_28_clk _00147_ VGND VGND VPWR VPWR tanh_inst.z_\[-5\] sky130_fd_sc_hd__dfxtp_2
X_09018_ tanh_inst.divider.x\[3\] tanh_inst.divider.x\[4\] tanh_inst.divider.x\[5\]
+ tanh_inst.divider.x\[6\] tanh_inst.LOOKUP.index\[0\] tanh_inst.LOOKUP.index\[1\]
+ VGND VGND VPWR VPWR _03761_ sky130_fd_sc_hd__mux4_2
XFILLER_0_13_281 VPWR VGND VPWR VGND sky130_ef_sc_hd__decap_12
XFILLER_0_68_421 VPWR VGND VPWR VGND sky130_ef_sc_hd__decap_12
XFILLER_0_68_410 VGND VGND VPWR VPWR sky130_fd_sc_hd__decap_8
XTAP_TAPCELL_ROW_103_1547 VGND VPWR sky130_fd_sc_hd__tapvpwrvgnd_1
XFILLER_0_28_307 VGND VGND VPWR VPWR sky130_fd_sc_hd__fill_1
XFILLER_0_36_351 VGND VGND VPWR VPWR sky130_fd_sc_hd__fill_1
XFILLER_0_91_490 VGND VGND VPWR VPWR sky130_fd_sc_hd__decap_3
XFILLER_0_64_682 VGND VGND VPWR VPWR sky130_fd_sc_hd__fill_2
XFILLER_0_51_321 VPWR VGND VPWR VGND sky130_ef_sc_hd__decap_12
XFILLER_0_106_272 VGND VGND VPWR VPWR sky130_fd_sc_hd__fill_2
XFILLER_0_59_15 VPWR VGND VPWR VGND sky130_ef_sc_hd__decap_12
XFILLER_0_3_429 VPWR VGND VPWR VGND sky130_ef_sc_hd__decap_12
XFILLER_0_24_557 VGND VGND VPWR VPWR sky130_fd_sc_hd__decap_3
XFILLER_0_106_294 VGND VGND VPWR VPWR sky130_fd_sc_hd__decap_3
XFILLER_0_51_387 VGND VGND VPWR VPWR sky130_fd_sc_hd__decap_4
XFILLER_0_121_253 VPWR VGND VPWR VGND sky130_ef_sc_hd__decap_12
XTAP_TAPCELL_ROW_114_1687 VGND VPWR sky130_fd_sc_hd__tapvpwrvgnd_1
XFILLER_0_75_25 VGND VGND VPWR VPWR sky130_fd_sc_hd__decap_8
XFILLER_0_78_218 VGND VGND VPWR VPWR sky130_fd_sc_hd__decap_6
X_06650_ _01551_ _01552_ _01549_ VGND VGND VPWR VPWR _01561_ sky130_fd_sc_hd__a21o_2
XTAP_TAPCELL_ROW_69_1122 VGND VPWR sky130_fd_sc_hd__tapvpwrvgnd_1
XFILLER_0_91_57 VGND VGND VPWR VPWR sky130_fd_sc_hd__fill_2
XTAP_TAPCELL_ROW_35_703 VGND VPWR sky130_fd_sc_hd__tapvpwrvgnd_1
X_05601_ _00575_ _00576_ mac_inst.z\[31\] VGND VGND VPWR VPWR _00589_ sky130_fd_sc_hd__a21oi_2
XFILLER_0_91_68 VGND VGND VPWR VPWR sky130_fd_sc_hd__decap_3
X_06581_ tanh_inst.z_\[-23\] tanh_inst.z_\[-24\] tanh_inst.z_\[-21\] tanh_inst.z_\[-22\]
+ VGND VGND VPWR VPWR _01496_ sky130_fd_sc_hd__or4_2
XFILLER_0_74_402 VGND VGND VPWR VPWR sky130_fd_sc_hd__decap_8
XFILLER_0_59_476 VGND VGND VPWR VPWR sky130_fd_sc_hd__decap_8
XFILLER_0_19_329 VGND VGND VPWR VPWR sky130_fd_sc_hd__decap_6
X_08320_ _03068_ _03069_ _04791_ VGND VGND VPWR VPWR _03109_ sky130_fd_sc_hd__o21ai_2
X_05532_ mac_inst.y\[16\] _00526_ VGND VGND VPWR VPWR _00527_ sky130_fd_sc_hd__xnor2_2
X_05463_ mac_inst.i\[3\] _00349_ _00462_ _04912_ VGND VGND VPWR VPWR _00463_ sky130_fd_sc_hd__a211o_2
X_08251_ _02964_ _03038_ _03040_ VGND VGND VPWR VPWR _03041_ sky130_fd_sc_hd__o21a_2
XFILLER_0_47_649 VPWR VGND VPWR VGND sky130_ef_sc_hd__decap_12
XFILLER_0_117_559 VGND VGND VPWR VPWR sky130_fd_sc_hd__fill_1
X_07202_ _01514_ _01524_ _01501_ VGND VGND VPWR VPWR _02013_ sky130_fd_sc_hd__a21o_2
XFILLER_0_6_245 VGND VGND VPWR VPWR sky130_fd_sc_hd__decap_6
X_05394_ mac_inst.i\[2\] _05014_ _00350_ VGND VGND VPWR VPWR _00399_ sky130_fd_sc_hd__o21a_2
X_08182_ _02888_ _02890_ _02926_ _02925_ VGND VGND VPWR VPWR _02974_ sky130_fd_sc_hd__a31o_2
X_07133_ _01954_ _01955_ _01952_ VGND VGND VPWR VPWR _01957_ sky130_fd_sc_hd__a21oi_2
XFILLER_0_70_641 VGND VGND VPWR VPWR sky130_fd_sc_hd__decap_3
XFILLER_0_6_289 VPWR VGND VPWR VGND sky130_ef_sc_hd__decap_12
XFILLER_0_40_83 VGND VGND VPWR VPWR sky130_fd_sc_hd__fill_1
XFILLER_0_42_365 VPWR VGND VPWR VGND sky130_ef_sc_hd__decap_12
X_07064_ tanh_inst.divider.y_\[7\] _01894_ VGND VGND VPWR VPWR _01895_ sky130_fd_sc_hd__or2_2
XFILLER_0_70_696 VGND VGND VPWR VPWR sky130_fd_sc_hd__fill_1
XPHY_EDGE_ROW_12_Right_12 VGND VGND VPWR VPWR sky130_fd_sc_hd__decap_3
XFILLER_0_30_516 VGND VGND VPWR VPWR sky130_fd_sc_hd__fill_1
XFILLER_0_112_253 VGND VGND VPWR VPWR sky130_fd_sc_hd__decap_4
XFILLER_0_64_3 VGND VGND VPWR VPWR sky130_fd_sc_hd__decap_6
X_06015_ mac_inst.i\[25\] _04947_ _00967_ VGND VGND VPWR VPWR _00969_ sky130_fd_sc_hd__and3_2
XFILLER_0_10_251 VGND VGND VPWR VPWR sky130_fd_sc_hd__fill_1
X_07966_ tanh_inst.divider.y\[-11\] tanh_inst.divider.x\[-11\] VGND VGND VPWR VPWR
+ _02763_ sky130_fd_sc_hd__and2_2
X_06917_ tanh_inst.div_en tanh_inst.divider.z_\[-1\] VGND VGND VPWR VPWR _00188_ sky130_fd_sc_hd__and2b_2
XFILLER_0_4_83 VGND VGND VPWR VPWR sky130_fd_sc_hd__fill_1
X_09705_ tanh_inst.divider.y\[-3\] _04429_ VGND VGND VPWR VPWR _04430_ sky130_fd_sc_hd__or2_2
X_07897_ tanh_inst.divider.y\[-12\] _02694_ VGND VGND VPWR VPWR _02695_ sky130_fd_sc_hd__nor2_2
X_09636_ tanh_inst.divider.y\[-5\] _02014_ _04362_ _01470_ VGND VGND VPWR VPWR _00316_
+ sky130_fd_sc_hd__o211a_2
X_06848_ _01726_ _01729_ _01736_ VGND VGND VPWR VPWR _01737_ sky130_fd_sc_hd__o21a_2
XPHY_EDGE_ROW_21_Right_21 VGND VGND VPWR VPWR sky130_fd_sc_hd__decap_3
X_09567_ _02018_ _04294_ _04295_ _02015_ VGND VGND VPWR VPWR _04296_ sky130_fd_sc_hd__a31o_2
X_06779_ _01674_ _01675_ VGND VGND VPWR VPWR _01676_ sky130_fd_sc_hd__or2_2
X_08518_ _03299_ _03301_ VGND VGND VPWR VPWR _03302_ sky130_fd_sc_hd__xnor2_2
X_09498_ tanh_inst.LOOKUP.index\[4\] _03656_ _04213_ VGND VGND VPWR VPWR _04228_ sky130_fd_sc_hd__o21ai_2
XFILLER_0_65_457 VGND VGND VPWR VPWR sky130_fd_sc_hd__fill_1
XTAP_TAPCELL_ROW_13_419 VGND VPWR sky130_fd_sc_hd__tapvpwrvgnd_1
X_08449_ _04791_ _03218_ _03234_ VGND VGND VPWR VPWR _03235_ sky130_fd_sc_hd__o21ai_2
XFILLER_0_92_276 VGND VGND VPWR VPWR sky130_fd_sc_hd__decap_8
XFILLER_0_80_405 VGND VGND VPWR VPWR sky130_fd_sc_hd__fill_1
XFILLER_0_18_351 VGND VGND VPWR VPWR sky130_fd_sc_hd__fill_1
XFILLER_0_52_118 VGND VGND VPWR VPWR sky130_fd_sc_hd__decap_6
X_10411_ clknet_leaf_35_clk _00268_ _00000_ VGND VGND VPWR VPWR mac_inst.i\[3\] sky130_fd_sc_hd__dfrtp_2
XFILLER_0_21_505 VPWR VGND VPWR VGND sky130_ef_sc_hd__decap_12
XPHY_EDGE_ROW_30_Right_30 VGND VGND VPWR VPWR sky130_fd_sc_hd__decap_3
X_10342_ clknet_leaf_15_clk _00199_ VGND VGND VPWR VPWR tanh_inst.divider.z_\[-22\]
+ sky130_fd_sc_hd__dfxtp_2
XFILLER_0_33_398 VGND VGND VPWR VPWR sky130_fd_sc_hd__decap_4
XFILLER_0_103_253 VPWR VGND VPWR VGND sky130_ef_sc_hd__decap_12
X_10273_ clknet_leaf_24_clk _00130_ VGND VGND VPWR VPWR tanh_inst.z_\[-22\] sky130_fd_sc_hd__dfxtp_2
XPHY_EDGE_ROW_100_Left_222 VGND VGND VPWR VPWR sky130_fd_sc_hd__decap_3
XFILLER_0_29_605 VGND VGND VPWR VPWR sky130_fd_sc_hd__decap_8
XFILLER_0_68_251 VGND VGND VPWR VPWR sky130_fd_sc_hd__fill_1
XFILLER_0_28_115 VGND VGND VPWR VPWR sky130_fd_sc_hd__decap_3
XFILLER_0_68_295 VPWR VGND VPWR VGND sky130_ef_sc_hd__decap_12
XTAP_TAPCELL_ROW_64_1063 VGND VPWR sky130_fd_sc_hd__tapvpwrvgnd_1
XFILLER_0_56_457 VPWR VGND VPWR VGND sky130_ef_sc_hd__decap_12
XFILLER_0_83_276 VGND VGND VPWR VPWR sky130_fd_sc_hd__decap_4
XFILLER_0_71_405 VGND VGND VPWR VPWR sky130_fd_sc_hd__fill_1
XFILLER_0_44_619 VGND VGND VPWR VPWR sky130_fd_sc_hd__decap_8
XFILLER_0_9_39 VPWR VGND VPWR VGND sky130_ef_sc_hd__decap_12
XFILLER_0_24_321 VPWR VGND VPWR VGND sky130_ef_sc_hd__decap_12
XTAP_TAPCELL_ROW_40_761 VGND VPWR sky130_fd_sc_hd__tapvpwrvgnd_1
XTAP_TAPCELL_ROW_116_1716 VGND VPWR sky130_fd_sc_hd__tapvpwrvgnd_1
XFILLER_0_36_192 VGND VGND VPWR VPWR sky130_fd_sc_hd__decap_4
XFILLER_0_12_516 VGND VGND VPWR VPWR sky130_fd_sc_hd__decap_4
XFILLER_0_10_53 VPWR VGND VPWR VGND sky130_ef_sc_hd__decap_12
XFILLER_0_3_237 VPWR VGND VPWR VGND sky130_ef_sc_hd__decap_12
XFILLER_0_10_97 VPWR VGND VPWR VGND sky130_ef_sc_hd__decap_12
XFILLER_0_86_24 VGND VGND VPWR VPWR sky130_fd_sc_hd__decap_4
X_07820_ _02617_ _02618_ VGND VGND VPWR VPWR _02620_ sky130_fd_sc_hd__xnor2_2
XFILLER_0_19_51 VGND VGND VPWR VPWR sky130_fd_sc_hd__decap_4
X_07751_ _02534_ _02551_ VGND VGND VPWR VPWR _02553_ sky130_fd_sc_hd__nand2_2
X_06702_ tanh_inst.z_\[-14\] _01606_ VGND VGND VPWR VPWR _01607_ sky130_fd_sc_hd__and2_2
X_07682_ _02024_ _02272_ _02022_ VGND VGND VPWR VPWR _02485_ sky130_fd_sc_hd__a21oi_2
XTAP_TAPCELL_ROW_48_861 VGND VPWR sky130_fd_sc_hd__tapvpwrvgnd_1
X_09421_ tanh_inst.divider.y\[-11\] _04153_ VGND VGND VPWR VPWR _04154_ sky130_fd_sc_hd__nor2_2
X_06633_ _01484_ _01486_ VGND VGND VPWR VPWR _01545_ sky130_fd_sc_hd__nor2_2
X_09352_ _02022_ _03785_ _03916_ VGND VGND VPWR VPWR _04086_ sky130_fd_sc_hd__o21a_2
XFILLER_0_75_700 VGND VGND VPWR VPWR sky130_fd_sc_hd__decap_6
X_06564_ tanh_inst.LOOKUP.index\[4\] tanh_inst.LOOKUP.index\[3\] tanh_inst.LOOKUP.index\[2\]
+ VGND VGND VPWR VPWR _01479_ sky130_fd_sc_hd__nor3_2
XFILLER_0_19_137 VPWR VGND VPWR VGND sky130_ef_sc_hd__decap_12
X_05515_ _00413_ _00416_ _04781_ VGND VGND VPWR VPWR _00511_ sky130_fd_sc_hd__mux2_1
X_08303_ _03029_ _03032_ _03089_ VGND VGND VPWR VPWR _03092_ sky130_fd_sc_hd__o21a_2
X_06495_ _01392_ _01398_ _01406_ VGND VGND VPWR VPWR _01416_ sky130_fd_sc_hd__and3_2
X_09283_ _02023_ _03681_ VGND VGND VPWR VPWR _04019_ sky130_fd_sc_hd__nor2_2
XFILLER_0_7_510 VGND VGND VPWR VPWR sky130_fd_sc_hd__fill_1
X_05446_ _00436_ _00438_ _00434_ VGND VGND VPWR VPWR _00448_ sky130_fd_sc_hd__o21a_2
X_08234_ _02990_ _02996_ _03024_ VGND VGND VPWR VPWR _03025_ sky130_fd_sc_hd__a21o_2
XFILLER_0_51_82 VGND VGND VPWR VPWR sky130_fd_sc_hd__fill_1
X_05377_ _00382_ _00383_ VGND VGND VPWR VPWR _05377_/X sky130_fd_sc_hd__xor2_2
X_08165_ tanh_inst.divider.y\[-6\] _02956_ VGND VGND VPWR VPWR _02957_ sky130_fd_sc_hd__nor2_2
X_07116_ _01031_ _01809_ VGND VGND VPWR VPWR _01941_ sky130_fd_sc_hd__or2_2
XFILLER_0_30_302 VGND VGND VPWR VPWR sky130_fd_sc_hd__fill_1
X_08096_ _02882_ _02884_ _02886_ _02889_ VGND VGND VPWR VPWR _02890_ sky130_fd_sc_hd__a31o_2
XFILLER_0_42_184 VPWR VGND VPWR VGND sky130_ef_sc_hd__decap_12
X_07047_ tanh_inst.divider.z_\[-11\] _01877_ _01879_ VGND VGND VPWR VPWR _01880_ sky130_fd_sc_hd__and3_2
X_08998_ tanh_inst.divider.y\[-21\] _03739_ VGND VGND VPWR VPWR _03741_ sky130_fd_sc_hd__xnor2_2
XFILLER_0_97_302 VGND VGND VPWR VPWR sky130_fd_sc_hd__decap_6
X_07949_ _02741_ _02746_ VGND VGND VPWR VPWR _02747_ sky130_fd_sc_hd__nand2_2
X_09619_ _04344_ _04345_ VGND VGND VPWR VPWR _04346_ sky130_fd_sc_hd__xnor2_2
XTAP_TAPCELL_ROW_100_1517 VGND VPWR sky130_fd_sc_hd__tapvpwrvgnd_1
XTAP_TAPCELL_ROW_100_1506 VGND VPWR sky130_fd_sc_hd__tapvpwrvgnd_1
XTAP_TAPCELL_ROW_26_588 VGND VPWR sky130_fd_sc_hd__tapvpwrvgnd_1
XFILLER_0_81_703 VGND VGND VPWR VPWR sky130_fd_sc_hd__decap_4
XFILLER_0_26_619 VGND VGND VPWR VPWR sky130_fd_sc_hd__fill_1
XFILLER_0_19_693 VGND VGND VPWR VPWR sky130_fd_sc_hd__fill_2
XFILLER_0_21_335 VGND VGND VPWR VPWR sky130_fd_sc_hd__fill_1
X_10325_ clknet_leaf_21_clk _00182_ VGND VGND VPWR VPWR tanh_out[17] sky130_fd_sc_hd__dfxtp_2
XTAP_TAPCELL_ROW_111_1646 VGND VPWR sky130_fd_sc_hd__tapvpwrvgnd_1
X_10256_ clknet_leaf_32_clk mac_inst.x\[18\] _00000_ VGND VGND VPWR VPWR mac_x_out[18]
+ sky130_fd_sc_hd__dfrtp_2
XFILLER_0_56_27 VGND VGND VPWR VPWR sky130_fd_sc_hd__fill_1
X_10187_ x_in[13] _00000_ VGND VGND VPWR VPWR mac_inst.x\[13\] sky130_fd_sc_hd__dlxtn_1
XTAP_TAPCELL_ROW_45_820 VGND VPWR sky130_fd_sc_hd__tapvpwrvgnd_1
XFILLER_0_118_109 VPWR VGND VPWR VGND sky130_ef_sc_hd__decap_12
XFILLER_0_96_390 VGND VGND VPWR VPWR sky130_fd_sc_hd__fill_2
XFILLER_0_56_210 VGND VGND VPWR VPWR sky130_fd_sc_hd__decap_8
XFILLER_0_8_307 VGND VGND VPWR VPWR sky130_fd_sc_hd__fill_1
XFILLER_0_29_446 VGND VGND VPWR VPWR sky130_fd_sc_hd__fill_2
X_06280_ _01194_ _01195_ _01206_ tanh_inst.divider.y_\[7\] VGND VGND VPWR VPWR _01218_
+ sky130_fd_sc_hd__a31o_2
X_05300_ _04922_ _04999_ _04912_ VGND VGND VPWR VPWR _05000_ sky130_fd_sc_hd__a21o_2
XFILLER_0_114_326 VGND VGND VPWR VPWR sky130_fd_sc_hd__decap_4
XFILLER_0_112_65 VPWR VGND VPWR VGND sky130_ef_sc_hd__decap_12
XFILLER_0_4_513 VPWR VGND VPWR VGND sky130_ef_sc_hd__decap_12
X_05231_ mac_inst.i\[0\] mac_inst.i\[1\] VGND VGND VPWR VPWR _04932_ sky130_fd_sc_hd__nor2_2
XFILLER_0_25_630 VGND VGND VPWR VPWR sky130_fd_sc_hd__decap_4
XTAP_TAPCELL_ROW_77_1221 VGND VPWR sky130_fd_sc_hd__tapvpwrvgnd_1
XFILLER_0_52_460 VPWR VGND VPWR VGND sky130_ef_sc_hd__decap_12
X_05162_ mac_inst.x\[22\] _04852_ _04853_ VGND VGND VPWR VPWR _04866_ sky130_fd_sc_hd__a21o_2
XFILLER_0_24_195 VGND VGND VPWR VPWR sky130_fd_sc_hd__fill_1
XFILLER_0_40_633 VGND VGND VPWR VPWR sky130_fd_sc_hd__fill_2
X_09970_ tanh_inst.divider.x\[5\] _04686_ VGND VGND VPWR VPWR _04687_ sky130_fd_sc_hd__nor2_2
XFILLER_0_12_357 VGND VGND VPWR VPWR sky130_fd_sc_hd__decap_6
X_05093_ _04807_ _00000_ _04812_ VGND VGND VPWR VPWR _00339_ sky130_fd_sc_hd__and3b_2
X_08921_ _03584_ _03665_ _01469_ VGND VGND VPWR VPWR _00298_ sky130_fd_sc_hd__a21oi_2
XFILLER_0_110_587 VGND VGND VPWR VPWR sky130_fd_sc_hd__fill_1
X_08852_ _02027_ _03594_ VGND VGND VPWR VPWR _03597_ sky130_fd_sc_hd__nand2_2
X_07803_ _02602_ _02603_ VGND VGND VPWR VPWR _02604_ sky130_fd_sc_hd__xnor2_2
X_08783_ _03508_ _03528_ VGND VGND VPWR VPWR _03529_ sky130_fd_sc_hd__and2_2
X_05995_ _00910_ _00942_ VGND VGND VPWR VPWR _00950_ sky130_fd_sc_hd__nand2b_2
X_07734_ tanh_inst.divider.x\[-16\] _02534_ VGND VGND VPWR VPWR _02536_ sky130_fd_sc_hd__xnor2_2
XFILLER_0_79_324 VPWR VGND VPWR VGND sky130_ef_sc_hd__decap_12
XFILLER_0_27_3 VPWR VGND VPWR VGND sky130_ef_sc_hd__decap_12
XFILLER_0_46_82 VGND VGND VPWR VPWR sky130_fd_sc_hd__fill_2
XTAP_TAPCELL_ROW_88_1361 VGND VPWR sky130_fd_sc_hd__tapvpwrvgnd_1
X_07665_ tanh_inst.LOOKUP.index\[3\] _04759_ _02255_ _04757_ VGND VGND VPWR VPWR _02469_
+ sky130_fd_sc_hd__o31a_2
X_09404_ _04135_ _04136_ VGND VGND VPWR VPWR _04137_ sky130_fd_sc_hd__nor2_2
X_06616_ _04759_ _01484_ _01525_ VGND VGND VPWR VPWR _01529_ sky130_fd_sc_hd__nor3_2
XFILLER_0_1_51 VGND VGND VPWR VPWR sky130_fd_sc_hd__decap_4
XFILLER_0_94_349 VGND VGND VPWR VPWR sky130_fd_sc_hd__fill_2
X_07596_ _02337_ _02352_ _02351_ VGND VGND VPWR VPWR _02401_ sky130_fd_sc_hd__a21boi_2
X_09335_ _04022_ _04024_ VGND VGND VPWR VPWR _04070_ sky130_fd_sc_hd__nor2_2
X_06547_ _04769_ _01462_ VGND VGND VPWR VPWR _01463_ sky130_fd_sc_hd__xnor2_2
XFILLER_0_90_500 VGND VGND VPWR VPWR sky130_fd_sc_hd__decap_3
XFILLER_0_63_714 VGND VGND VPWR VPWR sky130_fd_sc_hd__fill_1
XTAP_TAPCELL_ROW_23_547 VGND VPWR sky130_fd_sc_hd__tapvpwrvgnd_1
X_09266_ _03964_ _03966_ _03962_ VGND VGND VPWR VPWR _04003_ sky130_fd_sc_hd__a21bo_2
X_06478_ tanh_inst.divider.y\[0\] tanh_inst.div_en tanh_inst.divider.y_\[0\] _01092_
+ _01400_ VGND VGND VPWR VPWR _00110_ sky130_fd_sc_hd__a221o_2
XFILLER_0_62_202 VGND VGND VPWR VPWR sky130_fd_sc_hd__decap_8
XFILLER_0_62_246 VGND VGND VPWR VPWR sky130_fd_sc_hd__fill_1
XFILLER_0_7_373 VGND VGND VPWR VPWR sky130_fd_sc_hd__fill_2
XFILLER_0_16_641 VGND VGND VPWR VPWR sky130_fd_sc_hd__decap_3
X_05429_ _00419_ _00420_ mac_inst.z\[31\] VGND VGND VPWR VPWR _00432_ sky130_fd_sc_hd__a21o_2
XFILLER_0_35_449 VGND VGND VPWR VPWR sky130_fd_sc_hd__fill_1
X_08217_ tanh_inst.divider.x\[-5\] _02999_ VGND VGND VPWR VPWR _03008_ sky130_fd_sc_hd__nand2_2
X_09197_ _03887_ _03891_ _03934_ tanh_inst.z_\[7\] VGND VGND VPWR VPWR _03936_ sky130_fd_sc_hd__a31o_2
X_08148_ _02876_ _02879_ _02874_ VGND VGND VPWR VPWR _02941_ sky130_fd_sc_hd__a21o_2
XFILLER_0_31_644 VGND VGND VPWR VPWR sky130_fd_sc_hd__fill_2
XFILLER_0_43_493 VGND VGND VPWR VPWR sky130_fd_sc_hd__decap_8
X_08079_ _02871_ _02872_ VGND VGND VPWR VPWR _02873_ sky130_fd_sc_hd__nor2_2
X_10041_ _01514_ _04748_ VGND VGND VPWR VPWR _04753_ sky130_fd_sc_hd__and2_2
XFILLER_0_98_611 VPWR VGND VPWR VGND sky130_ef_sc_hd__decap_12
XTAP_TAPCELL_ROW_3_294 VGND VPWR sky130_fd_sc_hd__tapvpwrvgnd_1
XFILLER_0_98_699 VGND VGND VPWR VPWR sky130_fd_sc_hd__fill_1
XFILLER_0_97_165 VGND VGND VPWR VPWR sky130_fd_sc_hd__decap_3
XFILLER_0_42_29 VGND VGND VPWR VPWR sky130_fd_sc_hd__fill_2
XFILLER_0_66_574 VGND VGND VPWR VPWR sky130_fd_sc_hd__fill_1
XTAP_TAPCELL_ROW_61_1022 VGND VPWR sky130_fd_sc_hd__tapvpwrvgnd_1
XFILLER_0_109_654 VGND VGND VPWR VPWR sky130_fd_sc_hd__fill_1
XFILLER_0_53_202 VGND VGND VPWR VPWR sky130_fd_sc_hd__decap_8
XFILLER_0_108_175 VGND VGND VPWR VPWR sky130_fd_sc_hd__fill_2
XFILLER_0_34_471 VGND VGND VPWR VPWR sky130_fd_sc_hd__decap_4
XFILLER_0_53_279 VGND VGND VPWR VPWR sky130_fd_sc_hd__fill_1
XFILLER_0_111_318 VGND VGND VPWR VPWR sky130_fd_sc_hd__decap_8
XFILLER_0_6_29 VPWR VGND VPWR VGND sky130_ef_sc_hd__decap_12
X_10308_ clknet_leaf_21_clk _00165_ VGND VGND VPWR VPWR tanh_out[0] sky130_fd_sc_hd__dfxtp_2
XTAP_TAPCELL_ROW_72_1162 VGND VPWR sky130_fd_sc_hd__tapvpwrvgnd_1
X_10239_ clknet_leaf_32_clk mac_inst.x\[1\] _00000_ VGND VGND VPWR VPWR mac_x_out[1]
+ sky130_fd_sc_hd__dfrtp_2
XFILLER_0_89_600 VGND VGND VPWR VPWR sky130_fd_sc_hd__decap_8
XFILLER_0_83_47 VGND VGND VPWR VPWR sky130_fd_sc_hd__fill_2
X_05780_ mac_inst.z\[31\] _00750_ _00748_ VGND VGND VPWR VPWR _00751_ sky130_fd_sc_hd__o21ai_2
XFILLER_0_16_41 VPWR VGND VPWR VGND sky130_ef_sc_hd__decap_12
XFILLER_0_16_85 VPWR VGND VPWR VGND sky130_ef_sc_hd__decap_12
XFILLER_0_119_407 VGND VGND VPWR VPWR sky130_fd_sc_hd__decap_4
X_07450_ _01525_ _02257_ _02254_ _02253_ VGND VGND VPWR VPWR _02258_ sky130_fd_sc_hd__o211a_2
XFILLER_0_119_429 VGND VGND VPWR VPWR sky130_fd_sc_hd__fill_1
X_06401_ _01329_ VGND VGND VPWR VPWR _01330_ sky130_fd_sc_hd__inv_2
X_07381_ tanh_inst.divider.y\[-11\] tanh_inst.divider.y\[-10\] tanh_inst.divider.y\[-9\]
+ tanh_inst.divider.y\[-8\] tanh_inst.LOOKUP.index\[0\] tanh_inst.LOOKUP.index\[1\]
+ VGND VGND VPWR VPWR _02190_ sky130_fd_sc_hd__mux4_2
X_06332_ _01039_ _01157_ _01264_ _04776_ _01265_ VGND VGND VPWR VPWR _01266_ sky130_fd_sc_hd__o221a_2
X_09120_ _03857_ _03860_ VGND VGND VPWR VPWR _03861_ sky130_fd_sc_hd__xnor2_2
XTAP_TAPCELL_ROW_20_506 VGND VPWR sky130_fd_sc_hd__tapvpwrvgnd_1
X_09051_ _03791_ _03792_ VGND VGND VPWR VPWR _03793_ sky130_fd_sc_hd__nor2_2
XFILLER_0_72_533 VPWR VGND VPWR VGND sky130_ef_sc_hd__decap_12
XTAP_TAPCELL_ROW_20_517 VGND VPWR sky130_fd_sc_hd__tapvpwrvgnd_1
X_06263_ _01200_ _01201_ _01202_ VGND VGND VPWR VPWR _01203_ sky130_fd_sc_hd__o21a_2
X_08002_ _02707_ _02796_ _02797_ VGND VGND VPWR VPWR _02798_ sky130_fd_sc_hd__o21ai_2
XPHY_EDGE_ROW_6_Right_6 VGND VGND VPWR VPWR sky130_fd_sc_hd__decap_3
XFILLER_0_4_321 VPWR VGND VPWR VGND sky130_ef_sc_hd__decap_12
XFILLER_0_115_679 VGND VGND VPWR VPWR sky130_fd_sc_hd__fill_2
X_06194_ _01088_ _01136_ _01137_ VGND VGND VPWR VPWR _00089_ sky130_fd_sc_hd__a21o_2
XFILLER_0_102_307 VGND VGND VPWR VPWR sky130_fd_sc_hd__fill_1
XFILLER_0_12_121 VPWR VGND VPWR VGND sky130_ef_sc_hd__decap_12
XFILLER_0_4_365 VPWR VGND VPWR VGND sky130_ef_sc_hd__decap_12
X_05214_ mac_inst.x\[6\] _04852_ _04853_ VGND VGND VPWR VPWR _04918_ sky130_fd_sc_hd__a21o_2
XFILLER_0_102_329 VGND VGND VPWR VPWR sky130_fd_sc_hd__fill_1
XFILLER_0_4_398 VGND VGND VPWR VPWR sky130_fd_sc_hd__decap_6
X_05145_ mac_inst.i\[25\] mac_inst.i\[24\] mac_inst.i\[31\] mac_inst.i\[30\] VGND
+ VGND VPWR VPWR _04849_ sky130_fd_sc_hd__or4_2
XFILLER_0_40_463 VPWR VGND VPWR VGND sky130_ef_sc_hd__decap_12
XFILLER_0_12_165 VPWR VGND VPWR VGND sky130_ef_sc_hd__decap_12
XFILLER_0_40_485 VGND VGND VPWR VPWR sky130_fd_sc_hd__fill_2
XFILLER_0_40_496 VGND VGND VPWR VPWR sky130_fd_sc_hd__decap_8
X_09953_ _03384_ _04649_ VGND VGND VPWR VPWR _04671_ sky130_fd_sc_hd__and2_2
X_05076_ mac_inst.z\[10\] VGND VGND VPWR VPWR _04800_ sky130_fd_sc_hd__inv_2
X_09884_ _04523_ _04558_ _04559_ VGND VGND VPWR VPWR _04604_ sky130_fd_sc_hd__o21a_2
X_08904_ _03647_ _03648_ tanh_inst.LOOKUP.index\[2\] VGND VGND VPWR VPWR _03649_ sky130_fd_sc_hd__mux2_1
X_08835_ _02019_ _03580_ VGND VGND VPWR VPWR _03581_ sky130_fd_sc_hd__or2_2
XFILLER_0_57_92 VGND VGND VPWR VPWR sky130_fd_sc_hd__decap_6
X_08766_ tanh_inst.divider.x\[-9\] _02028_ _03508_ VGND VGND VPWR VPWR _03512_ sky130_fd_sc_hd__o21a_2
XTAP_TAPCELL_ROW_28_606 VGND VPWR sky130_fd_sc_hd__tapvpwrvgnd_1
XFILLER_0_79_110 VGND VGND VPWR VPWR sky130_fd_sc_hd__fill_2
X_07717_ tanh_inst.divider.x\[-17\] _02518_ VGND VGND VPWR VPWR _02520_ sky130_fd_sc_hd__or2_2
X_05978_ mac_inst.z\[23\] _00933_ VGND VGND VPWR VPWR _00934_ sky130_fd_sc_hd__xor2_2
XTAP_TAPCELL_ROW_28_617 VGND VPWR sky130_fd_sc_hd__tapvpwrvgnd_1
X_08697_ _04769_ _03475_ VGND VGND VPWR VPWR _03476_ sky130_fd_sc_hd__xnor2_2
XTAP_TAPCELL_ROW_56_959 VGND VPWR sky130_fd_sc_hd__tapvpwrvgnd_1
XTAP_TAPCELL_ROW_0_253 VGND VPWR sky130_fd_sc_hd__tapvpwrvgnd_1
XFILLER_0_94_135 VGND VGND VPWR VPWR sky130_fd_sc_hd__decap_4
X_07648_ _02449_ _02451_ tanh_inst.z_\[7\] VGND VGND VPWR VPWR _02452_ sky130_fd_sc_hd__o21ai_2
XTAP_TAPCELL_ROW_0_264 VGND VPWR sky130_fd_sc_hd__tapvpwrvgnd_1
XFILLER_0_48_530 VGND VGND VPWR VPWR sky130_fd_sc_hd__fill_2
X_07579_ _02015_ _02383_ _02384_ _01470_ VGND VGND VPWR VPWR _00237_ sky130_fd_sc_hd__o211a_2
X_09318_ _04052_ _04053_ VGND VGND VPWR VPWR _04054_ sky130_fd_sc_hd__nand2_2
XFILLER_0_48_574 VPWR VGND VPWR VGND sky130_ef_sc_hd__decap_12
XFILLER_0_75_393 VGND VGND VPWR VPWR sky130_fd_sc_hd__decap_8
XFILLER_0_35_246 VGND VGND VPWR VPWR sky130_fd_sc_hd__fill_1
XFILLER_0_90_363 VGND VGND VPWR VPWR sky130_fd_sc_hd__fill_1
XFILLER_0_90_352 VGND VGND VPWR VPWR sky130_fd_sc_hd__decap_4
X_09249_ _03985_ _03986_ _02019_ VGND VGND VPWR VPWR _03987_ sky130_fd_sc_hd__a21o_2
XFILLER_0_7_181 VPWR VGND VPWR VGND sky130_ef_sc_hd__decap_12
XFILLER_0_105_167 VGND VGND VPWR VPWR sky130_fd_sc_hd__fill_1
XFILLER_0_16_493 VGND VGND VPWR VPWR sky130_fd_sc_hd__fill_2
XFILLER_0_101_373 VGND VGND VPWR VPWR sky130_fd_sc_hd__decap_3
XTAP_TAPCELL_ROW_8_364 VGND VPWR sky130_fd_sc_hd__tapvpwrvgnd_1
X_10024_ _04724_ _04729_ _04738_ VGND VGND VPWR VPWR _04739_ sky130_fd_sc_hd__a21oi_2
XFILLER_0_53_17 VPWR VGND VPWR VGND sky130_ef_sc_hd__decap_12
XFILLER_0_98_474 VGND VGND VPWR VPWR sky130_fd_sc_hd__fill_2
XFILLER_0_58_316 VPWR VGND VPWR VGND sky130_ef_sc_hd__decap_12
XFILLER_0_85_113 VGND VGND VPWR VPWR sky130_fd_sc_hd__fill_1
XFILLER_0_85_102 VGND VGND VPWR VPWR sky130_fd_sc_hd__decap_8
XTAP_TAPCELL_ROW_106_1589 VGND VPWR sky130_fd_sc_hd__tapvpwrvgnd_1
XFILLER_0_73_308 VGND VGND VPWR VPWR sky130_fd_sc_hd__fill_1
XFILLER_0_54_511 VGND VGND VPWR VPWR sky130_fd_sc_hd__decap_4
XFILLER_0_39_596 VGND VGND VPWR VPWR sky130_fd_sc_hd__decap_6
XPHY_EDGE_ROW_59_Right_59 VGND VGND VPWR VPWR sky130_fd_sc_hd__decap_3
XFILLER_0_54_533 VPWR VGND VPWR VGND sky130_ef_sc_hd__decap_12
XFILLER_0_54_577 VGND VGND VPWR VPWR sky130_fd_sc_hd__decap_4
XFILLER_0_41_216 VGND VGND VPWR VPWR sky130_fd_sc_hd__decap_8
XFILLER_0_78_25 VGND VGND VPWR VPWR sky130_fd_sc_hd__decap_3
XFILLER_0_111_137 VGND VGND VPWR VPWR sky130_fd_sc_hd__fill_1
XFILLER_0_1_335 VGND VGND VPWR VPWR sky130_fd_sc_hd__fill_1
XFILLER_0_22_463 VGND VGND VPWR VPWR sky130_fd_sc_hd__decap_8
X_06950_ tanh_inst.divider.y_\[7\] _01035_ _01792_ VGND VGND VPWR VPWR _01793_ sky130_fd_sc_hd__a21o_2
X_06881_ tanh_inst.divider.i\[0\] _01060_ _01763_ VGND VGND VPWR VPWR _00160_ sky130_fd_sc_hd__o21a_2
XPHY_EDGE_ROW_68_Right_68 VGND VGND VPWR VPWR sky130_fd_sc_hd__decap_3
X_05901_ _00808_ _00810_ _00862_ _00863_ VGND VGND VPWR VPWR _00864_ sky130_fd_sc_hd__a31o_2
XFILLER_0_118_53 VPWR VGND VPWR VGND sky130_ef_sc_hd__decap_12
X_08620_ _03373_ _03390_ _03401_ _02018_ VGND VGND VPWR VPWR _03402_ sky130_fd_sc_hd__a22o_2
X_05832_ _00771_ _00776_ _00783_ VGND VGND VPWR VPWR _00799_ sky130_fd_sc_hd__and3_2
XFILLER_0_27_51 VGND VGND VPWR VPWR sky130_fd_sc_hd__decap_4
XFILLER_0_118_97 VPWR VGND VPWR VGND sky130_ef_sc_hd__decap_12
XTAP_TAPCELL_ROW_85_1320 VGND VPWR sky130_fd_sc_hd__tapvpwrvgnd_1
X_05763_ mac_inst.z\[6\] _00734_ VGND VGND VPWR VPWR _00736_ sky130_fd_sc_hd__nand2_2
X_08551_ _03309_ _03312_ _03332_ VGND VGND VPWR VPWR _03334_ sky130_fd_sc_hd__nor3_2
XFILLER_0_89_496 VGND VGND VPWR VPWR sky130_fd_sc_hd__fill_2
X_07502_ tanh_inst.z_\[7\] _02307_ _02308_ _02019_ _02298_ VGND VGND VPWR VPWR _02309_
+ sky130_fd_sc_hd__o311a_2
XTAP_TAPCELL_ROW_53_929 VGND VPWR sky130_fd_sc_hd__tapvpwrvgnd_1
X_05694_ mac_inst.z\[1\] _00668_ VGND VGND VPWR VPWR _00672_ sky130_fd_sc_hd__xnor2_2
XFILLER_0_43_50 VGND VGND VPWR VPWR sky130_fd_sc_hd__decap_6
X_08482_ _03200_ _03203_ _03266_ VGND VGND VPWR VPWR _03267_ sky130_fd_sc_hd__nor3_2
X_07433_ _02170_ _02174_ _02240_ VGND VGND VPWR VPWR _02241_ sky130_fd_sc_hd__a21oi_2
XFILLER_0_77_669 VGND VGND VPWR VPWR sky130_fd_sc_hd__decap_3
XFILLER_0_76_168 VGND VGND VPWR VPWR sky130_fd_sc_hd__decap_8
XFILLER_0_9_402 VGND VGND VPWR VPWR sky130_fd_sc_hd__decap_4
XFILLER_0_119_237 VPWR VGND VPWR VGND sky130_ef_sc_hd__decap_12
XPHY_EDGE_ROW_77_Right_77 VGND VGND VPWR VPWR sky130_fd_sc_hd__decap_3
X_09103_ _03789_ _03791_ _03842_ VGND VGND VPWR VPWR _03844_ sky130_fd_sc_hd__or3_2
X_07364_ _02167_ _02172_ VGND VGND VPWR VPWR _02173_ sky130_fd_sc_hd__nand2_2
XTAP_TAPCELL_ROW_33_675 VGND VPWR sky130_fd_sc_hd__tapvpwrvgnd_1
XFILLER_0_45_544 VGND VGND VPWR VPWR sky130_fd_sc_hd__fill_1
X_06315_ _01229_ _01240_ _01230_ VGND VGND VPWR VPWR _01250_ sky130_fd_sc_hd__or3b_2
XFILLER_0_94_3 VPWR VGND VPWR VGND sky130_ef_sc_hd__decap_12
XFILLER_0_72_363 VGND VGND VPWR VPWR sky130_fd_sc_hd__fill_1
X_07295_ tanh_inst.divider.y\[-12\] tanh_inst.divider.y\[-11\] tanh_inst.divider.y\[-10\]
+ tanh_inst.divider.y\[-9\] tanh_inst.LOOKUP.index\[0\] tanh_inst.LOOKUP.index\[1\]
+ VGND VGND VPWR VPWR _02105_ sky130_fd_sc_hd__mux4_2
XFILLER_0_17_279 VGND VGND VPWR VPWR sky130_fd_sc_hd__fill_1
X_06246_ tanh_inst.divider.y\[-18\] tanh_inst.div_en tanh_inst.divider.y_\[-18\] _01092_
+ _01186_ VGND VGND VPWR VPWR _00092_ sky130_fd_sc_hd__a221o_2
X_09034_ _03717_ _03719_ _03716_ VGND VGND VPWR VPWR _03777_ sky130_fd_sc_hd__a21o_2
XFILLER_0_103_627 VGND VGND VPWR VPWR sky130_fd_sc_hd__fill_2
XTAP_TAPCELL_ROW_96_1460 VGND VPWR sky130_fd_sc_hd__tapvpwrvgnd_1
X_06177_ _01115_ _01116_ _01119_ tanh_inst.divider.x\[7\] tanh_inst.divider.i\[2\]
+ tanh_inst.divider.i\[3\] VGND VGND VPWR VPWR _01121_ sky130_fd_sc_hd__mux4_2
XFILLER_0_4_195 VGND VGND VPWR VPWR sky130_fd_sc_hd__fill_1
X_05128_ mac_counter\[1\] _04832_ _00000_ VGND VGND VPWR VPWR _04834_ sky130_fd_sc_hd__o21ai_2
XPHY_EDGE_ROW_86_Right_86 VGND VGND VPWR VPWR sky130_fd_sc_hd__decap_3
XFILLER_0_68_91 VPWR VGND VPWR VGND sky130_ef_sc_hd__decap_12
X_09936_ tanh_inst.divider.x\[4\] _04652_ VGND VGND VPWR VPWR _04654_ sky130_fd_sc_hd__and2_2
X_05059_ mac_inst.i\[0\] VGND VGND VPWR VPWR _04783_ sky130_fd_sc_hd__inv_2
XTAP_TAPCELL_ROW_5_323 VGND VPWR sky130_fd_sc_hd__tapvpwrvgnd_1
XFILLER_0_99_205 VPWR VGND VPWR VGND sky130_ef_sc_hd__decap_12
X_09867_ _03302_ _04585_ VGND VGND VPWR VPWR _04587_ sky130_fd_sc_hd__xor2_2
XFILLER_0_99_238 VGND VGND VPWR VPWR sky130_fd_sc_hd__fill_1
X_08818_ tanh_inst.divider.x\[-5\] _02028_ _03508_ VGND VGND VPWR VPWR _03564_ sky130_fd_sc_hd__o21a_2
X_09798_ tanh_inst.divider.x\[0\] _04519_ VGND VGND VPWR VPWR _04520_ sky130_fd_sc_hd__nor2_2
X_08749_ mac_inst.i\[23\] _00966_ mac_inst.i\[24\] VGND VGND VPWR VPWR _03503_ sky130_fd_sc_hd__a21oi_2
XFILLER_0_95_411 VPWR VGND VPWR VGND sky130_ef_sc_hd__decap_12
XFILLER_0_67_113 VPWR VGND VPWR VGND sky130_ef_sc_hd__decap_12
XPHY_EDGE_ROW_95_Right_95 VGND VGND VPWR VPWR sky130_fd_sc_hd__decap_3
XFILLER_0_76_691 VGND VGND VPWR VPWR sky130_fd_sc_hd__decap_8
XFILLER_0_118_292 VGND VGND VPWR VPWR sky130_fd_sc_hd__decap_6
XFILLER_0_106_421 VGND VGND VPWR VPWR sky130_fd_sc_hd__decap_4
XFILLER_0_63_341 VGND VGND VPWR VPWR sky130_fd_sc_hd__fill_1
XFILLER_0_121_413 VGND VGND VPWR VPWR sky130_fd_sc_hd__fill_2
XFILLER_0_23_249 VPWR VGND VPWR VGND sky130_ef_sc_hd__decap_12
XFILLER_0_31_293 VGND VGND VPWR VPWR sky130_fd_sc_hd__decap_6
X_10007_ tanh_inst.divider.y\[5\] _04678_ _04687_ VGND VGND VPWR VPWR _04723_ sky130_fd_sc_hd__a21oi_2
XTAP_TAPCELL_ROW_108_1618 VGND VPWR sky130_fd_sc_hd__tapvpwrvgnd_1
XTAP_TAPCELL_ROW_108_1607 VGND VPWR sky130_fd_sc_hd__tapvpwrvgnd_1
XFILLER_0_59_614 VGND VGND VPWR VPWR sky130_fd_sc_hd__fill_2
XFILLER_0_86_433 VGND VGND VPWR VPWR sky130_fd_sc_hd__decap_8
XFILLER_0_59_647 VGND VGND VPWR VPWR sky130_fd_sc_hd__decap_3
XTAP_TAPCELL_ROW_67_1094 VGND VPWR sky130_fd_sc_hd__tapvpwrvgnd_1
XFILLER_0_86_477 VPWR VGND VPWR VGND sky130_ef_sc_hd__decap_12
XFILLER_0_116_207 VGND VGND VPWR VPWR sky130_fd_sc_hd__fill_2
XTAP_TAPCELL_ROW_80_1261 VGND VPWR sky130_fd_sc_hd__tapvpwrvgnd_1
XFILLER_0_109_281 VPWR VGND VPWR VGND sky130_ef_sc_hd__decap_12
XFILLER_0_6_449 VPWR VGND VPWR VGND sky130_ef_sc_hd__decap_12
XTAP_TAPCELL_ROW_30_634 VGND VPWR sky130_fd_sc_hd__tapvpwrvgnd_1
XTAP_TAPCELL_ROW_119_1747 VGND VPWR sky130_fd_sc_hd__tapvpwrvgnd_1
X_06100_ tanh_inst.divider.y_\[5\] tanh_inst.divider.y_\[4\] tanh_inst.divider.y_\[7\]
+ tanh_inst.divider.y_\[6\] VGND VGND VPWR VPWR _01047_ sky130_fd_sc_hd__or4_2
X_07080_ _01894_ _01902_ _01908_ tanh_inst.divider.y_\[7\] VGND VGND VPWR VPWR _01909_
+ sky130_fd_sc_hd__a31o_2
XFILLER_0_82_683 VGND VGND VPWR VPWR sky130_fd_sc_hd__fill_1
XFILLER_0_80_9 VGND VGND VPWR VPWR sky130_fd_sc_hd__fill_1
XFILLER_0_120_65 VPWR VGND VPWR VGND sky130_ef_sc_hd__decap_12
XFILLER_0_81_193 VGND VGND VPWR VPWR sky130_fd_sc_hd__decap_8
X_06031_ _00940_ _00975_ VGND VGND VPWR VPWR _00984_ sky130_fd_sc_hd__nand2_2
XTAP_TAPCELL_ROW_10_391 VGND VPWR sky130_fd_sc_hd__tapvpwrvgnd_1
XFILLER_0_100_619 VGND VGND VPWR VPWR sky130_fd_sc_hd__decap_3
X_07982_ _02778_ VGND VGND VPWR VPWR _02779_ sky130_fd_sc_hd__inv_2
X_06933_ _04777_ _01765_ _01776_ _01057_ _01058_ VGND VGND VPWR VPWR _01778_ sky130_fd_sc_hd__o32a_2
X_09721_ _04441_ _04443_ VGND VGND VPWR VPWR _04445_ sky130_fd_sc_hd__and2_2
XFILLER_0_38_50 VGND VGND VPWR VPWR sky130_fd_sc_hd__decap_4
XFILLER_0_38_83 VGND VGND VPWR VPWR sky130_fd_sc_hd__fill_1
X_09652_ _02053_ _03787_ _04193_ VGND VGND VPWR VPWR _04378_ sky130_fd_sc_hd__o21a_2
X_06864_ _01745_ _01749_ VGND VGND VPWR VPWR _01751_ sky130_fd_sc_hd__or2_2
XFILLER_0_96_208 VGND VGND VPWR VPWR sky130_fd_sc_hd__decap_8
X_08603_ _03357_ _03384_ VGND VGND VPWR VPWR _03385_ sky130_fd_sc_hd__nor2_2
X_06795_ tanh_inst.z_\[-5\] _01683_ _01674_ VGND VGND VPWR VPWR _01690_ sky130_fd_sc_hd__o21a_2
X_09583_ _02929_ _04269_ _04244_ VGND VGND VPWR VPWR _04311_ sky130_fd_sc_hd__o21a_2
X_05815_ _04944_ _00691_ _00760_ VGND VGND VPWR VPWR _00783_ sky130_fd_sc_hd__or3_2
XTAP_TAPCELL_ROW_38_734 VGND VPWR sky130_fd_sc_hd__tapvpwrvgnd_1
XFILLER_0_89_271 VGND VGND VPWR VPWR sky130_fd_sc_hd__fill_1
X_05746_ mac_inst.z\[31\] _00708_ _00718_ VGND VGND VPWR VPWR _00720_ sky130_fd_sc_hd__o21ai_2
X_08534_ _03213_ _03216_ _03269_ _03209_ VGND VGND VPWR VPWR _03318_ sky130_fd_sc_hd__o211a_2
XFILLER_0_49_113 VGND VGND VPWR VPWR sky130_fd_sc_hd__decap_4
X_08465_ _02052_ _02578_ _02833_ VGND VGND VPWR VPWR _03250_ sky130_fd_sc_hd__a21oi_2
XTAP_TAPCELL_ROW_18_491 VGND VPWR sky130_fd_sc_hd__tapvpwrvgnd_1
X_05677_ _00655_ _00657_ VGND VGND VPWR VPWR _05677_/Y sky130_fd_sc_hd__xnor2_2
X_07416_ _04773_ _02223_ VGND VGND VPWR VPWR _02224_ sky130_fd_sc_hd__nor2_2
X_08396_ _03146_ _03148_ _03181_ VGND VGND VPWR VPWR _03183_ sky130_fd_sc_hd__nor3_2
X_07347_ _02139_ _02155_ _04774_ VGND VGND VPWR VPWR _02156_ sky130_fd_sc_hd__a21oi_2
XFILLER_0_18_577 VGND VGND VPWR VPWR sky130_fd_sc_hd__decap_8
XFILLER_0_33_503 VGND VGND VPWR VPWR sky130_fd_sc_hd__fill_1
XFILLER_0_33_525 VGND VGND VPWR VPWR sky130_fd_sc_hd__decap_3
XFILLER_0_115_262 VGND VGND VPWR VPWR sky130_fd_sc_hd__fill_1
X_07278_ tanh_inst.divider.y\[-5\] _02028_ _02029_ VGND VGND VPWR VPWR _02088_ sky130_fd_sc_hd__o21a_2
X_09017_ tanh_inst.divider.x\[7\] tanh_inst.LOOKUP.index\[2\] VGND VGND VPWR VPWR
+ _03760_ sky130_fd_sc_hd__nand2b_2
X_06229_ _01169_ _01170_ _01088_ VGND VGND VPWR VPWR _01171_ sky130_fd_sc_hd__o21ai_2
XFILLER_0_60_377 VGND VGND VPWR VPWR sky130_fd_sc_hd__decap_8
XFILLER_0_13_293 VPWR VGND VPWR VGND sky130_ef_sc_hd__decap_12
X_09919_ _02018_ _04637_ _02015_ VGND VGND VPWR VPWR _04638_ sky130_fd_sc_hd__a21o_2
XFILLER_0_68_433 VGND VGND VPWR VPWR sky130_fd_sc_hd__decap_8
XTAP_TAPCELL_ROW_103_1548 VGND VPWR sky130_fd_sc_hd__tapvpwrvgnd_1
XFILLER_0_95_285 VGND VGND VPWR VPWR sky130_fd_sc_hd__fill_1
XFILLER_0_83_436 VGND VGND VPWR VPWR sky130_fd_sc_hd__decap_6
XFILLER_0_50_29 VGND VGND VPWR VPWR sky130_fd_sc_hd__decap_6
XFILLER_0_64_650 VGND VGND VPWR VPWR sky130_fd_sc_hd__decap_8
XFILLER_0_36_363 VGND VGND VPWR VPWR sky130_fd_sc_hd__fill_1
XFILLER_0_51_333 VGND VGND VPWR VPWR sky130_fd_sc_hd__decap_3
XFILLER_0_121_221 VGND VGND VPWR VPWR sky130_fd_sc_hd__decap_3
XFILLER_0_59_27 VGND VGND VPWR VPWR sky130_fd_sc_hd__decap_3
XFILLER_0_121_265 VPWR VGND VPWR VGND sky130_ef_sc_hd__decap_12
XTAP_TAPCELL_ROW_114_1688 VGND VPWR sky130_fd_sc_hd__tapvpwrvgnd_1
XTAP_TAPCELL_ROW_69_1123 VGND VPWR sky130_fd_sc_hd__tapvpwrvgnd_1
XFILLER_0_91_47 VGND VGND VPWR VPWR sky130_fd_sc_hd__fill_2
X_05600_ _00509_ _00586_ VGND VGND VPWR VPWR _00588_ sky130_fd_sc_hd__or2_2
XTAP_TAPCELL_ROW_35_704 VGND VPWR sky130_fd_sc_hd__tapvpwrvgnd_1
X_06580_ tanh_inst.z_\[-19\] tanh_inst.z_\[-20\] tanh_inst.z_\[-17\] tanh_inst.z_\[-18\]
+ VGND VGND VPWR VPWR _01495_ sky130_fd_sc_hd__or4_2
XFILLER_0_24_41 VPWR VGND VPWR VGND sky130_ef_sc_hd__decap_12
XFILLER_0_24_85 VPWR VGND VPWR VGND sky130_ef_sc_hd__decap_12
X_05531_ _00522_ _00525_ VGND VGND VPWR VPWR _00526_ sky130_fd_sc_hd__xor2_2
XFILLER_0_47_617 VGND VGND VPWR VPWR sky130_fd_sc_hd__decap_8
XFILLER_0_86_296 VPWR VGND VPWR VGND sky130_ef_sc_hd__decap_12
XTAP_TAPCELL_ROW_15_450 VGND VPWR sky130_fd_sc_hd__tapvpwrvgnd_1
X_05462_ mac_inst.i\[3\] _00357_ VGND VGND VPWR VPWR _00462_ sky130_fd_sc_hd__nor2_2
X_08250_ _02960_ _03012_ _03013_ VGND VGND VPWR VPWR _03040_ sky130_fd_sc_hd__o21ba_2
X_07201_ _04759_ _01472_ _01525_ VGND VGND VPWR VPWR _02012_ sky130_fd_sc_hd__or3_2
X_08181_ _02925_ _04771_ tanh_inst.divider.y\[-8\] VGND VGND VPWR VPWR _02973_ sky130_fd_sc_hd__or3b_2
X_07132_ _01952_ _01954_ _01955_ VGND VGND VPWR VPWR _01956_ sky130_fd_sc_hd__and3_2
X_05393_ _00397_ _00398_ VGND VGND VPWR VPWR _05393_/Y sky130_fd_sc_hd__xnor2_2
XFILLER_0_42_322 VGND VGND VPWR VPWR sky130_fd_sc_hd__decap_3
XFILLER_0_113_722 VGND VGND VPWR VPWR sky130_fd_sc_hd__fill_2
XFILLER_0_15_569 VGND VGND VPWR VPWR sky130_fd_sc_hd__fill_1
XFILLER_0_112_232 VGND VGND VPWR VPWR sky130_fd_sc_hd__decap_4
X_07063_ _01878_ _01885_ _01893_ VGND VGND VPWR VPWR _01894_ sky130_fd_sc_hd__and3_2
XFILLER_0_42_377 VPWR VGND VPWR VGND sky130_ef_sc_hd__decap_12
XFILLER_0_112_276 VGND VGND VPWR VPWR sky130_fd_sc_hd__fill_1
XFILLER_0_100_416 VGND VGND VPWR VPWR sky130_fd_sc_hd__decap_4
XTAP_TAPCELL_ROW_93_1430 VGND VPWR sky130_fd_sc_hd__tapvpwrvgnd_1
X_06014_ mac_inst.i\[25\] _00967_ VGND VGND VPWR VPWR _00968_ sky130_fd_sc_hd__and2_2
XFILLER_0_100_438 VPWR VGND VPWR VGND sky130_ef_sc_hd__decap_12
XFILLER_0_57_3 VPWR VGND VPWR VGND sky130_ef_sc_hd__decap_12
X_07965_ tanh_inst.divider.y\[-11\] tanh_inst.divider.x\[-11\] VGND VGND VPWR VPWR
+ _02762_ sky130_fd_sc_hd__nor2_2
X_06916_ tanh_inst.div_en tanh_inst.divider.z_\[-2\] VGND VGND VPWR VPWR _00187_ sky130_fd_sc_hd__and2b_2
X_09704_ _04428_ VGND VGND VPWR VPWR _04429_ sky130_fd_sc_hd__inv_2
X_07896_ _02692_ _02693_ VGND VGND VPWR VPWR _02694_ sky130_fd_sc_hd__or2_2
X_09635_ _02019_ _04352_ _04360_ _04361_ _02015_ VGND VGND VPWR VPWR _04362_ sky130_fd_sc_hd__a221o_2
X_06847_ tanh_inst.z_\[1\] _01728_ _01735_ VGND VGND VPWR VPWR _01736_ sky130_fd_sc_hd__o21ai_2
X_06778_ tanh_inst.z_\[-6\] _01673_ VGND VGND VPWR VPWR _01675_ sky130_fd_sc_hd__nor2_2
X_09566_ _04233_ _04236_ _04293_ VGND VGND VPWR VPWR _04295_ sky130_fd_sc_hd__o21bai_2
X_09497_ _03976_ _04123_ _04225_ _04226_ VGND VGND VPWR VPWR _04227_ sky130_fd_sc_hd__o31a_2
X_05729_ mac_inst.i\[3\] _04977_ _00703_ VGND VGND VPWR VPWR _00704_ sky130_fd_sc_hd__or3_2
X_08517_ _03226_ _03227_ _03251_ _03252_ _03300_ VGND VGND VPWR VPWR _03301_ sky130_fd_sc_hd__a311o_2
XFILLER_0_37_138 VGND VGND VPWR VPWR sky130_fd_sc_hd__fill_2
X_08448_ _03232_ _03233_ _02019_ VGND VGND VPWR VPWR _03234_ sky130_fd_sc_hd__o21a_2
XFILLER_0_92_244 VGND VGND VPWR VPWR sky130_fd_sc_hd__decap_8
X_10410_ clknet_leaf_35_clk _00267_ _00000_ VGND VGND VPWR VPWR mac_inst.i\[2\] sky130_fd_sc_hd__dfrtp_2
X_08379_ tanh_inst.divider.y\[-1\] tanh_inst.divider.x\[-1\] VGND VGND VPWR VPWR _03166_
+ sky130_fd_sc_hd__or2_2
XFILLER_0_46_683 VGND VGND VPWR VPWR sky130_fd_sc_hd__decap_4
XFILLER_0_60_141 VPWR VGND VPWR VGND sky130_ef_sc_hd__decap_12
X_10341_ clknet_leaf_19_clk _00198_ VGND VGND VPWR VPWR tanh_inst.divider.z_\[-23\]
+ sky130_fd_sc_hd__dfxtp_2
XFILLER_0_21_517 VGND VGND VPWR VPWR sky130_fd_sc_hd__decap_4
XFILLER_0_103_276 VGND VGND VPWR VPWR sky130_fd_sc_hd__decap_4
XFILLER_0_103_265 VGND VGND VPWR VPWR sky130_fd_sc_hd__decap_4
X_10272_ clknet_leaf_24_clk _00129_ VGND VGND VPWR VPWR tanh_inst.z_\[-23\] sky130_fd_sc_hd__dfxtp_2
XFILLER_0_88_506 VGND VGND VPWR VPWR sky130_fd_sc_hd__fill_2
XFILLER_0_84_723 VGND VGND VPWR VPWR sky130_fd_sc_hd__fill_1
XFILLER_0_84_701 VGND VGND VPWR VPWR sky130_fd_sc_hd__fill_1
XTAP_TAPCELL_ROW_64_1064 VGND VPWR sky130_fd_sc_hd__tapvpwrvgnd_1
XFILLER_0_71_417 VGND VGND VPWR VPWR sky130_fd_sc_hd__fill_1
XFILLER_0_56_469 VGND VGND VPWR VPWR sky130_fd_sc_hd__decap_6
XTAP_TAPCELL_ROW_40_762 VGND VPWR sky130_fd_sc_hd__tapvpwrvgnd_1
XTAP_TAPCELL_ROW_116_1706 VGND VPWR sky130_fd_sc_hd__tapvpwrvgnd_1
XFILLER_0_114_519 VGND VGND VPWR VPWR sky130_fd_sc_hd__decap_4
XFILLER_0_3_205 VPWR VGND VPWR VGND sky130_ef_sc_hd__decap_12
XFILLER_0_24_333 VPWR VGND VPWR VGND sky130_ef_sc_hd__decap_12
XTAP_TAPCELL_ROW_116_1717 VGND VPWR sky130_fd_sc_hd__tapvpwrvgnd_1
XFILLER_0_12_528 VGND VGND VPWR VPWR sky130_fd_sc_hd__decap_4
XFILLER_0_3_249 VPWR VGND VPWR VGND sky130_ef_sc_hd__decap_12
XFILLER_0_51_163 VGND VGND VPWR VPWR sky130_fd_sc_hd__decap_4
XFILLER_0_10_65 VPWR VGND VPWR VGND sky130_ef_sc_hd__decap_12
XFILLER_0_51_185 VGND VGND VPWR VPWR sky130_fd_sc_hd__decap_8
XFILLER_0_86_36 VGND VGND VPWR VPWR sky130_fd_sc_hd__fill_1
X_07750_ _02534_ _02551_ VGND VGND VPWR VPWR _02552_ sky130_fd_sc_hd__nor2_2
X_06701_ _01547_ tanh_inst.z_\[7\] _01605_ VGND VGND VPWR VPWR _01606_ sky130_fd_sc_hd__mux2_1
X_07681_ _02025_ _02275_ VGND VGND VPWR VPWR _02484_ sky130_fd_sc_hd__nand2_2
XTAP_TAPCELL_ROW_48_862 VGND VPWR sky130_fd_sc_hd__tapvpwrvgnd_1
X_06632_ tanh_inst.z_\[7\] _01477_ VGND VGND VPWR VPWR _01544_ sky130_fd_sc_hd__nor2_2
X_09420_ _04151_ _04152_ VGND VGND VPWR VPWR _04153_ sky130_fd_sc_hd__xnor2_2
XFILLER_0_87_561 VGND VGND VPWR VPWR sky130_fd_sc_hd__fill_1
X_09351_ tanh_inst.divider.y\[-13\] _02014_ _04085_ _01470_ VGND VGND VPWR VPWR _00308_
+ sky130_fd_sc_hd__o211a_2
XFILLER_0_75_723 VGND VGND VPWR VPWR sky130_fd_sc_hd__fill_1
X_06563_ tanh_inst.LOOKUP.index\[2\] tanh_inst.LOOKUP.index\[1\] VGND VGND VPWR VPWR
+ _01478_ sky130_fd_sc_hd__or2_2
XFILLER_0_19_105 VGND VGND VPWR VPWR sky130_fd_sc_hd__decap_6
X_09282_ _02022_ _03676_ _03678_ _03916_ VGND VGND VPWR VPWR _04018_ sky130_fd_sc_hd__o31ai_2
X_05514_ mac_inst.x\[31\] _04912_ VGND VGND VPWR VPWR _00510_ sky130_fd_sc_hd__nand2_2
X_08302_ _03029_ _03032_ _03089_ VGND VGND VPWR VPWR _03091_ sky130_fd_sc_hd__or3_2
X_06494_ _01413_ _01414_ VGND VGND VPWR VPWR _01415_ sky130_fd_sc_hd__and2_2
XFILLER_0_19_149 VPWR VGND VPWR VGND sky130_ef_sc_hd__decap_12
XFILLER_0_35_609 VGND VGND VPWR VPWR sky130_fd_sc_hd__fill_1
X_08233_ _03022_ _03023_ VGND VGND VPWR VPWR _03024_ sky130_fd_sc_hd__nand2b_2
XFILLER_0_117_346 VGND VGND VPWR VPWR sky130_fd_sc_hd__fill_1
X_05445_ _00445_ _00446_ VGND VGND VPWR VPWR _00447_ sky130_fd_sc_hd__nand2b_2
X_08164_ _04770_ _02954_ VGND VGND VPWR VPWR _02956_ sky130_fd_sc_hd__xnor2_2
X_05376_ _00368_ _00369_ _00366_ VGND VGND VPWR VPWR _00383_ sky130_fd_sc_hd__a21oi_2
XFILLER_0_113_541 VGND VGND VPWR VPWR sky130_fd_sc_hd__decap_4
X_07115_ _01088_ _01939_ _01940_ _01092_ tanh_inst.divider.z_\[-4\] VGND VGND VPWR
+ VPWR _00217_ sky130_fd_sc_hd__a32o_2
X_08095_ _02887_ _02888_ VGND VGND VPWR VPWR _02889_ sky130_fd_sc_hd__nand2_2
X_07046_ tanh_inst.divider.y_\[7\] _01878_ VGND VGND VPWR VPWR _01879_ sky130_fd_sc_hd__or2_2
XFILLER_0_11_561 VGND VGND VPWR VPWR sky130_fd_sc_hd__decap_4
X_08997_ tanh_inst.divider.y\[-21\] _03739_ VGND VGND VPWR VPWR _03740_ sky130_fd_sc_hd__nand2_2
X_07948_ _02683_ _02686_ _02684_ VGND VGND VPWR VPWR _02746_ sky130_fd_sc_hd__o21a_2
XFILLER_0_97_325 VGND VGND VPWR VPWR sky130_fd_sc_hd__decap_3
X_07879_ tanh_inst.LOOKUP.index\[3\] _02315_ _02509_ VGND VGND VPWR VPWR _02678_ sky130_fd_sc_hd__o21a_2
X_09618_ _04322_ _04329_ VGND VGND VPWR VPWR _04345_ sky130_fd_sc_hd__nand2_2
XFILLER_0_66_723 VGND VGND VPWR VPWR sky130_fd_sc_hd__fill_1
XFILLER_0_66_701 VGND VGND VPWR VPWR sky130_fd_sc_hd__fill_1
X_09549_ tanh_inst.divider.x\[-7\] _04277_ VGND VGND VPWR VPWR _04278_ sky130_fd_sc_hd__nor2_2
XTAP_TAPCELL_ROW_100_1507 VGND VPWR sky130_fd_sc_hd__tapvpwrvgnd_1
XFILLER_0_65_222 VGND VGND VPWR VPWR sky130_fd_sc_hd__fill_2
XTAP_TAPCELL_ROW_26_589 VGND VPWR sky130_fd_sc_hd__tapvpwrvgnd_1
XTAP_TAPCELL_ROW_100_1518 VGND VPWR sky130_fd_sc_hd__tapvpwrvgnd_1
XFILLER_0_19_650 VGND VGND VPWR VPWR sky130_fd_sc_hd__fill_1
XFILLER_0_34_642 VGND VGND VPWR VPWR sky130_fd_sc_hd__fill_2
XFILLER_0_34_653 VGND VGND VPWR VPWR sky130_fd_sc_hd__fill_2
XFILLER_0_116_390 VGND VGND VPWR VPWR sky130_fd_sc_hd__fill_2
X_10324_ clknet_leaf_21_clk _00181_ VGND VGND VPWR VPWR tanh_out[16] sky130_fd_sc_hd__dfxtp_2
XFILLER_0_21_369 VGND VGND VPWR VPWR sky130_fd_sc_hd__decap_4
X_10255_ clknet_leaf_32_clk mac_inst.x\[17\] _00000_ VGND VGND VPWR VPWR mac_x_out[17]
+ sky130_fd_sc_hd__dfrtp_2
XTAP_TAPCELL_ROW_111_1647 VGND VPWR sky130_fd_sc_hd__tapvpwrvgnd_1
X_10186_ x_in[12] _00000_ VGND VGND VPWR VPWR mac_inst.x\[12\] sky130_fd_sc_hd__dlxtn_1
XFILLER_0_88_336 VGND VGND VPWR VPWR sky130_fd_sc_hd__fill_1
XFILLER_0_72_27 VGND VGND VPWR VPWR sky130_fd_sc_hd__fill_1
XTAP_TAPCELL_ROW_45_821 VGND VPWR sky130_fd_sc_hd__tapvpwrvgnd_1
XFILLER_0_69_561 VPWR VGND VPWR VGND sky130_ef_sc_hd__decap_12
XFILLER_0_57_723 VGND VGND VPWR VPWR sky130_fd_sc_hd__fill_1
XFILLER_0_84_564 VGND VGND VPWR VPWR sky130_fd_sc_hd__decap_3
XFILLER_0_71_225 VPWR VGND VPWR VGND sky130_ef_sc_hd__decap_12
XFILLER_0_56_299 VGND VGND VPWR VPWR sky130_fd_sc_hd__decap_8
XFILLER_0_115_3 VPWR VGND VPWR VGND sky130_ef_sc_hd__decap_12
XFILLER_0_112_77 VGND VGND VPWR VPWR sky130_fd_sc_hd__decap_6
X_05230_ start _04809_ _04818_ _04780_ _04931_ VGND VGND VPWR VPWR next_state\[0\]
+ sky130_fd_sc_hd__a221o_2
XFILLER_0_4_525 VGND VGND VPWR VPWR sky130_fd_sc_hd__decap_6
XTAP_TAPCELL_ROW_77_1222 VGND VPWR sky130_fd_sc_hd__tapvpwrvgnd_1
X_05161_ mac_inst.x\[23\] _04852_ _04853_ VGND VGND VPWR VPWR _04865_ sky130_fd_sc_hd__a21o_2
XFILLER_0_24_141 VGND VGND VPWR VPWR sky130_fd_sc_hd__fill_1
XFILLER_0_40_601 VGND VGND VPWR VPWR sky130_fd_sc_hd__decap_4
XFILLER_0_52_472 VGND VGND VPWR VPWR sky130_fd_sc_hd__decap_4
XFILLER_0_110_533 VGND VGND VPWR VPWR sky130_fd_sc_hd__fill_1
XFILLER_0_97_57 VPWR VGND VPWR VGND sky130_ef_sc_hd__decap_12
X_05092_ tanh_counter\[4\] _04806_ tanh_counter\[5\] VGND VGND VPWR VPWR _04812_ sky130_fd_sc_hd__a21o_2
X_08920_ _02018_ _03664_ _03629_ _02015_ VGND VGND VPWR VPWR _03665_ sky130_fd_sc_hd__a211o_2
X_08851_ _02026_ _03589_ _03592_ _02024_ VGND VGND VPWR VPWR _03596_ sky130_fd_sc_hd__o211a_2
X_07802_ _02515_ _02516_ _02567_ tanh_inst.z_\[7\] VGND VGND VPWR VPWR _02603_ sky130_fd_sc_hd__a31o_2
X_08782_ _04757_ _02020_ tanh_inst.divider.x\[-19\] VGND VGND VPWR VPWR _03528_ sky130_fd_sc_hd__a21o_2
X_05994_ mac_inst.z\[23\] _00933_ _00948_ VGND VGND VPWR VPWR _00949_ sky130_fd_sc_hd__a21oi_2
X_07733_ tanh_inst.divider.x\[-16\] _02534_ VGND VGND VPWR VPWR _02535_ sky130_fd_sc_hd__and2_2
XFILLER_0_46_94 VPWR VGND VPWR VGND sky130_ef_sc_hd__decap_12
XTAP_TAPCELL_ROW_88_1362 VGND VPWR sky130_fd_sc_hd__tapvpwrvgnd_1
X_07664_ tanh_inst.LOOKUP.index\[3\] tanh_inst.LOOKUP.index\[2\] _02252_ VGND VGND
+ VPWR VPWR _02468_ sky130_fd_sc_hd__or3_2
X_09403_ tanh_inst.divider.y\[-12\] _04087_ _04100_ VGND VGND VPWR VPWR _04136_ sky130_fd_sc_hd__a21o_2
X_06615_ _01480_ _01484_ VGND VGND VPWR VPWR _01528_ sky130_fd_sc_hd__nor2_2
XFILLER_0_48_701 VPWR VGND VPWR VGND sky130_ef_sc_hd__decap_12
X_07595_ _02397_ _02399_ VGND VGND VPWR VPWR _02400_ sky130_fd_sc_hd__nor2_2
X_09334_ _04067_ _04068_ VGND VGND VPWR VPWR _04069_ sky130_fd_sc_hd__nor2_2
X_06546_ tanh_inst.divider.y_\[7\] _01452_ _01453_ VGND VGND VPWR VPWR _01462_ sky130_fd_sc_hd__or3_2
X_09265_ _04000_ _04001_ VGND VGND VPWR VPWR _04002_ sky130_fd_sc_hd__and2b_2
X_06477_ _01392_ _01398_ _01399_ VGND VGND VPWR VPWR _01400_ sky130_fd_sc_hd__o21a_2
XTAP_TAPCELL_ROW_23_548 VGND VPWR sky130_fd_sc_hd__tapvpwrvgnd_1
XFILLER_0_118_699 VGND VGND VPWR VPWR sky130_fd_sc_hd__fill_1
X_09196_ _03887_ _03891_ _03934_ VGND VGND VPWR VPWR _03935_ sky130_fd_sc_hd__a21oi_2
X_05428_ _04835_ _00430_ _00429_ _05020_ VGND VGND VPWR VPWR _00431_ sky130_fd_sc_hd__a211o_2
X_08216_ _03005_ _03006_ VGND VGND VPWR VPWR _03007_ sky130_fd_sc_hd__xor2_2
XFILLER_0_90_589 VGND VGND VPWR VPWR sky130_fd_sc_hd__decap_3
XFILLER_0_7_385 VGND VGND VPWR VPWR sky130_fd_sc_hd__fill_1
XFILLER_0_43_461 VGND VGND VPWR VPWR sky130_fd_sc_hd__decap_3
X_08147_ _02938_ _02939_ VGND VGND VPWR VPWR _02940_ sky130_fd_sc_hd__nor2_2
X_05359_ mac_inst.y\[3\] _00365_ VGND VGND VPWR VPWR _00367_ sky130_fd_sc_hd__xnor2_2
X_08078_ tanh_inst.divider.y\[-8\] _02870_ VGND VGND VPWR VPWR _02872_ sky130_fd_sc_hd__and2_2
XFILLER_0_3_591 VGND VGND VPWR VPWR sky130_fd_sc_hd__fill_2
XFILLER_0_113_393 VPWR VGND VPWR VGND sky130_ef_sc_hd__decap_12
X_07029_ _01862_ _01863_ tanh_inst.divider.z_\[-13\] VGND VGND VPWR VPWR _01864_ sky130_fd_sc_hd__a21o_2
XFILLER_0_31_689 VGND VGND VPWR VPWR sky130_fd_sc_hd__fill_2
X_10040_ _01513_ _04749_ _04751_ _01470_ VGND VGND VPWR VPWR _00330_ sky130_fd_sc_hd__o211a_2
XFILLER_0_11_391 VGND VGND VPWR VPWR sky130_fd_sc_hd__fill_1
XFILLER_0_98_645 VGND VGND VPWR VPWR sky130_fd_sc_hd__fill_1
XFILLER_0_97_144 VGND VGND VPWR VPWR sky130_fd_sc_hd__decap_3
XTAP_TAPCELL_ROW_3_295 VGND VPWR sky130_fd_sc_hd__tapvpwrvgnd_1
XFILLER_0_78_380 VGND VGND VPWR VPWR sky130_fd_sc_hd__decap_4
XFILLER_0_66_520 VPWR VGND VPWR VGND sky130_ef_sc_hd__decap_12
XTAP_TAPCELL_ROW_61_1023 VGND VPWR sky130_fd_sc_hd__tapvpwrvgnd_1
XFILLER_0_108_121 VGND VGND VPWR VPWR sky130_fd_sc_hd__decap_6
XFILLER_0_38_288 VGND VGND VPWR VPWR sky130_fd_sc_hd__decap_6
XFILLER_0_81_578 VGND VGND VPWR VPWR sky130_fd_sc_hd__decap_4
XTAP_TAPCELL_ROW_50_890 VGND VPWR sky130_fd_sc_hd__tapvpwrvgnd_1
XFILLER_0_21_111 VGND VGND VPWR VPWR sky130_fd_sc_hd__fill_1
XFILLER_0_22_645 VGND VGND VPWR VPWR sky130_fd_sc_hd__decap_6
X_10307_ clknet_leaf_14_clk _00164_ VGND VGND VPWR VPWR tanh_inst.divider.i\[4\] sky130_fd_sc_hd__dfxtp_2
XTAP_TAPCELL_ROW_72_1163 VGND VPWR sky130_fd_sc_hd__tapvpwrvgnd_1
X_10238_ clknet_leaf_32_clk mac_inst.x\[0\] _00000_ VGND VGND VPWR VPWR mac_x_out[0]
+ sky130_fd_sc_hd__dfrtp_2
XFILLER_0_83_15 VPWR VGND VPWR VGND sky130_ef_sc_hd__decap_12
XFILLER_0_107_55 VGND VGND VPWR VPWR sky130_fd_sc_hd__fill_1
XFILLER_0_89_645 VGND VGND VPWR VPWR sky130_fd_sc_hd__decap_3
XFILLER_0_89_634 VGND VGND VPWR VPWR sky130_fd_sc_hd__decap_4
XFILLER_0_88_111 VGND VGND VPWR VPWR sky130_fd_sc_hd__decap_6
XFILLER_0_16_53 VPWR VGND VPWR VGND sky130_ef_sc_hd__decap_12
XTAP_TAPCELL_ROW_58_990 VGND VPWR sky130_fd_sc_hd__tapvpwrvgnd_1
X_06400_ _01326_ _01327_ VGND VGND VPWR VPWR _01329_ sky130_fd_sc_hd__nor2_2
XFILLER_0_16_97 VPWR VGND VPWR VGND sky130_ef_sc_hd__decap_12
X_07380_ tanh_inst.divider.y\[-15\] tanh_inst.divider.y\[-14\] tanh_inst.divider.y\[-13\]
+ tanh_inst.divider.y\[-12\] tanh_inst.LOOKUP.index\[0\] tanh_inst.LOOKUP.index\[1\]
+ VGND VGND VPWR VPWR _02189_ sky130_fd_sc_hd__mux4_2
XFILLER_0_69_391 VGND VGND VPWR VPWR sky130_fd_sc_hd__fill_1
X_06331_ _01031_ _01161_ VGND VGND VPWR VPWR _01265_ sky130_fd_sc_hd__or2_2
X_06262_ _01200_ _01201_ _01089_ VGND VGND VPWR VPWR _01202_ sky130_fd_sc_hd__a21oi_2
XFILLER_0_115_614 VGND VGND VPWR VPWR sky130_fd_sc_hd__fill_2
X_09050_ tanh_inst.divider.x\[-20\] _03790_ VGND VGND VPWR VPWR _03792_ sky130_fd_sc_hd__and2_2
XFILLER_0_72_545 VGND VGND VPWR VPWR sky130_fd_sc_hd__fill_1
XTAP_TAPCELL_ROW_20_507 VGND VPWR sky130_fd_sc_hd__tapvpwrvgnd_1
XTAP_TAPCELL_ROW_20_518 VGND VPWR sky130_fd_sc_hd__tapvpwrvgnd_1
XFILLER_0_115_636 VGND VGND VPWR VPWR sky130_fd_sc_hd__fill_1
X_08001_ _02699_ _02757_ _02758_ VGND VGND VPWR VPWR _02797_ sky130_fd_sc_hd__o21a_2
XFILLER_0_60_707 VGND VGND VPWR VPWR sky130_fd_sc_hd__fill_2
XFILLER_0_4_333 VPWR VGND VPWR VGND sky130_ef_sc_hd__decap_12
X_05213_ mac_inst.x\[6\] _04852_ _04853_ VGND VGND VPWR VPWR _04917_ sky130_fd_sc_hd__a21oi_2
X_06193_ tanh_inst.divider.y\[-21\] tanh_inst.div_en tanh_inst.divider.y_\[-21\] _01092_
+ VGND VGND VPWR VPWR _01137_ sky130_fd_sc_hd__a22o_2
XFILLER_0_13_612 VGND VGND VPWR VPWR sky130_fd_sc_hd__decap_4
XFILLER_0_12_133 VGND VGND VPWR VPWR sky130_fd_sc_hd__decap_6
XFILLER_0_4_377 VGND VGND VPWR VPWR sky130_fd_sc_hd__decap_8
X_05144_ mac_inst.i\[25\] mac_inst.i\[24\] VGND VGND VPWR VPWR _04848_ sky130_fd_sc_hd__or2_2
X_09952_ _03384_ _04649_ VGND VGND VPWR VPWR _04670_ sky130_fd_sc_hd__nor2_2
XFILLER_0_12_177 VPWR VGND VPWR VGND sky130_ef_sc_hd__decap_12
X_05075_ mac_inst.z\[7\] VGND VGND VPWR VPWR _04799_ sky130_fd_sc_hd__inv_2
XFILLER_0_40_475 VGND VGND VPWR VPWR sky130_fd_sc_hd__fill_1
XFILLER_0_110_363 VGND VGND VPWR VPWR sky130_fd_sc_hd__fill_1
XFILLER_0_0_561 VGND VGND VPWR VPWR sky130_fd_sc_hd__fill_2
X_08903_ tanh_inst.divider.x\[-4\] tanh_inst.divider.x\[-3\] tanh_inst.divider.x\[-2\]
+ tanh_inst.divider.x\[-1\] tanh_inst.LOOKUP.index\[0\] tanh_inst.LOOKUP.index\[1\]
+ VGND VGND VPWR VPWR _03648_ sky130_fd_sc_hd__mux4_2
X_09883_ _04527_ _04528_ _04602_ VGND VGND VPWR VPWR _04603_ sky130_fd_sc_hd__a21o_2
X_08834_ _01524_ _03575_ _03576_ _03579_ VGND VGND VPWR VPWR _03580_ sky130_fd_sc_hd__a211o_2
X_08765_ tanh_inst.divider.x\[-10\] _02028_ _03508_ VGND VGND VPWR VPWR _03511_ sky130_fd_sc_hd__o21a_2
X_07716_ tanh_inst.divider.x\[-17\] _02518_ VGND VGND VPWR VPWR _02519_ sky130_fd_sc_hd__and2_2
X_05977_ mac_inst.z\[31\] _00932_ _00930_ VGND VGND VPWR VPWR _00933_ sky130_fd_sc_hd__o21ai_2
XTAP_TAPCELL_ROW_28_607 VGND VPWR sky130_fd_sc_hd__tapvpwrvgnd_1
XTAP_TAPCELL_ROW_28_618 VGND VPWR sky130_fd_sc_hd__tapvpwrvgnd_1
X_08696_ tanh_inst.divider.x\[6\] _03445_ _03457_ VGND VGND VPWR VPWR _03475_ sky130_fd_sc_hd__a21oi_2
XPHY_EDGE_ROW_69_Left_191 VGND VGND VPWR VPWR sky130_fd_sc_hd__decap_3
XTAP_TAPCELL_ROW_0_254 VGND VPWR sky130_fd_sc_hd__tapvpwrvgnd_1
X_07647_ _02337_ _02352_ _02400_ _02450_ VGND VGND VPWR VPWR _02451_ sky130_fd_sc_hd__a31o_2
XTAP_TAPCELL_ROW_0_265 VGND VPWR sky130_fd_sc_hd__tapvpwrvgnd_1
X_07578_ tanh_inst.divider.x\[-20\] _02014_ VGND VGND VPWR VPWR _02384_ sky130_fd_sc_hd__or2_2
XFILLER_0_82_309 VPWR VGND VPWR VGND sky130_ef_sc_hd__decap_12
X_06529_ tanh_inst.divider.y_\[5\] _01444_ VGND VGND VPWR VPWR _01447_ sky130_fd_sc_hd__and2_2
X_09317_ _03983_ _03985_ _04011_ _04012_ VGND VGND VPWR VPWR _04053_ sky130_fd_sc_hd__a31o_2
XFILLER_0_75_361 VGND VGND VPWR VPWR sky130_fd_sc_hd__fill_2
XFILLER_0_48_586 VGND VGND VPWR VPWR sky130_fd_sc_hd__fill_2
XFILLER_0_35_225 VGND VGND VPWR VPWR sky130_fd_sc_hd__fill_2
XFILLER_0_105_113 VGND VGND VPWR VPWR sky130_fd_sc_hd__decap_8
X_09248_ _03976_ _03984_ VGND VGND VPWR VPWR _03986_ sky130_fd_sc_hd__nand2_2
XFILLER_0_8_694 VGND VGND VPWR VPWR sky130_fd_sc_hd__fill_1
XFILLER_0_7_193 VPWR VGND VPWR VGND sky130_ef_sc_hd__decap_12
X_09179_ _02022_ _03917_ _03916_ VGND VGND VPWR VPWR _03918_ sky130_fd_sc_hd__o21a_2
XFILLER_0_16_483 VGND VGND VPWR VPWR sky130_fd_sc_hd__decap_3
XFILLER_0_50_239 VPWR VGND VPWR VGND sky130_ef_sc_hd__decap_12
XFILLER_0_9_3 VPWR VGND VPWR VGND sky130_ef_sc_hd__decap_12
XFILLER_0_101_385 VGND VGND VPWR VPWR sky130_fd_sc_hd__decap_6
XTAP_TAPCELL_ROW_8_365 VGND VPWR sky130_fd_sc_hd__tapvpwrvgnd_1
X_10023_ tanh_inst.divider.y\[7\] _04737_ VGND VGND VPWR VPWR _04738_ sky130_fd_sc_hd__xnor2_2
XFILLER_0_53_29 VGND VGND VPWR VPWR sky130_fd_sc_hd__decap_4
XFILLER_0_98_486 VGND VGND VPWR VPWR sky130_fd_sc_hd__decap_6
XFILLER_0_86_626 VGND VGND VPWR VPWR sky130_fd_sc_hd__fill_1
XFILLER_0_58_328 VGND VGND VPWR VPWR sky130_fd_sc_hd__decap_4
XFILLER_0_85_169 VGND VGND VPWR VPWR sky130_fd_sc_hd__fill_2
XFILLER_0_54_556 VGND VGND VPWR VPWR sky130_fd_sc_hd__decap_8
XFILLER_0_54_545 VGND VGND VPWR VPWR sky130_fd_sc_hd__decap_6
XFILLER_0_54_523 VGND VGND VPWR VPWR sky130_fd_sc_hd__decap_8
XFILLER_0_109_485 VGND VGND VPWR VPWR sky130_fd_sc_hd__fill_1
XFILLER_0_14_409 VGND VGND VPWR VPWR sky130_fd_sc_hd__decap_6
XFILLER_0_111_105 VGND VGND VPWR VPWR sky130_fd_sc_hd__decap_6
X_06880_ tanh_inst.divider.i\[0\] _01060_ tanh_inst.div_en VGND VGND VPWR VPWR _01763_
+ sky130_fd_sc_hd__a21oi_2
XFILLER_0_94_47 VGND VGND VPWR VPWR sky130_fd_sc_hd__fill_1
X_05900_ _00804_ _00819_ _00857_ _00862_ VGND VGND VPWR VPWR _00863_ sky130_fd_sc_hd__o31a_2
XFILLER_0_118_65 VPWR VGND VPWR VGND sky130_ef_sc_hd__decap_12
X_05831_ mac_inst.z\[31\] _00785_ _00797_ VGND VGND VPWR VPWR _00798_ sky130_fd_sc_hd__o21ai_2
XFILLER_0_89_431 VGND VGND VPWR VPWR sky130_fd_sc_hd__fill_1
XTAP_TAPCELL_ROW_85_1321 VGND VPWR sky130_fd_sc_hd__tapvpwrvgnd_1
X_05762_ mac_inst.z\[6\] _00734_ VGND VGND VPWR VPWR _00735_ sky130_fd_sc_hd__or2_2
X_08550_ _03309_ _03312_ _03332_ VGND VGND VPWR VPWR _03333_ sky130_fd_sc_hd__o21a_2
X_07501_ _02239_ _02241_ _02306_ VGND VGND VPWR VPWR _02308_ sky130_fd_sc_hd__o21a_2
XFILLER_0_77_626 VGND VGND VPWR VPWR sky130_fd_sc_hd__decap_3
XFILLER_0_76_103 VPWR VGND VPWR VGND sky130_ef_sc_hd__decap_12
X_05693_ _00668_ mac_inst.z\[1\] VGND VGND VPWR VPWR _00671_ sky130_fd_sc_hd__nand2b_2
X_08481_ _03264_ _03265_ VGND VGND VPWR VPWR _03266_ sky130_fd_sc_hd__nor2_2
XTAP_TAPCELL_ROW_53_919 VGND VPWR sky130_fd_sc_hd__tapvpwrvgnd_1
XFILLER_0_119_216 VGND VGND VPWR VPWR sky130_fd_sc_hd__decap_3
X_07432_ _02223_ _02237_ VGND VGND VPWR VPWR _02240_ sky130_fd_sc_hd__xnor2_2
XFILLER_0_77_659 VGND VGND VPWR VPWR sky130_fd_sc_hd__fill_1
XFILLER_0_119_249 VPWR VGND VPWR VGND sky130_ef_sc_hd__decap_12
XFILLER_0_43_95 VGND VGND VPWR VPWR sky130_fd_sc_hd__fill_2
X_09102_ _03789_ _03791_ _03842_ VGND VGND VPWR VPWR _03843_ sky130_fd_sc_hd__o21ai_2
X_07363_ tanh_inst.divider.y\[-24\] tanh_inst.divider.x\[-24\] VGND VGND VPWR VPWR
+ _02172_ sky130_fd_sc_hd__or2_2
XFILLER_0_84_191 VGND VGND VPWR VPWR sky130_fd_sc_hd__decap_4
XFILLER_0_17_225 VPWR VGND VPWR VGND sky130_ef_sc_hd__decap_12
XTAP_TAPCELL_ROW_33_676 VGND VPWR sky130_fd_sc_hd__tapvpwrvgnd_1
X_06314_ _01039_ _01138_ _01247_ _04776_ _01248_ VGND VGND VPWR VPWR _01249_ sky130_fd_sc_hd__o221a_2
X_07294_ tanh_inst.divider.y\[-16\] tanh_inst.divider.y\[-15\] tanh_inst.divider.y\[-14\]
+ tanh_inst.divider.y\[-13\] tanh_inst.LOOKUP.index\[0\] tanh_inst.LOOKUP.index\[1\]
+ VGND VGND VPWR VPWR _02104_ sky130_fd_sc_hd__mux4_2
XFILLER_0_32_206 VGND VGND VPWR VPWR sky130_fd_sc_hd__fill_1
X_06245_ _01168_ _01182_ _01183_ _01185_ _01088_ VGND VGND VPWR VPWR _01186_ sky130_fd_sc_hd__o311a_2
XFILLER_0_87_3 VGND VGND VPWR VPWR sky130_fd_sc_hd__decap_8
X_09033_ _03775_ VGND VGND VPWR VPWR _03776_ sky130_fd_sc_hd__inv_2
XFILLER_0_4_141 VPWR VGND VPWR VGND sky130_ef_sc_hd__decap_12
XFILLER_0_115_499 VGND VGND VPWR VPWR sky130_fd_sc_hd__decap_4
X_06176_ tanh_inst.divider.i\[2\] _01119_ _01118_ VGND VGND VPWR VPWR _01120_ sky130_fd_sc_hd__o21a_2
XTAP_TAPCELL_ROW_96_1461 VGND VPWR sky130_fd_sc_hd__tapvpwrvgnd_1
XFILLER_0_13_431 VGND VGND VPWR VPWR sky130_fd_sc_hd__decap_4
X_05127_ mac_counter\[2\] _04833_ _04823_ _00000_ VGND VGND VPWR VPWR _00120_ sky130_fd_sc_hd__o211a_2
XFILLER_0_7_51 VGND VGND VPWR VPWR sky130_fd_sc_hd__decap_4
XFILLER_0_40_250 VGND VGND VPWR VPWR sky130_fd_sc_hd__fill_2
XFILLER_0_13_497 VGND VGND VPWR VPWR sky130_fd_sc_hd__decap_6
X_09935_ tanh_inst.divider.x\[4\] _04652_ VGND VGND VPWR VPWR _04653_ sky130_fd_sc_hd__nor2_2
X_05058_ mac_inst.i\[2\] VGND VGND VPWR VPWR _04782_ sky130_fd_sc_hd__inv_2
XTAP_TAPCELL_ROW_5_324 VGND VPWR sky130_fd_sc_hd__tapvpwrvgnd_1
X_09866_ _03302_ _04585_ VGND VGND VPWR VPWR _04586_ sky130_fd_sc_hd__nor2_2
XFILLER_0_99_217 VGND VGND VPWR VPWR sky130_fd_sc_hd__decap_6
X_08817_ tanh_inst.divider.x\[-6\] _02028_ _03508_ VGND VGND VPWR VPWR _03563_ sky130_fd_sc_hd__o21ai_2
X_09797_ _04517_ _04518_ VGND VGND VPWR VPWR _04519_ sky130_fd_sc_hd__or2_2
X_08748_ mac_inst.i\[23\] _00966_ VGND VGND VPWR VPWR _00288_ sky130_fd_sc_hd__xor2_2
XFILLER_0_95_423 VPWR VGND VPWR VGND sky130_ef_sc_hd__decap_12
X_08679_ _03457_ _03458_ VGND VGND VPWR VPWR _03459_ sky130_fd_sc_hd__nor2_2
XFILLER_0_67_125 VGND VGND VPWR VPWR sky130_fd_sc_hd__decap_8
XFILLER_0_76_670 VGND VGND VPWR VPWR sky130_fd_sc_hd__decap_4
XFILLER_0_67_169 VGND VGND VPWR VPWR sky130_fd_sc_hd__fill_1
XFILLER_0_48_350 VPWR VGND VPWR VGND sky130_ef_sc_hd__decap_12
XFILLER_0_63_331 VGND VGND VPWR VPWR sky130_fd_sc_hd__decap_4
XFILLER_0_91_673 VGND VGND VPWR VPWR sky130_fd_sc_hd__fill_1
XFILLER_0_36_589 VGND VGND VPWR VPWR sky130_fd_sc_hd__fill_2
XFILLER_0_106_466 VGND VGND VPWR VPWR sky130_fd_sc_hd__fill_1
XFILLER_0_51_537 VGND VGND VPWR VPWR sky130_fd_sc_hd__fill_2
XFILLER_0_51_559 VGND VGND VPWR VPWR sky130_fd_sc_hd__fill_1
XFILLER_0_31_272 VGND VGND VPWR VPWR sky130_fd_sc_hd__decap_3
X_10006_ _04720_ _04721_ VGND VGND VPWR VPWR _04722_ sky130_fd_sc_hd__nor2_2
XTAP_TAPCELL_ROW_108_1608 VGND VPWR sky130_fd_sc_hd__tapvpwrvgnd_1
XFILLER_0_59_604 VGND VGND VPWR VPWR sky130_fd_sc_hd__fill_1
XFILLER_0_98_283 VGND VGND VPWR VPWR sky130_fd_sc_hd__decap_3
XFILLER_0_86_467 VGND VGND VPWR VPWR sky130_fd_sc_hd__decap_4
XFILLER_0_58_147 VGND VGND VPWR VPWR sky130_fd_sc_hd__fill_1
XFILLER_0_86_489 VGND VGND VPWR VPWR sky130_fd_sc_hd__decap_8
XTAP_TAPCELL_ROW_67_1095 VGND VPWR sky130_fd_sc_hd__tapvpwrvgnd_1
XFILLER_0_46_309 VGND VGND VPWR VPWR sky130_fd_sc_hd__decap_4
XTAP_TAPCELL_ROW_80_1262 VGND VPWR sky130_fd_sc_hd__tapvpwrvgnd_1
XFILLER_0_73_128 VPWR VGND VPWR VGND sky130_ef_sc_hd__decap_12
XFILLER_0_109_271 VGND VGND VPWR VPWR sky130_fd_sc_hd__decap_3
XFILLER_0_82_651 VGND VGND VPWR VPWR sky130_fd_sc_hd__decap_3
XFILLER_0_27_556 VGND VGND VPWR VPWR sky130_fd_sc_hd__decap_4
XTAP_TAPCELL_ROW_30_635 VGND VPWR sky130_fd_sc_hd__tapvpwrvgnd_1
XTAP_TAPCELL_ROW_119_1748 VGND VPWR sky130_fd_sc_hd__tapvpwrvgnd_1
XFILLER_0_109_293 VPWR VGND VPWR VGND sky130_ef_sc_hd__decap_12
XFILLER_0_2_601 VGND VGND VPWR VPWR sky130_fd_sc_hd__decap_8
X_06030_ _00982_ VGND VGND VPWR VPWR _00983_ sky130_fd_sc_hd__inv_2
XFILLER_0_120_77 VGND VGND VPWR VPWR sky130_fd_sc_hd__decap_6
XTAP_TAPCELL_ROW_10_392 VGND VPWR sky130_fd_sc_hd__tapvpwrvgnd_1
XTAP_TAPCELL_ROW_10_381 VGND VPWR sky130_fd_sc_hd__tapvpwrvgnd_1
XFILLER_0_1_111 VGND VGND VPWR VPWR sky130_fd_sc_hd__fill_1
XFILLER_0_2_645 VGND VGND VPWR VPWR sky130_fd_sc_hd__decap_4
XFILLER_0_2_656 VGND VGND VPWR VPWR sky130_fd_sc_hd__decap_4
XFILLER_0_112_469 VGND VGND VPWR VPWR sky130_fd_sc_hd__decap_6
XFILLER_0_2_689 VGND VGND VPWR VPWR sky130_fd_sc_hd__decap_8
XFILLER_0_50_581 VGND VGND VPWR VPWR sky130_fd_sc_hd__fill_1
XFILLER_0_120_491 VGND VGND VPWR VPWR sky130_fd_sc_hd__decap_4
X_07981_ tanh_inst.divider.x\[-11\] _02777_ VGND VGND VPWR VPWR _02778_ sky130_fd_sc_hd__or2_2
X_06932_ _04777_ _01765_ _01776_ VGND VGND VPWR VPWR _01777_ sky130_fd_sc_hd__or3_2
X_09720_ _04441_ _04443_ VGND VGND VPWR VPWR _04444_ sky130_fd_sc_hd__nor2_2
XFILLER_0_38_95 VGND VGND VPWR VPWR sky130_fd_sc_hd__fill_2
X_06863_ _01745_ _01749_ VGND VGND VPWR VPWR _01750_ sky130_fd_sc_hd__nand2_2
X_09651_ _04369_ _04375_ VGND VGND VPWR VPWR _04377_ sky130_fd_sc_hd__nor2_2
X_08602_ _03382_ _03383_ VGND VGND VPWR VPWR _03384_ sky130_fd_sc_hd__xnor2_2
X_06794_ tanh_inst.z_\[-4\] _01688_ VGND VGND VPWR VPWR _01689_ sky130_fd_sc_hd__xor2_2
X_05814_ _00779_ _00781_ VGND VGND VPWR VPWR _05814_/X sky130_fd_sc_hd__xor2_2
XTAP_TAPCELL_ROW_38_735 VGND VPWR sky130_fd_sc_hd__tapvpwrvgnd_1
X_09582_ _02976_ _04308_ VGND VGND VPWR VPWR _04310_ sky130_fd_sc_hd__xor2_2
X_05745_ _00708_ _00718_ VGND VGND VPWR VPWR _00719_ sky130_fd_sc_hd__and2_2
X_08533_ _03314_ _03315_ VGND VGND VPWR VPWR _03317_ sky130_fd_sc_hd__xnor2_2
XTAP_TAPCELL_ROW_18_481 VGND VPWR sky130_fd_sc_hd__tapvpwrvgnd_1
XTAP_TAPCELL_ROW_18_492 VGND VPWR sky130_fd_sc_hd__tapvpwrvgnd_1
X_05676_ _00649_ _00656_ VGND VGND VPWR VPWR _00657_ sky130_fd_sc_hd__nand2_2
X_08464_ tanh_inst.divider.x\[0\] _02015_ _03235_ _03249_ _01469_ VGND VGND VPWR VPWR
+ _00257_ sky130_fd_sc_hd__a221o_2
XFILLER_0_49_169 VGND VGND VPWR VPWR sky130_fd_sc_hd__decap_4
X_07415_ _02053_ _02217_ _02222_ _02212_ VGND VGND VPWR VPWR _02223_ sky130_fd_sc_hd__a31o_2
XFILLER_0_58_692 VGND VGND VPWR VPWR sky130_fd_sc_hd__decap_8
X_08395_ _03146_ _03148_ _03181_ VGND VGND VPWR VPWR _03182_ sky130_fd_sc_hd__o21a_2
X_07346_ _02023_ _02143_ _02154_ _02052_ VGND VGND VPWR VPWR _02155_ sky130_fd_sc_hd__o211ai_2
XFILLER_0_73_673 VGND VGND VPWR VPWR sky130_fd_sc_hd__decap_8
XFILLER_0_45_364 VGND VGND VPWR VPWR sky130_fd_sc_hd__decap_8
XFILLER_0_18_589 VGND VGND VPWR VPWR sky130_fd_sc_hd__decap_6
X_07277_ _02079_ _02083_ _02085_ _02081_ _04760_ _04761_ VGND VGND VPWR VPWR _02087_
+ sky130_fd_sc_hd__mux4_2
XFILLER_0_33_559 VGND VGND VPWR VPWR sky130_fd_sc_hd__fill_1
X_09016_ _03757_ _03758_ tanh_inst.LOOKUP.index\[2\] VGND VGND VPWR VPWR _03759_ sky130_fd_sc_hd__mux2_1
X_06228_ _01151_ _01153_ _01150_ VGND VGND VPWR VPWR _01170_ sky130_fd_sc_hd__a21o_2
XFILLER_0_13_261 VPWR VGND VPWR VGND sky130_ef_sc_hd__decap_12
XFILLER_0_20_209 VPWR VGND VPWR VGND sky130_ef_sc_hd__decap_12
X_06159_ tanh_inst.divider.x\[-10\] tanh_inst.divider.x\[-9\] tanh_inst.divider.x\[-8\]
+ tanh_inst.divider.x\[-7\] tanh_inst.divider.i\[0\] tanh_inst.divider.i\[1\] VGND
+ VGND VPWR VPWR _01104_ sky130_fd_sc_hd__mux4_2
XFILLER_0_41_581 VGND VGND VPWR VPWR sky130_fd_sc_hd__decap_6
X_09918_ _04635_ _04636_ VGND VGND VPWR VPWR _04637_ sky130_fd_sc_hd__xnor2_2
X_09849_ _04510_ _04513_ _04569_ VGND VGND VPWR VPWR _04570_ sky130_fd_sc_hd__a21oi_2
XFILLER_0_68_456 VPWR VGND VPWR VGND sky130_ef_sc_hd__decap_12
XTAP_TAPCELL_ROW_103_1549 VGND VPWR sky130_fd_sc_hd__tapvpwrvgnd_1
XFILLER_0_121_277 VGND VGND VPWR VPWR sky130_fd_sc_hd__decap_3
XTAP_TAPCELL_ROW_114_1689 VGND VPWR sky130_fd_sc_hd__tapvpwrvgnd_1
XFILLER_0_91_15 VPWR VGND VPWR VGND sky130_ef_sc_hd__decap_12
XTAP_TAPCELL_ROW_69_1124 VGND VPWR sky130_fd_sc_hd__tapvpwrvgnd_1
XTAP_TAPCELL_ROW_35_705 VGND VPWR sky130_fd_sc_hd__tapvpwrvgnd_1
XFILLER_0_115_55 VGND VGND VPWR VPWR sky130_fd_sc_hd__fill_1
XFILLER_0_59_445 VGND VGND VPWR VPWR sky130_fd_sc_hd__decap_3
XFILLER_0_86_253 VGND VGND VPWR VPWR sky130_fd_sc_hd__decap_6
XFILLER_0_59_467 VGND VGND VPWR VPWR sky130_fd_sc_hd__fill_2
XFILLER_0_24_53 VPWR VGND VPWR VGND sky130_ef_sc_hd__decap_12
X_05530_ _00465_ _00466_ _00523_ mac_inst.z\[31\] VGND VGND VPWR VPWR _00525_ sky130_fd_sc_hd__a31o_2
XFILLER_0_46_106 VGND VGND VPWR VPWR sky130_fd_sc_hd__fill_2
XTAP_TAPCELL_ROW_15_451 VGND VPWR sky130_fd_sc_hd__tapvpwrvgnd_1
XFILLER_0_24_97 VGND VGND VPWR VPWR sky130_fd_sc_hd__decap_4
X_05461_ _00459_ _00461_ VGND VGND VPWR VPWR _05461_/Y sky130_fd_sc_hd__xnor2_2
X_07200_ _01502_ _01570_ tanh_inst.IS_FIRST4 _01469_ VGND VGND VPWR VPWR _00231_ sky130_fd_sc_hd__o2bb2a_2
XFILLER_0_55_651 VGND VGND VPWR VPWR sky130_fd_sc_hd__decap_4
XFILLER_0_55_640 VGND VGND VPWR VPWR sky130_fd_sc_hd__decap_4
X_05392_ _00382_ _00383_ _00380_ VGND VGND VPWR VPWR _00398_ sky130_fd_sc_hd__o21a_2
XFILLER_0_39_191 VGND VGND VPWR VPWR sky130_fd_sc_hd__decap_8
X_08180_ _02970_ _02971_ VGND VGND VPWR VPWR _02972_ sky130_fd_sc_hd__nand2_2
X_07131_ _01933_ _01944_ _01945_ VGND VGND VPWR VPWR _01955_ sky130_fd_sc_hd__a21o_2
XFILLER_0_15_515 VGND VGND VPWR VPWR sky130_fd_sc_hd__decap_8
XFILLER_0_42_301 VGND VGND VPWR VPWR sky130_fd_sc_hd__decap_6
XFILLER_0_54_194 VGND VGND VPWR VPWR sky130_fd_sc_hd__fill_2
XFILLER_0_40_96 VGND VGND VPWR VPWR sky130_fd_sc_hd__decap_6
XFILLER_0_112_222 VGND VGND VPWR VPWR sky130_fd_sc_hd__fill_1
X_07062_ tanh_inst.divider.i\[2\] _01035_ _01039_ VGND VGND VPWR VPWR _01893_ sky130_fd_sc_hd__or3_2
XFILLER_0_70_676 VGND VGND VPWR VPWR sky130_fd_sc_hd__decap_8
XFILLER_0_30_529 VGND VGND VPWR VPWR sky130_fd_sc_hd__decap_3
XFILLER_0_42_389 VGND VGND VPWR VPWR sky130_fd_sc_hd__decap_8
XTAP_TAPCELL_ROW_93_1420 VGND VPWR sky130_fd_sc_hd__tapvpwrvgnd_1
X_06013_ mac_inst.i\[23\] mac_inst.i\[24\] _00966_ VGND VGND VPWR VPWR _00967_ sky130_fd_sc_hd__and3_2
XFILLER_0_10_253 VPWR VGND VPWR VGND sky130_ef_sc_hd__decap_12
X_07964_ _02698_ _02709_ _02759_ tanh_inst.z_\[7\] VGND VGND VPWR VPWR _02761_ sky130_fd_sc_hd__o31a_2
XFILLER_0_4_41 VPWR VGND VPWR VGND sky130_ef_sc_hd__decap_12
X_06915_ tanh_inst.div_en tanh_inst.divider.z_\[-3\] VGND VGND VPWR VPWR _00186_ sky130_fd_sc_hd__and2b_2
X_07895_ tanh_inst.divider.x\[-12\] _02691_ VGND VGND VPWR VPWR _02693_ sky130_fd_sc_hd__nor2_2
XFILLER_0_4_85 VPWR VGND VPWR VGND sky130_ef_sc_hd__decap_12
X_09703_ _04426_ _04427_ VGND VGND VPWR VPWR _04428_ sky130_fd_sc_hd__xor2_2
X_06846_ tanh_inst.z_\[0\] _01719_ _01728_ tanh_inst.z_\[1\] VGND VGND VPWR VPWR _01735_
+ sky130_fd_sc_hd__a22o_2
X_09634_ _04301_ _04306_ _04359_ _02019_ VGND VGND VPWR VPWR _04361_ sky130_fd_sc_hd__a31oi_2
X_06777_ tanh_inst.z_\[-6\] _01673_ VGND VGND VPWR VPWR _01674_ sky130_fd_sc_hd__and2_2
X_09565_ _04233_ _04236_ _04293_ VGND VGND VPWR VPWR _04294_ sky130_fd_sc_hd__or3b_2
XFILLER_0_81_70 VGND VGND VPWR VPWR sky130_fd_sc_hd__decap_4
X_09496_ _04125_ _04167_ _04217_ _04224_ VGND VGND VPWR VPWR _04226_ sky130_fd_sc_hd__or4_2
X_05728_ mac_inst.i\[2\] _04932_ VGND VGND VPWR VPWR _00703_ sky130_fd_sc_hd__nand2_2
X_08516_ tanh_inst.divider.y\[0\] tanh_inst.divider.x\[0\] _03251_ VGND VGND VPWR
+ VPWR _03300_ sky130_fd_sc_hd__and3_2
X_08447_ _03220_ _03223_ _03231_ tanh_inst.z_\[7\] VGND VGND VPWR VPWR _03233_ sky130_fd_sc_hd__a31o_2
X_05659_ _00624_ _00641_ _00640_ _00630_ VGND VGND VPWR VPWR _00642_ sky130_fd_sc_hd__o211a_2
XFILLER_0_46_662 VGND VGND VPWR VPWR sky130_fd_sc_hd__decap_4
XFILLER_0_73_470 VPWR VGND VPWR VGND sky130_ef_sc_hd__decap_12
XFILLER_0_61_610 VGND VGND VPWR VPWR sky130_fd_sc_hd__decap_6
X_08378_ tanh_inst.divider.y\[-1\] tanh_inst.divider.x\[-1\] VGND VGND VPWR VPWR _03165_
+ sky130_fd_sc_hd__nor2_2
XFILLER_0_104_723 VGND VGND VPWR VPWR sky130_fd_sc_hd__fill_1
X_07329_ _02022_ _02136_ _02137_ VGND VGND VPWR VPWR _02138_ sky130_fd_sc_hd__o21ai_2
XFILLER_0_33_334 VGND VGND VPWR VPWR sky130_fd_sc_hd__fill_2
X_10340_ clknet_leaf_19_clk _00197_ VGND VGND VPWR VPWR tanh_inst.divider.z_\[-24\]
+ sky130_fd_sc_hd__dfxtp_2
XFILLER_0_61_698 VGND VGND VPWR VPWR sky130_fd_sc_hd__decap_3
XFILLER_0_60_153 VGND VGND VPWR VPWR sky130_fd_sc_hd__fill_2
X_10271_ clknet_leaf_24_clk _00128_ VGND VGND VPWR VPWR tanh_inst.z_\[-24\] sky130_fd_sc_hd__dfxtp_2
XFILLER_0_60_197 VPWR VGND VPWR VGND sky130_ef_sc_hd__decap_12
XFILLER_0_60_175 VGND VGND VPWR VPWR sky130_fd_sc_hd__fill_1
XFILLER_0_96_551 VGND VGND VPWR VPWR sky130_fd_sc_hd__decap_4
XPHY_EDGE_ROW_14_Left_136 VGND VGND VPWR VPWR sky130_fd_sc_hd__decap_3
XFILLER_0_29_629 VGND VGND VPWR VPWR sky130_fd_sc_hd__decap_6
XFILLER_0_83_223 VGND VGND VPWR VPWR sky130_fd_sc_hd__fill_1
XFILLER_0_68_286 VGND VGND VPWR VPWR sky130_fd_sc_hd__decap_4
XFILLER_0_68_275 VGND VGND VPWR VPWR sky130_fd_sc_hd__decap_6
XTAP_TAPCELL_ROW_64_1065 VGND VPWR sky130_fd_sc_hd__tapvpwrvgnd_1
XFILLER_0_28_128 VGND VGND VPWR VPWR sky130_fd_sc_hd__decap_6
XFILLER_0_83_245 VGND VGND VPWR VPWR sky130_fd_sc_hd__fill_2
XTAP_TAPCELL_ROW_12_410 VGND VPWR sky130_fd_sc_hd__tapvpwrvgnd_1
XFILLER_0_37_662 VGND VGND VPWR VPWR sky130_fd_sc_hd__decap_8
XFILLER_0_52_610 VGND VGND VPWR VPWR sky130_fd_sc_hd__decap_8
XFILLER_0_24_301 VGND VGND VPWR VPWR sky130_fd_sc_hd__decap_6
XFILLER_0_36_161 VGND VGND VPWR VPWR sky130_fd_sc_hd__decap_4
XTAP_TAPCELL_ROW_40_763 VGND VPWR sky130_fd_sc_hd__tapvpwrvgnd_1
XTAP_TAPCELL_ROW_116_1707 VGND VPWR sky130_fd_sc_hd__tapvpwrvgnd_1
XFILLER_0_3_217 VGND VGND VPWR VPWR sky130_fd_sc_hd__decap_6
XFILLER_0_24_345 VGND VGND VPWR VPWR sky130_fd_sc_hd__decap_4
XTAP_TAPCELL_ROW_116_1718 VGND VPWR sky130_fd_sc_hd__tapvpwrvgnd_1
XFILLER_0_10_77 VGND VGND VPWR VPWR sky130_fd_sc_hd__decap_6
XPHY_EDGE_ROW_23_Left_145 VGND VGND VPWR VPWR sky130_fd_sc_hd__decap_3
X_10469_ clknet_leaf_2_clk _00326_ VGND VGND VPWR VPWR tanh_inst.divider.y\[5\] sky130_fd_sc_hd__dfxtp_2
XTAP_TAPCELL_ROW_75_1194 VGND VPWR sky130_fd_sc_hd__tapvpwrvgnd_1
X_06700_ _01475_ _01528_ _01570_ VGND VGND VPWR VPWR _01605_ sky130_fd_sc_hd__or3_2
X_07680_ tanh_inst.divider.x\[-18\] _02014_ _02483_ _01470_ VGND VGND VPWR VPWR _00239_
+ sky130_fd_sc_hd__o211a_2
XTAP_TAPCELL_ROW_48_863 VGND VPWR sky130_fd_sc_hd__tapvpwrvgnd_1
X_06631_ tanh_inst.LOOKUP.index\[1\] _01486_ _01518_ _01485_ VGND VGND VPWR VPWR _01543_
+ sky130_fd_sc_hd__o211a_2
XPHY_EDGE_ROW_32_Left_154 VGND VGND VPWR VPWR sky130_fd_sc_hd__decap_3
X_09350_ _02019_ _04075_ _04083_ _04084_ _02015_ VGND VGND VPWR VPWR _04085_ sky130_fd_sc_hd__a221o_2
X_06562_ tanh_inst.LOOKUP.index\[4\] tanh_inst.LOOKUP.index\[3\] VGND VGND VPWR VPWR
+ _01477_ sky130_fd_sc_hd__or2_2
X_09281_ tanh_inst.divider.y\[-15\] _02014_ _04017_ _01470_ VGND VGND VPWR VPWR _00306_
+ sky130_fd_sc_hd__o211a_2
XFILLER_0_74_201 VGND VGND VPWR VPWR sky130_fd_sc_hd__fill_1
X_05513_ _04788_ _04911_ VGND VGND VPWR VPWR _00509_ sky130_fd_sc_hd__nor2_2
X_08301_ _03029_ _03032_ _03089_ VGND VGND VPWR VPWR _03090_ sky130_fd_sc_hd__nor3_2
X_06493_ tanh_inst.divider.y_\[2\] _01412_ VGND VGND VPWR VPWR _01414_ sky130_fd_sc_hd__or2_2
XFILLER_0_7_501 VGND VGND VPWR VPWR sky130_fd_sc_hd__decap_3
X_08232_ tanh_inst.divider.x\[-5\] _03021_ VGND VGND VPWR VPWR _03023_ sky130_fd_sc_hd__nand2_2
XFILLER_0_51_51 VGND VGND VPWR VPWR sky130_fd_sc_hd__decap_4
XFILLER_0_55_470 VPWR VGND VPWR VGND sky130_ef_sc_hd__decap_12
XFILLER_0_27_150 VGND VGND VPWR VPWR sky130_fd_sc_hd__decap_3
X_05444_ mac_inst.y\[9\] _00444_ VGND VGND VPWR VPWR _00446_ sky130_fd_sc_hd__nand2_2
X_05375_ _00380_ _00381_ VGND VGND VPWR VPWR _00382_ sky130_fd_sc_hd__nand2_2
XFILLER_0_43_632 VGND VGND VPWR VPWR sky130_fd_sc_hd__decap_6
XFILLER_0_43_643 VPWR VGND VPWR VGND sky130_ef_sc_hd__decap_12
X_08163_ _04770_ _02954_ VGND VGND VPWR VPWR _02955_ sky130_fd_sc_hd__nor2_2
X_07114_ _01935_ _01938_ VGND VGND VPWR VPWR _01940_ sky130_fd_sc_hd__or2_2
XFILLER_0_70_451 VPWR VGND VPWR VGND sky130_ef_sc_hd__decap_12
X_08094_ tanh_inst.divider.y\[-8\] tanh_inst.divider.x\[-8\] VGND VGND VPWR VPWR _02888_
+ sky130_fd_sc_hd__nand2_2
XPHY_EDGE_ROW_41_Left_163 VGND VGND VPWR VPWR sky130_fd_sc_hd__decap_3
XFILLER_0_42_153 VGND VGND VPWR VPWR sky130_fd_sc_hd__fill_1
XFILLER_0_101_704 VGND VGND VPWR VPWR sky130_fd_sc_hd__decap_3
X_07045_ _01861_ _01869_ _01877_ VGND VGND VPWR VPWR _01878_ sky130_fd_sc_hd__and3_2
XFILLER_0_42_175 VGND VGND VPWR VPWR sky130_fd_sc_hd__fill_1
XFILLER_0_42_197 VGND VGND VPWR VPWR sky130_fd_sc_hd__fill_2
XFILLER_0_100_269 VGND VGND VPWR VPWR sky130_fd_sc_hd__fill_1
X_08996_ _02052_ _03738_ _03731_ VGND VGND VPWR VPWR _03739_ sky130_fd_sc_hd__o21a_2
X_07947_ _02606_ _02650_ _02742_ _02744_ VGND VGND VPWR VPWR _02745_ sky130_fd_sc_hd__a31o_2
X_07878_ _02018_ _02676_ VGND VGND VPWR VPWR _02677_ sky130_fd_sc_hd__nor2_2
XPHY_EDGE_ROW_50_Left_172 VGND VGND VPWR VPWR sky130_fd_sc_hd__decap_3
X_06829_ tanh_inst.z_\[0\] _01719_ VGND VGND VPWR VPWR _01720_ sky130_fd_sc_hd__xnor2_2
X_09617_ _04341_ _04342_ VGND VGND VPWR VPWR _04344_ sky130_fd_sc_hd__or2_2
X_09548_ _04275_ _04276_ VGND VGND VPWR VPWR _04277_ sky130_fd_sc_hd__or2_2
XTAP_TAPCELL_ROW_100_1508 VGND VPWR sky130_fd_sc_hd__tapvpwrvgnd_1
X_09479_ _04208_ _04209_ VGND VGND VPWR VPWR _04210_ sky130_fd_sc_hd__xnor2_2
XFILLER_0_65_289 VGND VGND VPWR VPWR sky130_fd_sc_hd__fill_1
XFILLER_0_19_673 VPWR VGND VPWR VGND sky130_ef_sc_hd__decap_12
X_10323_ clknet_leaf_21_clk _00180_ VGND VGND VPWR VPWR tanh_out[15] sky130_fd_sc_hd__dfxtp_2
XFILLER_0_0_209 VPWR VGND VPWR VGND sky130_ef_sc_hd__decap_12
XFILLER_0_21_337 VGND VGND VPWR VPWR sky130_fd_sc_hd__decap_4
X_10254_ clknet_leaf_32_clk mac_inst.x\[16\] _00000_ VGND VGND VPWR VPWR mac_x_out[16]
+ sky130_fd_sc_hd__dfrtp_2
XTAP_TAPCELL_ROW_111_1648 VGND VPWR sky130_fd_sc_hd__tapvpwrvgnd_1
X_10185_ x_in[11] _00000_ VGND VGND VPWR VPWR mac_inst.x\[11\] sky130_fd_sc_hd__dlxtn_1
XFILLER_0_88_348 VPWR VGND VPWR VGND sky130_ef_sc_hd__decap_12
XFILLER_0_69_573 VPWR VGND VPWR VGND sky130_ef_sc_hd__decap_12
XTAP_TAPCELL_ROW_45_822 VGND VPWR sky130_fd_sc_hd__tapvpwrvgnd_1
XFILLER_0_8_309 VPWR VGND VPWR VGND sky130_ef_sc_hd__decap_12
XFILLER_0_16_109 VPWR VGND VPWR VGND sky130_ef_sc_hd__decap_12
XFILLER_0_71_237 VPWR VGND VPWR VGND sky130_ef_sc_hd__decap_12
XFILLER_0_108_3 VPWR VGND VPWR VGND sky130_ef_sc_hd__decap_12
XFILLER_0_107_391 VGND VGND VPWR VPWR sky130_fd_sc_hd__fill_1
X_05160_ mac_inst.x\[20\] _04852_ _04853_ VGND VGND VPWR VPWR _04864_ sky130_fd_sc_hd__a21o_2
XFILLER_0_52_440 VGND VGND VPWR VPWR sky130_fd_sc_hd__fill_2
XTAP_TAPCELL_ROW_77_1223 VGND VPWR sky130_fd_sc_hd__tapvpwrvgnd_1
XFILLER_0_97_69 VGND VGND VPWR VPWR sky130_fd_sc_hd__decap_6
X_05091_ _04808_ _04811_ VGND VGND VPWR VPWR _00340_ sky130_fd_sc_hd__nor2_2
XFILLER_0_40_668 VPWR VGND VPWR VGND sky130_ef_sc_hd__decap_12
XFILLER_0_110_589 VGND VGND VPWR VPWR sky130_fd_sc_hd__decap_6
X_08850_ tanh_inst.divider.x\[-23\] tanh_inst.divider.x\[-22\] tanh_inst.LOOKUP.index\[0\]
+ VGND VGND VPWR VPWR _03595_ sky130_fd_sc_hd__mux2_1
X_07801_ tanh_inst.LOOKUP.index\[4\] _02600_ _02601_ VGND VGND VPWR VPWR _02602_ sky130_fd_sc_hd__a21bo_2
X_08781_ tanh_inst.divider.x\[-17\] _02028_ _03508_ VGND VGND VPWR VPWR _03527_ sky130_fd_sc_hd__o21ai_2
X_05993_ _00916_ _00929_ _00941_ _00947_ VGND VGND VPWR VPWR _00948_ sky130_fd_sc_hd__a31o_2
X_07732_ _02053_ _02531_ _02532_ _02533_ VGND VGND VPWR VPWR _02534_ sky130_fd_sc_hd__a22o_2
XTAP_TAPCELL_ROW_88_1363 VGND VPWR sky130_fd_sc_hd__tapvpwrvgnd_1
XFILLER_0_79_337 VGND VGND VPWR VPWR sky130_fd_sc_hd__decap_8
X_07663_ _02245_ _02256_ _04759_ VGND VGND VPWR VPWR _02467_ sky130_fd_sc_hd__mux2_1
X_09402_ tanh_inst.divider.x\[-11\] _04134_ VGND VGND VPWR VPWR _04135_ sky130_fd_sc_hd__xor2_2
XFILLER_0_94_307 VGND VGND VPWR VPWR sky130_fd_sc_hd__fill_1
X_06614_ tanh_inst.LOOKUP.index\[3\] tanh_inst.LOOKUP.index\[2\] VGND VGND VPWR VPWR
+ _01527_ sky130_fd_sc_hd__nor2_2
XFILLER_0_48_713 VGND VGND VPWR VPWR sky130_fd_sc_hd__decap_8
X_09333_ tanh_inst.divider.x\[-13\] _04066_ VGND VGND VPWR VPWR _04068_ sky130_fd_sc_hd__and2_2
X_07594_ _02346_ _02348_ _02396_ VGND VGND VPWR VPWR _02399_ sky130_fd_sc_hd__nor3_2
XFILLER_0_87_381 VGND VGND VPWR VPWR sky130_fd_sc_hd__decap_8
XFILLER_0_47_212 VGND VGND VPWR VPWR sky130_fd_sc_hd__decap_4
X_06545_ _01089_ _01459_ _01460_ _01461_ VGND VGND VPWR VPWR _00116_ sky130_fd_sc_hd__o31ai_2
XFILLER_0_117_111 VGND VGND VPWR VPWR sky130_fd_sc_hd__fill_1
X_09264_ _03956_ _03959_ _03999_ VGND VGND VPWR VPWR _04001_ sky130_fd_sc_hd__o21ai_2
X_06476_ _01392_ _01398_ _01089_ VGND VGND VPWR VPWR _01399_ sky130_fd_sc_hd__a21oi_2
XFILLER_0_90_524 VGND VGND VPWR VPWR sky130_fd_sc_hd__fill_1
XTAP_TAPCELL_ROW_23_549 VGND VPWR sky130_fd_sc_hd__tapvpwrvgnd_1
XFILLER_0_47_278 VGND VGND VPWR VPWR sky130_fd_sc_hd__fill_2
XFILLER_0_118_678 VGND VGND VPWR VPWR sky130_fd_sc_hd__fill_2
X_09195_ _03930_ _03933_ VGND VGND VPWR VPWR _03934_ sky130_fd_sc_hd__nand2_2
XFILLER_0_62_226 VGND VGND VPWR VPWR sky130_fd_sc_hd__decap_4
X_05427_ mac_inst.i\[3\] _04882_ _00412_ VGND VGND VPWR VPWR _00430_ sky130_fd_sc_hd__o21ai_2
X_08215_ _02978_ _02982_ _02977_ VGND VGND VPWR VPWR _03006_ sky130_fd_sc_hd__a21bo_2
XFILLER_0_117_199 VGND VGND VPWR VPWR sky130_fd_sc_hd__fill_1
XFILLER_0_105_328 VGND VGND VPWR VPWR sky130_fd_sc_hd__fill_2
X_08146_ _02869_ _02871_ _02937_ VGND VGND VPWR VPWR _02939_ sky130_fd_sc_hd__o21a_2
XFILLER_0_120_309 VGND VGND VPWR VPWR sky130_fd_sc_hd__fill_1
XFILLER_0_16_687 VGND VGND VPWR VPWR sky130_fd_sc_hd__fill_1
XFILLER_0_43_473 VGND VGND VPWR VPWR sky130_fd_sc_hd__decap_8
X_05358_ mac_inst.y\[3\] _00365_ VGND VGND VPWR VPWR _00366_ sky130_fd_sc_hd__and2_2
X_08077_ tanh_inst.divider.y\[-8\] _02870_ VGND VGND VPWR VPWR _02871_ sky130_fd_sc_hd__nor2_2
X_05289_ _04869_ _04871_ _04872_ _04876_ mac_inst.i\[1\] mac_inst.i\[0\] VGND VGND
+ VPWR VPWR _04989_ sky130_fd_sc_hd__mux4_2
XFILLER_0_31_657 VGND VGND VPWR VPWR sky130_fd_sc_hd__fill_1
X_07028_ _04777_ _01035_ _01039_ VGND VGND VPWR VPWR _01863_ sky130_fd_sc_hd__or3_2
X_08979_ _01469_ _03722_ VGND VGND VPWR VPWR _00299_ sky130_fd_sc_hd__nor2_2
XTAP_TAPCELL_ROW_3_296 VGND VPWR sky130_fd_sc_hd__tapvpwrvgnd_1
XFILLER_0_85_318 VGND VGND VPWR VPWR sky130_fd_sc_hd__fill_1
XFILLER_0_38_212 VGND VGND VPWR VPWR sky130_fd_sc_hd__fill_1
XFILLER_0_66_587 VGND VGND VPWR VPWR sky130_fd_sc_hd__fill_1
XTAP_TAPCELL_ROW_61_1024 VGND VPWR sky130_fd_sc_hd__tapvpwrvgnd_1
XFILLER_0_38_278 VGND VGND VPWR VPWR sky130_fd_sc_hd__decap_4
XFILLER_0_109_678 VGND VGND VPWR VPWR sky130_fd_sc_hd__fill_2
XFILLER_0_81_535 VGND VGND VPWR VPWR sky130_fd_sc_hd__decap_3
XTAP_TAPCELL_ROW_50_891 VGND VPWR sky130_fd_sc_hd__tapvpwrvgnd_1
XFILLER_0_22_679 VGND VGND VPWR VPWR sky130_fd_sc_hd__decap_6
X_10306_ clknet_leaf_14_clk _00163_ VGND VGND VPWR VPWR tanh_inst.divider.i\[3\] sky130_fd_sc_hd__dfxtp_2
XFILLER_0_21_167 VGND VGND VPWR VPWR sky130_fd_sc_hd__fill_1
X_10237_ clknet_leaf_23_clk mac_inst.y\[31\] _00000_ VGND VGND VPWR VPWR mac_y_out[31]
+ sky130_fd_sc_hd__dfrtp_2
XTAP_TAPCELL_ROW_72_1164 VGND VPWR sky130_fd_sc_hd__tapvpwrvgnd_1
X_10099_ clknet_leaf_10_clk _00116_ VGND VGND VPWR VPWR tanh_inst.divider.y_\[6\]
+ sky130_fd_sc_hd__dfxtp_2
XFILLER_0_83_27 VPWR VGND VPWR VGND sky130_ef_sc_hd__decap_12
XTAP_TAPCELL_ROW_58_991 VGND VPWR sky130_fd_sc_hd__tapvpwrvgnd_1
XFILLER_0_16_65 VPWR VGND VPWR VGND sky130_ef_sc_hd__decap_12
XFILLER_0_57_532 VPWR VGND VPWR VGND sky130_ef_sc_hd__decap_12
X_06330_ tanh_inst.divider.i\[3\] _01158_ _01187_ VGND VGND VPWR VPWR _01264_ sky130_fd_sc_hd__o21a_2
XFILLER_0_8_139 VGND VGND VPWR VPWR sky130_fd_sc_hd__fill_1
XFILLER_0_29_278 VGND VGND VPWR VPWR sky130_fd_sc_hd__fill_2
X_06261_ _01167_ _01182_ _01184_ _01181_ tanh_inst.divider.y_\[-18\] VGND VGND VPWR
+ VPWR _01201_ sky130_fd_sc_hd__a32o_2
XTAP_TAPCELL_ROW_20_508 VGND VPWR sky130_fd_sc_hd__tapvpwrvgnd_1
X_08000_ _02701_ _02759_ VGND VGND VPWR VPWR _02796_ sky130_fd_sc_hd__nand2_2
XFILLER_0_72_579 VGND VGND VPWR VPWR sky130_fd_sc_hd__fill_2
XFILLER_0_4_301 VGND VGND VPWR VPWR sky130_fd_sc_hd__decap_6
X_05212_ mac_inst.x\[5\] _04852_ _04853_ _04783_ VGND VGND VPWR VPWR _04916_ sky130_fd_sc_hd__a211o_2
XFILLER_0_44_259 VGND VGND VPWR VPWR sky130_fd_sc_hd__fill_2
X_06192_ _01134_ _01135_ VGND VGND VPWR VPWR _01136_ sky130_fd_sc_hd__xor2_2
XFILLER_0_102_309 VPWR VGND VPWR VGND sky130_ef_sc_hd__decap_12
XFILLER_0_4_345 VPWR VGND VPWR VGND sky130_ef_sc_hd__decap_12
XFILLER_0_40_421 VPWR VGND VPWR VGND sky130_ef_sc_hd__decap_12
X_05143_ mac_inst.i\[21\] mac_inst.i\[20\] mac_inst.i\[23\] mac_inst.i\[22\] VGND
+ VGND VPWR VPWR _04847_ sky130_fd_sc_hd__or4_2
X_05074_ mac_inst.z\[6\] VGND VGND VPWR VPWR _04798_ sky130_fd_sc_hd__inv_2
X_09951_ _04541_ _04549_ _04665_ _04666_ _04668_ VGND VGND VPWR VPWR _04669_ sky130_fd_sc_hd__o311ai_2
X_08902_ tanh_inst.divider.x\[-8\] tanh_inst.divider.x\[-7\] tanh_inst.divider.x\[-6\]
+ tanh_inst.divider.x\[-5\] tanh_inst.LOOKUP.index\[0\] tanh_inst.LOOKUP.index\[1\]
+ VGND VGND VPWR VPWR _03647_ sky130_fd_sc_hd__mux4_2
XFILLER_0_12_189 VGND VGND VPWR VPWR sky130_fd_sc_hd__decap_6
X_09882_ _04525_ _04560_ VGND VGND VPWR VPWR _04602_ sky130_fd_sc_hd__nand2_2
X_08833_ tanh_inst.LOOKUP.index\[2\] _01476_ _03578_ VGND VGND VPWR VPWR _03579_ sky130_fd_sc_hd__and3_2
X_08764_ tanh_inst.divider.x\[-11\] _02028_ _03508_ VGND VGND VPWR VPWR _03510_ sky130_fd_sc_hd__o21a_2
X_05976_ _00900_ _00912_ _00920_ VGND VGND VPWR VPWR _00932_ sky130_fd_sc_hd__and3_2
XFILLER_0_32_3 VPWR VGND VPWR VGND sky130_ef_sc_hd__decap_12
X_07715_ _02515_ _02517_ VGND VGND VPWR VPWR _02518_ sky130_fd_sc_hd__xnor2_2
XTAP_TAPCELL_ROW_28_608 VGND VPWR sky130_fd_sc_hd__tapvpwrvgnd_1
X_08695_ _03469_ _03471_ _03473_ VGND VGND VPWR VPWR _03474_ sky130_fd_sc_hd__o21a_2
XFILLER_0_73_82 VGND VGND VPWR VPWR sky130_fd_sc_hd__decap_3
XTAP_TAPCELL_ROW_0_244 VGND VPWR sky130_fd_sc_hd__tapvpwrvgnd_1
X_07646_ _02351_ _02398_ _02399_ VGND VGND VPWR VPWR _02450_ sky130_fd_sc_hd__a21oi_2
XTAP_TAPCELL_ROW_0_255 VGND VPWR sky130_fd_sc_hd__tapvpwrvgnd_1
XTAP_TAPCELL_ROW_0_266 VGND VPWR sky130_fd_sc_hd__tapvpwrvgnd_1
X_07577_ _02018_ _02382_ _02365_ _02354_ VGND VGND VPWR VPWR _02383_ sky130_fd_sc_hd__o2bb2a_2
XFILLER_0_48_554 VGND VGND VPWR VPWR sky130_fd_sc_hd__decap_3
X_06528_ _01445_ VGND VGND VPWR VPWR _01446_ sky130_fd_sc_hd__inv_2
X_09316_ _04050_ _04051_ VGND VGND VPWR VPWR _04052_ sky130_fd_sc_hd__nand2_2
XFILLER_0_118_475 VGND VGND VPWR VPWR sky130_fd_sc_hd__fill_1
XFILLER_0_106_615 VGND VGND VPWR VPWR sky130_fd_sc_hd__decap_3
X_09247_ _03976_ _03984_ VGND VGND VPWR VPWR _03985_ sky130_fd_sc_hd__or2_2
XFILLER_0_35_237 VGND VGND VPWR VPWR sky130_fd_sc_hd__decap_4
XFILLER_0_118_497 VGND VGND VPWR VPWR sky130_fd_sc_hd__decap_4
X_06459_ _01370_ _01375_ _01381_ VGND VGND VPWR VPWR _01383_ sky130_fd_sc_hd__or3_2
XFILLER_0_90_365 VGND VGND VPWR VPWR sky130_fd_sc_hd__decap_6
XFILLER_0_7_161 VGND VGND VPWR VPWR sky130_fd_sc_hd__decap_6
XFILLER_0_16_440 VGND VGND VPWR VPWR sky130_fd_sc_hd__fill_1
X_09178_ _03732_ _03734_ _02025_ VGND VGND VPWR VPWR _03917_ sky130_fd_sc_hd__mux2_1
XFILLER_0_50_229 VGND VGND VPWR VPWR sky130_fd_sc_hd__fill_2
X_08129_ _02018_ _02919_ _02920_ VGND VGND VPWR VPWR _02923_ sky130_fd_sc_hd__and3_2
XFILLER_0_31_432 VGND VGND VPWR VPWR sky130_fd_sc_hd__decap_6
XFILLER_0_43_281 VPWR VGND VPWR VGND sky130_ef_sc_hd__decap_12
XFILLER_0_120_139 VGND VGND VPWR VPWR sky130_fd_sc_hd__fill_1
XTAP_TAPCELL_ROW_8_366 VGND VPWR sky130_fd_sc_hd__tapvpwrvgnd_1
X_10022_ tanh_inst.divider.y\[6\] _04713_ _04720_ VGND VGND VPWR VPWR _04737_ sky130_fd_sc_hd__a21oi_2
XFILLER_0_98_421 VPWR VGND VPWR VGND sky130_ef_sc_hd__decap_12
XPHY_EDGE_ROW_113_Right_113 VGND VGND VPWR VPWR sky130_fd_sc_hd__decap_3
XFILLER_0_86_649 VGND VGND VPWR VPWR sky130_fd_sc_hd__fill_1
XTAP_TAPCELL_ROW_55_950 VGND VPWR sky130_fd_sc_hd__tapvpwrvgnd_1
XFILLER_0_85_148 VPWR VGND VPWR VGND sky130_ef_sc_hd__decap_12
XFILLER_0_93_192 VGND VGND VPWR VPWR sky130_fd_sc_hd__decap_6
XFILLER_0_105_681 VGND VGND VPWR VPWR sky130_fd_sc_hd__decap_4
XFILLER_0_1_337 VPWR VGND VPWR VGND sky130_ef_sc_hd__decap_12
XFILLER_0_94_15 VPWR VGND VPWR VGND sky130_ef_sc_hd__decap_12
X_05830_ _04943_ _00796_ VGND VGND VPWR VPWR _00797_ sky130_fd_sc_hd__nand2_2
XFILLER_0_118_77 VGND VGND VPWR VPWR sky130_fd_sc_hd__decap_6
XPHY_EDGE_ROW_6_Left_128 VGND VGND VPWR VPWR sky130_fd_sc_hd__decap_3
X_07500_ _02239_ _02241_ _02306_ VGND VGND VPWR VPWR _02307_ sky130_fd_sc_hd__nor3_2
XTAP_TAPCELL_ROW_85_1322 VGND VPWR sky130_fd_sc_hd__tapvpwrvgnd_1
X_05761_ mac_inst.z\[31\] _00733_ _00729_ VGND VGND VPWR VPWR _00734_ sky130_fd_sc_hd__o21ai_2
XFILLER_0_76_115 VPWR VGND VPWR VGND sky130_ef_sc_hd__decap_12
X_05692_ mac_inst.z\[31\] _00667_ VGND VGND VPWR VPWR _00670_ sky130_fd_sc_hd__nand2_2
XFILLER_0_49_329 VGND VGND VPWR VPWR sky130_fd_sc_hd__decap_6
X_08480_ tanh_inst.divider.y\[1\] _03263_ VGND VGND VPWR VPWR _03265_ sky130_fd_sc_hd__and2_2
X_07431_ _02223_ _02237_ VGND VGND VPWR VPWR _02239_ sky130_fd_sc_hd__and2_2
X_07362_ _02139_ _02155_ _02168_ VGND VGND VPWR VPWR _02171_ sky130_fd_sc_hd__a21oi_2
XFILLER_0_57_373 VGND VGND VPWR VPWR sky130_fd_sc_hd__decap_4
XFILLER_0_45_502 VGND VGND VPWR VPWR sky130_fd_sc_hd__fill_2
X_06313_ _01031_ _01143_ VGND VGND VPWR VPWR _01248_ sky130_fd_sc_hd__or2_2
X_09101_ tanh_inst.divider.x\[-19\] _03841_ VGND VGND VPWR VPWR _03842_ sky130_fd_sc_hd__xor2_2
XFILLER_0_17_237 VPWR VGND VPWR VGND sky130_ef_sc_hd__decap_12
XTAP_TAPCELL_ROW_33_677 VGND VPWR sky130_fd_sc_hd__tapvpwrvgnd_1
X_07293_ _02101_ _02102_ VGND VGND VPWR VPWR _02103_ sky130_fd_sc_hd__nand2_2
XFILLER_0_72_365 VPWR VGND VPWR VGND sky130_ef_sc_hd__decap_12
XFILLER_0_45_557 VGND VGND VPWR VPWR sky130_fd_sc_hd__decap_3
X_06244_ _01168_ _01183_ _01182_ VGND VGND VPWR VPWR _01185_ sky130_fd_sc_hd__o21ai_2
XFILLER_0_103_607 VGND VGND VPWR VPWR sky130_fd_sc_hd__fill_1
X_09032_ tanh_inst.divider.y\[-21\] _03773_ VGND VGND VPWR VPWR _03775_ sky130_fd_sc_hd__xnor2_2
X_06175_ tanh_inst.divider.x\[3\] tanh_inst.divider.x\[4\] tanh_inst.divider.x\[5\]
+ tanh_inst.divider.x\[6\] tanh_inst.divider.i\[0\] tanh_inst.divider.i\[1\] VGND
+ VGND VPWR VPWR _01119_ sky130_fd_sc_hd__mux4_2
XTAP_TAPCELL_ROW_96_1462 VGND VPWR sky130_fd_sc_hd__tapvpwrvgnd_1
XFILLER_0_60_549 VPWR VGND VPWR VGND sky130_ef_sc_hd__decap_12
XFILLER_0_4_153 VPWR VGND VPWR VGND sky130_ef_sc_hd__decap_12
XFILLER_0_25_281 VPWR VGND VPWR VGND sky130_ef_sc_hd__decap_12
X_05126_ mac_counter\[1\] _04832_ VGND VGND VPWR VPWR _04833_ sky130_fd_sc_hd__and2_2
XFILLER_0_4_197 VPWR VGND VPWR VGND sky130_ef_sc_hd__decap_12
X_09934_ _04650_ _04651_ VGND VGND VPWR VPWR _04652_ sky130_fd_sc_hd__or2_2
X_05057_ mac_inst.i\[3\] VGND VGND VPWR VPWR _04781_ sky130_fd_sc_hd__inv_2
X_09865_ _02052_ _04018_ _04193_ VGND VGND VPWR VPWR _04585_ sky130_fd_sc_hd__a21boi_2
XTAP_TAPCELL_ROW_5_325 VGND VPWR sky130_fd_sc_hd__tapvpwrvgnd_1
X_08816_ tanh_inst.divider.x\[-6\] _02028_ _03508_ VGND VGND VPWR VPWR _03562_ sky130_fd_sc_hd__o21a_2
XFILLER_0_84_70 VPWR VGND VPWR VGND sky130_ef_sc_hd__decap_12
X_09796_ tanh_inst.divider.y\[0\] _04516_ VGND VGND VPWR VPWR _04518_ sky130_fd_sc_hd__nor2_2
X_05959_ mac_inst.z\[31\] _00911_ _00913_ _04802_ VGND VGND VPWR VPWR _00917_ sky130_fd_sc_hd__a211oi_2
X_08747_ mac_inst.i\[22\] _00965_ VGND VGND VPWR VPWR _00287_ sky130_fd_sc_hd__xor2_2
X_08678_ tanh_inst.divider.y\[6\] _03456_ VGND VGND VPWR VPWR _03458_ sky130_fd_sc_hd__and2_2
XFILLER_0_95_435 VPWR VGND VPWR VGND sky130_ef_sc_hd__decap_12
X_07629_ _02204_ _02220_ _02024_ VGND VGND VPWR VPWR _02433_ sky130_fd_sc_hd__mux2_1
XTAP_TAPCELL_ROW_105_1580 VGND VPWR sky130_fd_sc_hd__tapvpwrvgnd_1
XFILLER_0_48_362 VGND VGND VPWR VPWR sky130_fd_sc_hd__fill_2
XFILLER_0_63_310 VGND VGND VPWR VPWR sky130_fd_sc_hd__fill_1
XFILLER_0_118_261 VGND VGND VPWR VPWR sky130_fd_sc_hd__fill_2
XFILLER_0_106_401 VPWR VGND VPWR VGND sky130_ef_sc_hd__decap_12
XFILLER_0_51_505 VPWR VGND VPWR VGND sky130_ef_sc_hd__decap_12
XFILLER_0_90_162 VGND VGND VPWR VPWR sky130_fd_sc_hd__decap_8
XFILLER_0_63_387 VGND VGND VPWR VPWR sky130_fd_sc_hd__decap_4
XFILLER_0_101_161 VGND VGND VPWR VPWR sky130_fd_sc_hd__decap_6
X_10005_ tanh_inst.divider.x\[6\] _04719_ VGND VGND VPWR VPWR _04721_ sky130_fd_sc_hd__and2_2
XTAP_TAPCELL_ROW_108_1609 VGND VPWR sky130_fd_sc_hd__tapvpwrvgnd_1
XFILLER_0_64_29 VPWR VGND VPWR VGND sky130_ef_sc_hd__decap_12
XFILLER_0_98_251 VGND VGND VPWR VPWR sky130_fd_sc_hd__fill_1
XFILLER_0_59_627 VPWR VGND VPWR VGND sky130_ef_sc_hd__decap_12
XFILLER_0_67_671 VGND VGND VPWR VPWR sky130_fd_sc_hd__fill_1
XTAP_TAPCELL_ROW_67_1096 VGND VPWR sky130_fd_sc_hd__tapvpwrvgnd_1
XFILLER_0_82_630 VGND VGND VPWR VPWR sky130_fd_sc_hd__decap_3
XTAP_TAPCELL_ROW_80_1263 VGND VPWR sky130_fd_sc_hd__tapvpwrvgnd_1
XFILLER_0_13_55 VGND VGND VPWR VPWR sky130_fd_sc_hd__fill_1
XFILLER_0_27_513 VPWR VGND VPWR VGND sky130_ef_sc_hd__decap_12
XFILLER_0_89_15 VPWR VGND VPWR VGND sky130_ef_sc_hd__decap_12
XFILLER_0_27_568 VPWR VGND VPWR VGND sky130_ef_sc_hd__decap_12
XTAP_TAPCELL_ROW_30_636 VGND VPWR sky130_fd_sc_hd__tapvpwrvgnd_1
XTAP_TAPCELL_ROW_119_1749 VGND VPWR sky130_fd_sc_hd__tapvpwrvgnd_1
XFILLER_0_54_365 VPWR VGND VPWR VGND sky130_ef_sc_hd__decap_12
XFILLER_0_35_590 VGND VGND VPWR VPWR sky130_fd_sc_hd__fill_1
XTAP_TAPCELL_ROW_10_393 VGND VPWR sky130_fd_sc_hd__tapvpwrvgnd_1
XTAP_TAPCELL_ROW_10_382 VGND VPWR sky130_fd_sc_hd__tapvpwrvgnd_1
XFILLER_0_22_251 VGND VGND VPWR VPWR sky130_fd_sc_hd__fill_1
XFILLER_0_1_167 VGND VGND VPWR VPWR sky130_fd_sc_hd__fill_1
X_07980_ _02775_ _02776_ VGND VGND VPWR VPWR _02777_ sky130_fd_sc_hd__xnor2_2
XFILLER_0_10_468 VGND VGND VPWR VPWR sky130_fd_sc_hd__fill_2
X_06931_ tanh_inst.divider.i\[3\] tanh_inst.divider.i\[4\] VGND VGND VPWR VPWR _01776_
+ sky130_fd_sc_hd__nand2b_2
XFILLER_0_38_41 VGND VGND VPWR VPWR sky130_fd_sc_hd__fill_2
X_09650_ _04369_ _04375_ VGND VGND VPWR VPWR _04376_ sky130_fd_sc_hd__nand2_2
X_06862_ _01726_ _01729_ _01746_ _01748_ VGND VGND VPWR VPWR _01749_ sky130_fd_sc_hd__o31ai_2
X_08601_ _03338_ _03339_ _03340_ VGND VGND VPWR VPWR _03383_ sky130_fd_sc_hd__o21a_2
X_06793_ tanh_inst.z_\[7\] _01667_ _01687_ VGND VGND VPWR VPWR _01688_ sky130_fd_sc_hd__mux2_1
X_05813_ _00754_ _00766_ _00768_ VGND VGND VPWR VPWR _00782_ sky130_fd_sc_hd__o21a_2
XTAP_TAPCELL_ROW_38_736 VGND VPWR sky130_fd_sc_hd__tapvpwrvgnd_1
X_09581_ _02976_ _04308_ VGND VGND VPWR VPWR _04309_ sky130_fd_sc_hd__nand2_2
X_05744_ mac_inst.i\[2\] _04944_ _00665_ _00717_ VGND VGND VPWR VPWR _00718_ sky130_fd_sc_hd__or4_2
X_08532_ _03312_ _03313_ _03315_ VGND VGND VPWR VPWR _03316_ sky130_fd_sc_hd__or3_2
XFILLER_0_77_446 VGND VGND VPWR VPWR sky130_fd_sc_hd__fill_2
X_08463_ _02018_ _03248_ _02015_ VGND VGND VPWR VPWR _03249_ sky130_fd_sc_hd__a21oi_2
XFILLER_0_92_416 VGND VGND VPWR VPWR sky130_fd_sc_hd__decap_4
XFILLER_0_77_468 VGND VGND VPWR VPWR sky130_fd_sc_hd__fill_1
X_07414_ _02022_ _02221_ VGND VGND VPWR VPWR _02222_ sky130_fd_sc_hd__or2_2
XFILLER_0_65_608 VGND VGND VPWR VPWR sky130_fd_sc_hd__fill_1
XFILLER_0_9_223 VGND VGND VPWR VPWR sky130_fd_sc_hd__fill_1
XTAP_TAPCELL_ROW_18_482 VGND VPWR sky130_fd_sc_hd__tapvpwrvgnd_1
XTAP_TAPCELL_ROW_18_493 VGND VPWR sky130_fd_sc_hd__tapvpwrvgnd_1
X_05675_ _00639_ _00643_ _00647_ _00637_ VGND VGND VPWR VPWR _00656_ sky130_fd_sc_hd__o211ai_2
XFILLER_0_92_427 VGND VGND VPWR VPWR sky130_fd_sc_hd__fill_1
XFILLER_0_57_181 VPWR VGND VPWR VGND sky130_ef_sc_hd__decap_12
X_08394_ _03179_ _03180_ VGND VGND VPWR VPWR _03181_ sky130_fd_sc_hd__nor2_2
X_07345_ _02025_ _02153_ _02149_ _02022_ VGND VGND VPWR VPWR _02154_ sky130_fd_sc_hd__a211o_2
X_07276_ tanh_inst.divider.y\[-4\] _02028_ _02029_ VGND VGND VPWR VPWR _02086_ sky130_fd_sc_hd__o21ai_2
Xclkbuf_leaf_30_clk clknet_2_1__leaf_clk VGND VGND VPWR VPWR clknet_leaf_30_clk sky130_fd_sc_hd__clkbuf_8
X_06227_ _01166_ _01168_ VGND VGND VPWR VPWR _01169_ sky130_fd_sc_hd__nor2_2
X_09015_ tanh_inst.divider.x\[-1\] tanh_inst.divider.x\[0\] tanh_inst.divider.x\[1\]
+ tanh_inst.divider.x\[2\] tanh_inst.LOOKUP.index\[0\] tanh_inst.LOOKUP.index\[1\]
+ VGND VGND VPWR VPWR _03758_ sky130_fd_sc_hd__mux4_2
XFILLER_0_103_437 VGND VGND VPWR VPWR sky130_fd_sc_hd__decap_8
XFILLER_0_5_495 VGND VGND VPWR VPWR sky130_fd_sc_hd__fill_2
X_06158_ tanh_inst.divider.x\[-14\] tanh_inst.divider.x\[-13\] tanh_inst.divider.x\[-12\]
+ tanh_inst.divider.x\[-11\] tanh_inst.divider.i\[0\] tanh_inst.divider.i\[1\] VGND
+ VGND VPWR VPWR _01103_ sky130_fd_sc_hd__mux4_2
XFILLER_0_13_273 VGND VGND VPWR VPWR sky130_fd_sc_hd__decap_6
XFILLER_0_41_571 VGND VGND VPWR VPWR sky130_fd_sc_hd__decap_4
X_06089_ _04775_ _01034_ _01035_ _04774_ _04777_ VGND VGND VPWR VPWR _01036_ sky130_fd_sc_hd__o221a_2
X_05109_ mac_complete _04821_ _00000_ VGND VGND VPWR VPWR _00126_ sky130_fd_sc_hd__o21a_2
X_09917_ _04578_ _04582_ _04576_ VGND VGND VPWR VPWR _04636_ sky130_fd_sc_hd__o21ai_2
X_09848_ tanh_inst.divider.y\[1\] _04568_ VGND VGND VPWR VPWR _04569_ sky130_fd_sc_hd__xnor2_2
X_09779_ _04764_ _02015_ _04501_ _01469_ VGND VGND VPWR VPWR _00320_ sky130_fd_sc_hd__a211oi_2
XFILLER_0_83_405 VGND VGND VPWR VPWR sky130_fd_sc_hd__fill_1
XFILLER_0_68_468 VGND VGND VPWR VPWR sky130_fd_sc_hd__fill_1
XFILLER_0_36_321 VPWR VGND VPWR VGND sky130_ef_sc_hd__decap_12
Xclkbuf_leaf_21_clk clknet_2_3__leaf_clk VGND VGND VPWR VPWR clknet_leaf_21_clk sky130_fd_sc_hd__clkbuf_8
XFILLER_0_24_505 VPWR VGND VPWR VGND sky130_ef_sc_hd__decap_12
XFILLER_0_106_253 VGND VGND VPWR VPWR sky130_fd_sc_hd__fill_2
XFILLER_0_51_346 VPWR VGND VPWR VGND sky130_ef_sc_hd__decap_12
XFILLER_0_106_286 VGND VGND VPWR VPWR sky130_fd_sc_hd__decap_8
XFILLER_0_32_571 VGND VGND VPWR VPWR sky130_fd_sc_hd__decap_8
XPHY_EDGE_ROW_87_Left_209 VGND VGND VPWR VPWR sky130_fd_sc_hd__decap_3
XTAP_TAPCELL_ROW_69_1125 VGND VPWR sky130_fd_sc_hd__tapvpwrvgnd_1
XFILLER_0_99_571 VPWR VGND VPWR VGND sky130_ef_sc_hd__decap_12
XFILLER_0_91_27 VPWR VGND VPWR VGND sky130_ef_sc_hd__decap_12
XPHY_EDGE_ROW_96_Left_218 VGND VGND VPWR VPWR sky130_fd_sc_hd__decap_3
XFILLER_0_74_416 VGND VGND VPWR VPWR sky130_fd_sc_hd__decap_4
XFILLER_0_24_65 VPWR VGND VPWR VGND sky130_ef_sc_hd__decap_12
XFILLER_0_74_438 VGND VGND VPWR VPWR sky130_fd_sc_hd__decap_6
XTAP_TAPCELL_ROW_15_452 VGND VPWR sky130_fd_sc_hd__tapvpwrvgnd_1
X_05460_ _00424_ _00436_ _00437_ _00447_ _00460_ VGND VGND VPWR VPWR _00461_ sky130_fd_sc_hd__o41a_2
X_05391_ _00395_ _00396_ VGND VGND VPWR VPWR _00397_ sky130_fd_sc_hd__and2b_2
XTAP_TAPCELL_ROW_43_794 VGND VPWR sky130_fd_sc_hd__tapvpwrvgnd_1
Xclkbuf_leaf_12_clk clknet_2_3__leaf_clk VGND VGND VPWR VPWR clknet_leaf_12_clk sky130_fd_sc_hd__clkbuf_8
X_07130_ _01938_ _01953_ VGND VGND VPWR VPWR _01954_ sky130_fd_sc_hd__or2_2
XFILLER_0_15_505 VGND VGND VPWR VPWR sky130_fd_sc_hd__decap_3
XFILLER_0_27_365 VGND VGND VPWR VPWR sky130_fd_sc_hd__decap_4
XFILLER_0_70_633 VGND VGND VPWR VPWR sky130_fd_sc_hd__fill_1
X_07061_ _01088_ _01891_ _01892_ _01092_ tanh_inst.divider.z_\[-10\] VGND VGND VPWR
+ VPWR _00211_ sky130_fd_sc_hd__a32o_2
XTAP_TAPCELL_ROW_93_1421 VGND VPWR sky130_fd_sc_hd__tapvpwrvgnd_1
X_06012_ mac_inst.i\[22\] _00965_ VGND VGND VPWR VPWR _00966_ sky130_fd_sc_hd__and2_2
XFILLER_0_10_221 VPWR VGND VPWR VGND sky130_ef_sc_hd__decap_12
XFILLER_0_10_265 VPWR VGND VPWR VGND sky130_ef_sc_hd__decap_12
X_07963_ _02698_ _02709_ _02759_ VGND VGND VPWR VPWR _02760_ sky130_fd_sc_hd__o21ai_2
X_06914_ tanh_inst.div_en tanh_inst.divider.z_\[-4\] VGND VGND VPWR VPWR _00185_ sky130_fd_sc_hd__and2b_2
X_07894_ tanh_inst.divider.x\[-12\] _02691_ VGND VGND VPWR VPWR _02692_ sky130_fd_sc_hd__and2_2
XFILLER_0_4_53 VPWR VGND VPWR VGND sky130_ef_sc_hd__decap_12
X_09702_ _04363_ _04364_ _04791_ VGND VGND VPWR VPWR _04427_ sky130_fd_sc_hd__o21a_2
X_06845_ _01732_ _01733_ VGND VGND VPWR VPWR _01734_ sky130_fd_sc_hd__or2_2
XFILLER_0_4_97 VPWR VGND VPWR VGND sky130_ef_sc_hd__decap_12
X_09633_ _04301_ _04306_ _04359_ VGND VGND VPWR VPWR _04360_ sky130_fd_sc_hd__a21o_2
X_09564_ _04291_ _04292_ VGND VGND VPWR VPWR _04293_ sky130_fd_sc_hd__nand2_2
X_06776_ tanh_inst.z_\[7\] _01667_ _01672_ VGND VGND VPWR VPWR _01673_ sky130_fd_sc_hd__mux2_1
X_08515_ _03297_ _03298_ VGND VGND VPWR VPWR _03299_ sky130_fd_sc_hd__nor2_2
X_09495_ _04167_ _04217_ _04224_ VGND VGND VPWR VPWR _04225_ sky130_fd_sc_hd__or3_2
XFILLER_0_65_405 VPWR VGND VPWR VGND sky130_ef_sc_hd__decap_12
X_05727_ _00701_ _00702_ VGND VGND VPWR VPWR _05727_/X sky130_fd_sc_hd__and2_2
XFILLER_0_38_619 VGND VGND VPWR VPWR sky130_fd_sc_hd__fill_2
XFILLER_0_65_449 VGND VGND VPWR VPWR sky130_fd_sc_hd__decap_8
XFILLER_0_37_118 VGND VGND VPWR VPWR sky130_fd_sc_hd__fill_1
X_08446_ _03220_ _03223_ _03231_ VGND VGND VPWR VPWR _03232_ sky130_fd_sc_hd__a21oi_2
X_05658_ _00620_ _00621_ _00631_ VGND VGND VPWR VPWR _00641_ sky130_fd_sc_hd__or3_2
XFILLER_0_108_529 VGND VGND VPWR VPWR sky130_fd_sc_hd__decap_3
XFILLER_0_18_321 VPWR VGND VPWR VGND sky130_ef_sc_hd__decap_12
X_08377_ tanh_inst.divider.y\[-1\] tanh_inst.divider.x\[-1\] VGND VGND VPWR VPWR _03164_
+ sky130_fd_sc_hd__nand2_2
X_07328_ _02025_ _02132_ _02131_ _02023_ VGND VGND VPWR VPWR _02137_ sky130_fd_sc_hd__a211o_2
XFILLER_0_80_419 VGND VGND VPWR VPWR sky130_fd_sc_hd__fill_1
X_05589_ _00575_ _00577_ VGND VGND VPWR VPWR _00578_ sky130_fd_sc_hd__xnor2_2
XFILLER_0_73_482 VGND VGND VPWR VPWR sky130_fd_sc_hd__decap_4
XFILLER_0_60_121 VGND VGND VPWR VPWR sky130_fd_sc_hd__fill_2
X_07259_ tanh_inst.divider.y\[7\] _02068_ _04761_ VGND VGND VPWR VPWR _02069_ sky130_fd_sc_hd__mux2_1
XFILLER_0_5_281 VPWR VGND VPWR VGND sky130_ef_sc_hd__decap_12
X_10270_ clknet_leaf_33_clk _00127_ _00077_ VGND VGND VPWR VPWR current_state\[1\]
+ sky130_fd_sc_hd__dfrtp_2
XTAP_TAPCELL_ROW_64_1066 VGND VPWR sky130_fd_sc_hd__tapvpwrvgnd_1
XFILLER_0_56_416 VGND VGND VPWR VPWR sky130_fd_sc_hd__decap_4
XTAP_TAPCELL_ROW_12_411 VGND VPWR sky130_fd_sc_hd__tapvpwrvgnd_1
XFILLER_0_36_184 VGND VGND VPWR VPWR sky130_fd_sc_hd__fill_1
XTAP_TAPCELL_ROW_40_764 VGND VPWR sky130_fd_sc_hd__tapvpwrvgnd_1
XTAP_TAPCELL_ROW_116_1708 VGND VPWR sky130_fd_sc_hd__tapvpwrvgnd_1
XFILLER_0_101_47 VGND VGND VPWR VPWR sky130_fd_sc_hd__fill_2
XFILLER_0_12_508 VGND VGND VPWR VPWR sky130_fd_sc_hd__fill_1
X_10468_ clknet_leaf_44_clk _00325_ VGND VGND VPWR VPWR tanh_inst.divider.y\[4\] sky130_fd_sc_hd__dfxtp_2
XTAP_TAPCELL_ROW_75_1195 VGND VPWR sky130_fd_sc_hd__tapvpwrvgnd_1
X_10399_ clknet_leaf_39_clk _00256_ VGND VGND VPWR VPWR tanh_inst.divider.x\[-1\]
+ sky130_fd_sc_hd__dfxtp_2
XFILLER_0_20_596 VGND VGND VPWR VPWR sky130_fd_sc_hd__decap_6
Xclkbuf_leaf_1_clk clknet_2_2__leaf_clk VGND VGND VPWR VPWR clknet_leaf_1_clk sky130_fd_sc_hd__clkbuf_8
X_06630_ _01502_ _01541_ _01542_ _01469_ mac_y_out[2] VGND VGND VPWR VPWR _00130_
+ sky130_fd_sc_hd__a32o_2
XTAP_TAPCELL_ROW_48_864 VGND VPWR sky130_fd_sc_hd__tapvpwrvgnd_1
X_06561_ tanh_inst.LOOKUP.index\[4\] tanh_inst.LOOKUP.index\[3\] VGND VGND VPWR VPWR
+ _01476_ sky130_fd_sc_hd__nor2_2
XFILLER_0_35_86 VGND VGND VPWR VPWR sky130_fd_sc_hd__fill_1
X_06492_ tanh_inst.divider.y_\[2\] _01412_ VGND VGND VPWR VPWR _01413_ sky130_fd_sc_hd__nand2_2
X_09280_ _02018_ _04005_ _04015_ _04016_ _02014_ VGND VGND VPWR VPWR _04017_ sky130_fd_sc_hd__o221ai_2
X_08300_ _03087_ _03088_ VGND VGND VPWR VPWR _03089_ sky130_fd_sc_hd__nor2_2
X_05512_ _00507_ _00508_ VGND VGND VPWR VPWR _05512_/X sky130_fd_sc_hd__and2_2
XFILLER_0_51_30 VGND VGND VPWR VPWR sky130_fd_sc_hd__decap_3
X_05443_ mac_inst.y\[9\] _00444_ VGND VGND VPWR VPWR _00445_ sky130_fd_sc_hd__nor2_2
X_08231_ tanh_inst.divider.x\[-5\] _03021_ VGND VGND VPWR VPWR _03022_ sky130_fd_sc_hd__nor2_2
XFILLER_0_47_449 VPWR VGND VPWR VGND sky130_ef_sc_hd__decap_12
X_08162_ _02052_ _02217_ _02222_ _02833_ VGND VGND VPWR VPWR _02954_ sky130_fd_sc_hd__a31o_2
XFILLER_0_55_482 VPWR VGND VPWR VGND sky130_ef_sc_hd__decap_12
XFILLER_0_7_579 VGND VGND VPWR VPWR sky130_fd_sc_hd__decap_6
XFILLER_0_7_568 VGND VGND VPWR VPWR sky130_fd_sc_hd__decap_4
XFILLER_0_15_335 VGND VGND VPWR VPWR sky130_fd_sc_hd__fill_1
X_05374_ mac_inst.y\[4\] _00379_ VGND VGND VPWR VPWR _00381_ sky130_fd_sc_hd__or2_2
X_07113_ _01935_ _01938_ VGND VGND VPWR VPWR _01939_ sky130_fd_sc_hd__nand2_2
XFILLER_0_70_463 VPWR VGND VPWR VGND sky130_ef_sc_hd__decap_12
X_08093_ tanh_inst.divider.y\[-8\] tanh_inst.divider.x\[-8\] VGND VGND VPWR VPWR _02887_
+ sky130_fd_sc_hd__or2_2
X_07044_ _01039_ _01809_ VGND VGND VPWR VPWR _01877_ sky130_fd_sc_hd__or2_2
XFILLER_0_62_3 VGND VGND VPWR VPWR sky130_fd_sc_hd__decap_6
XFILLER_0_2_251 VGND VGND VPWR VPWR sky130_fd_sc_hd__fill_1
X_08995_ _03733_ _03737_ _02023_ VGND VGND VPWR VPWR _03738_ sky130_fd_sc_hd__mux2_1
X_07946_ _02648_ _02684_ _02683_ VGND VGND VPWR VPWR _02744_ sky130_fd_sc_hd__a21oi_2
X_07877_ _04791_ _02666_ _02674_ _02675_ VGND VGND VPWR VPWR _02676_ sky130_fd_sc_hd__o22a_2
XFILLER_0_78_530 VGND VGND VPWR VPWR sky130_fd_sc_hd__fill_2
X_06828_ tanh_inst.z_\[7\] _01667_ _01474_ VGND VGND VPWR VPWR _01719_ sky130_fd_sc_hd__mux2_1
X_09616_ _04342_ VGND VGND VPWR VPWR _04343_ sky130_fd_sc_hd__inv_2
X_09547_ tanh_inst.divider.y\[-7\] _04269_ VGND VGND VPWR VPWR _04276_ sky130_fd_sc_hd__nor2_2
X_06759_ tanh_inst.z_\[-8\] _01657_ VGND VGND VPWR VPWR _01658_ sky130_fd_sc_hd__nand2_2
X_09478_ _04186_ _04188_ _04185_ VGND VGND VPWR VPWR _04209_ sky130_fd_sc_hd__a21boi_2
XTAP_TAPCELL_ROW_100_1509 VGND VPWR sky130_fd_sc_hd__tapvpwrvgnd_1
XFILLER_0_80_205 VGND VGND VPWR VPWR sky130_fd_sc_hd__fill_1
XFILLER_0_19_685 VGND VGND VPWR VPWR sky130_fd_sc_hd__decap_8
X_08429_ _03182_ _03214_ VGND VGND VPWR VPWR _03215_ sky130_fd_sc_hd__and2b_2
XFILLER_0_80_249 VGND VGND VPWR VPWR sky130_fd_sc_hd__decap_3
XFILLER_0_61_430 VPWR VGND VPWR VGND sky130_ef_sc_hd__decap_12
XFILLER_0_18_195 VGND VGND VPWR VPWR sky130_fd_sc_hd__fill_1
Xclkload0 clknet_2_0__leaf_clk VGND VGND VPWR VPWR clkload0/Y sky130_fd_sc_hd__inv_12
X_10322_ clknet_leaf_21_clk _00179_ VGND VGND VPWR VPWR tanh_out[14] sky130_fd_sc_hd__dfxtp_2
XFILLER_0_21_305 VPWR VGND VPWR VGND sky130_ef_sc_hd__decap_12
XFILLER_0_34_699 VGND VGND VPWR VPWR sky130_fd_sc_hd__fill_1
X_10253_ clknet_leaf_32_clk mac_inst.x\[15\] _00000_ VGND VGND VPWR VPWR mac_x_out[15]
+ sky130_fd_sc_hd__dfrtp_2
XTAP_TAPCELL_ROW_111_1649 VGND VPWR sky130_fd_sc_hd__tapvpwrvgnd_1
X_10184_ x_in[10] _00000_ VGND VGND VPWR VPWR mac_inst.x\[10\] sky130_fd_sc_hd__dlxtn_1
XFILLER_0_72_29 VGND VGND VPWR VPWR sky130_fd_sc_hd__decap_8
XTAP_TAPCELL_ROW_45_823 VGND VPWR sky130_fd_sc_hd__tapvpwrvgnd_1
XFILLER_0_69_585 VGND VGND VPWR VPWR sky130_fd_sc_hd__decap_8
XFILLER_0_84_533 VGND VGND VPWR VPWR sky130_fd_sc_hd__decap_3
XFILLER_0_29_449 VGND VGND VPWR VPWR sky130_fd_sc_hd__fill_1
XFILLER_0_71_205 VGND VGND VPWR VPWR sky130_fd_sc_hd__decap_3
XFILLER_0_25_611 VGND VGND VPWR VPWR sky130_fd_sc_hd__decap_4
XTAP_TAPCELL_ROW_25_580 VGND VPWR sky130_fd_sc_hd__tapvpwrvgnd_1
XFILLER_0_44_419 VGND VGND VPWR VPWR sky130_fd_sc_hd__fill_1
XFILLER_0_114_307 VGND VGND VPWR VPWR sky130_fd_sc_hd__fill_1
XFILLER_0_71_249 VGND VGND VPWR VPWR sky130_fd_sc_hd__decap_4
XFILLER_0_21_55 VGND VGND VPWR VPWR sky130_fd_sc_hd__fill_1
XFILLER_0_107_370 VGND VGND VPWR VPWR sky130_fd_sc_hd__decap_3
XFILLER_0_4_538 VGND VGND VPWR VPWR sky130_fd_sc_hd__fill_1
XFILLER_0_97_15 VPWR VGND VPWR VGND sky130_ef_sc_hd__decap_12
XTAP_TAPCELL_ROW_77_1224 VGND VPWR sky130_fd_sc_hd__tapvpwrvgnd_1
XFILLER_0_25_688 VGND VGND VPWR VPWR sky130_fd_sc_hd__fill_1
X_05090_ tanh_counter\[6\] _04807_ _00000_ VGND VGND VPWR VPWR _04811_ sky130_fd_sc_hd__o21ai_2
XFILLER_0_40_658 VGND VGND VPWR VPWR sky130_fd_sc_hd__decap_3
X_08780_ tanh_inst.divider.x\[-17\] _02028_ _03508_ VGND VGND VPWR VPWR _03526_ sky130_fd_sc_hd__o21a_2
X_07800_ _01525_ _02180_ _02191_ _01477_ VGND VGND VPWR VPWR _02601_ sky130_fd_sc_hd__o22a_2
X_07731_ _02023_ _02050_ _02053_ VGND VGND VPWR VPWR _02533_ sky130_fd_sc_hd__a21oi_2
X_05992_ mac_inst.z\[23\] _00933_ _00923_ mac_inst.z\[22\] VGND VGND VPWR VPWR _00947_
+ sky130_fd_sc_hd__o211a_2
XFILLER_0_46_41 VGND VGND VPWR VPWR sky130_fd_sc_hd__decap_8
XFILLER_0_46_74 VGND VGND VPWR VPWR sky130_fd_sc_hd__decap_8
XFILLER_0_46_85 VGND VGND VPWR VPWR sky130_fd_sc_hd__decap_4
XTAP_TAPCELL_ROW_88_1364 VGND VPWR sky130_fd_sc_hd__tapvpwrvgnd_1
X_07662_ _02374_ _02375_ _02424_ tanh_inst.z_\[7\] VGND VGND VPWR VPWR _02466_ sky130_fd_sc_hd__a31o_2
X_09401_ _04132_ _04133_ VGND VGND VPWR VPWR _04134_ sky130_fd_sc_hd__nand2_2
X_07593_ _02346_ _02348_ _02396_ VGND VGND VPWR VPWR _02398_ sky130_fd_sc_hd__o21ai_2
X_06613_ tanh_inst.LOOKUP.index\[4\] _01484_ VGND VGND VPWR VPWR _01526_ sky130_fd_sc_hd__or2_2
X_09332_ tanh_inst.divider.x\[-13\] _04066_ VGND VGND VPWR VPWR _04067_ sky130_fd_sc_hd__nor2_2
X_06544_ tanh_inst.divider.y\[6\] tanh_inst.div_en tanh_inst.divider.y_\[6\] _01092_
+ VGND VGND VPWR VPWR _01461_ sky130_fd_sc_hd__a22oi_2
XFILLER_0_87_393 VPWR VGND VPWR VGND sky130_ef_sc_hd__decap_12
X_06475_ _01306_ _01352_ _01393_ _01397_ VGND VGND VPWR VPWR _01398_ sky130_fd_sc_hd__a31o_2
X_09263_ _03956_ _03959_ _03999_ VGND VGND VPWR VPWR _04000_ sky130_fd_sc_hd__nor3_2
XFILLER_0_117_167 VGND VGND VPWR VPWR sky130_fd_sc_hd__fill_1
X_09194_ _03932_ VGND VGND VPWR VPWR _03933_ sky130_fd_sc_hd__inv_2
XFILLER_0_62_238 VGND VGND VPWR VPWR sky130_fd_sc_hd__decap_8
XFILLER_0_62_216 VGND VGND VPWR VPWR sky130_fd_sc_hd__decap_3
XFILLER_0_16_633 VGND VGND VPWR VPWR sky130_fd_sc_hd__decap_8
X_05426_ mac_inst.i\[3\] _04902_ _04911_ _00428_ VGND VGND VPWR VPWR _00429_ sky130_fd_sc_hd__o211a_2
X_08214_ _02999_ _03003_ VGND VGND VPWR VPWR _03005_ sky130_fd_sc_hd__xor2_2
X_08145_ _02869_ _02871_ _02937_ VGND VGND VPWR VPWR _02938_ sky130_fd_sc_hd__nor3_2
X_05357_ _00363_ _00364_ VGND VGND VPWR VPWR _00365_ sky130_fd_sc_hd__xnor2_2
X_08076_ tanh_inst.divider.x\[-8\] _02868_ VGND VGND VPWR VPWR _02870_ sky130_fd_sc_hd__xnor2_2
XFILLER_0_3_571 VPWR VGND VPWR VGND sky130_ef_sc_hd__decap_12
X_05288_ _04871_ _04876_ mac_inst.i\[0\] VGND VGND VPWR VPWR _04988_ sky130_fd_sc_hd__mux2_1
XFILLER_0_113_384 VGND VGND VPWR VPWR sky130_fd_sc_hd__decap_8
X_07027_ tanh_inst.divider.y_\[7\] _01861_ VGND VGND VPWR VPWR _01862_ sky130_fd_sc_hd__or2_2
XFILLER_0_11_393 VPWR VGND VPWR VGND sky130_ef_sc_hd__decap_12
X_08978_ tanh_inst.divider.y\[-22\] _02015_ _03698_ _03721_ VGND VGND VPWR VPWR _03722_
+ sky130_fd_sc_hd__o2bb2a_2
X_07929_ _02557_ _02560_ _02587_ _02725_ _02554_ VGND VGND VPWR VPWR _02727_ sky130_fd_sc_hd__o2111a_2
XFILLER_0_97_113 VGND VGND VPWR VPWR sky130_fd_sc_hd__decap_4
XFILLER_0_97_102 VGND VGND VPWR VPWR sky130_fd_sc_hd__fill_1
XTAP_TAPCELL_ROW_3_297 VGND VPWR sky130_fd_sc_hd__tapvpwrvgnd_1
XFILLER_0_109_613 VGND VGND VPWR VPWR sky130_fd_sc_hd__decap_3
XFILLER_0_66_533 VGND VGND VPWR VPWR sky130_fd_sc_hd__decap_8
XFILLER_0_109_635 VGND VGND VPWR VPWR sky130_fd_sc_hd__decap_8
XFILLER_0_93_363 VGND VGND VPWR VPWR sky130_fd_sc_hd__fill_1
XTAP_TAPCELL_ROW_61_1025 VGND VPWR sky130_fd_sc_hd__tapvpwrvgnd_1
XFILLER_0_108_189 VGND VGND VPWR VPWR sky130_fd_sc_hd__fill_2
XTAP_TAPCELL_ROW_50_881 VGND VPWR sky130_fd_sc_hd__tapvpwrvgnd_1
XTAP_TAPCELL_ROW_50_892 VGND VPWR sky130_fd_sc_hd__tapvpwrvgnd_1
XFILLER_0_21_113 VPWR VGND VPWR VGND sky130_ef_sc_hd__decap_12
XFILLER_0_22_658 VPWR VGND VPWR VGND sky130_ef_sc_hd__decap_12
X_10305_ clknet_leaf_13_clk _00162_ VGND VGND VPWR VPWR tanh_inst.divider.i\[2\] sky130_fd_sc_hd__dfxtp_2
X_10236_ clknet_leaf_23_clk mac_inst.y\[30\] _00000_ VGND VGND VPWR VPWR mac_y_out[30]
+ sky130_fd_sc_hd__dfrtp_2
XFILLER_0_30_680 VGND VGND VPWR VPWR sky130_fd_sc_hd__fill_1
XTAP_TAPCELL_ROW_72_1165 VGND VPWR sky130_fd_sc_hd__tapvpwrvgnd_1
X_10098_ clknet_leaf_10_clk _00115_ VGND VGND VPWR VPWR tanh_inst.divider.y_\[5\]
+ sky130_fd_sc_hd__dfxtp_2
XFILLER_0_83_39 VGND VGND VPWR VPWR sky130_fd_sc_hd__decap_8
XFILLER_0_107_57 VPWR VGND VPWR VGND sky130_ef_sc_hd__decap_12
XFILLER_0_88_168 VGND VGND VPWR VPWR sky130_fd_sc_hd__decap_4
XTAP_TAPCELL_ROW_58_992 VGND VPWR sky130_fd_sc_hd__tapvpwrvgnd_1
XTAP_TAPCELL_ROW_58_981 VGND VPWR sky130_fd_sc_hd__tapvpwrvgnd_1
XFILLER_0_16_77 VGND VGND VPWR VPWR sky130_fd_sc_hd__decap_6
XFILLER_0_69_393 VGND VGND VPWR VPWR sky130_fd_sc_hd__fill_2
XFILLER_0_57_544 VPWR VGND VPWR VGND sky130_ef_sc_hd__decap_12
XFILLER_0_29_246 VGND VGND VPWR VPWR sky130_fd_sc_hd__decap_6
XFILLER_0_84_363 VGND VGND VPWR VPWR sky130_fd_sc_hd__fill_1
XTAP_TAPCELL_ROW_83_1294 VGND VPWR sky130_fd_sc_hd__tapvpwrvgnd_1
XFILLER_0_120_3 VPWR VGND VPWR VGND sky130_ef_sc_hd__decap_12
X_06260_ _01198_ _01199_ VGND VGND VPWR VPWR _01200_ sky130_fd_sc_hd__and2b_2
XTAP_TAPCELL_ROW_20_509 VGND VPWR sky130_fd_sc_hd__tapvpwrvgnd_1
X_05211_ mac_inst.x\[5\] _04852_ _04853_ VGND VGND VPWR VPWR _04915_ sky130_fd_sc_hd__a21oi_2
X_06191_ _01111_ _01112_ _01110_ VGND VGND VPWR VPWR _01135_ sky130_fd_sc_hd__a21o_2
XFILLER_0_4_357 VGND VGND VPWR VPWR sky130_fd_sc_hd__decap_6
XFILLER_0_25_485 VGND VGND VPWR VPWR sky130_fd_sc_hd__decap_3
XFILLER_0_13_669 VGND VGND VPWR VPWR sky130_fd_sc_hd__decap_3
X_05142_ mac_inst.i\[27\] mac_inst.i\[26\] mac_inst.i\[29\] mac_inst.i\[28\] VGND
+ VGND VPWR VPWR _04846_ sky130_fd_sc_hd__or4_2
XFILLER_0_110_321 VGND VGND VPWR VPWR sky130_fd_sc_hd__decap_4
XFILLER_0_0_530 VGND VGND VPWR VPWR sky130_fd_sc_hd__fill_2
X_05073_ mac_inst.z\[4\] VGND VGND VPWR VPWR _04797_ sky130_fd_sc_hd__inv_2
XFILLER_0_40_477 VGND VGND VPWR VPWR sky130_fd_sc_hd__decap_8
X_09950_ _03342_ _04611_ _04667_ VGND VGND VPWR VPWR _04668_ sky130_fd_sc_hd__a21o_2
XFILLER_0_110_365 VGND VGND VPWR VPWR sky130_fd_sc_hd__decap_4
X_08901_ _04757_ _03637_ _03645_ VGND VGND VPWR VPWR _03646_ sky130_fd_sc_hd__o21ai_2
X_09881_ _04599_ _04600_ VGND VGND VPWR VPWR _04601_ sky130_fd_sc_hd__and2_2
X_08832_ tanh_inst.divider.x\[-20\] tanh_inst.divider.x\[-19\] tanh_inst.divider.x\[-18\]
+ tanh_inst.divider.x\[-17\] tanh_inst.LOOKUP.index\[0\] tanh_inst.LOOKUP.index\[1\]
+ VGND VGND VPWR VPWR _03578_ sky130_fd_sc_hd__mux4_2
X_08763_ tanh_inst.divider.x\[-12\] _02028_ _03508_ VGND VGND VPWR VPWR _03509_ sky130_fd_sc_hd__o21a_2
X_05975_ mac_inst.z\[31\] _00922_ _00930_ VGND VGND VPWR VPWR _00931_ sky130_fd_sc_hd__o21ai_2
XFILLER_0_79_113 VGND VGND VPWR VPWR sky130_fd_sc_hd__decap_4
X_07714_ tanh_inst.z_\[7\] _02516_ VGND VGND VPWR VPWR _02517_ sky130_fd_sc_hd__or2_2
XFILLER_0_25_3 VPWR VGND VPWR VGND sky130_ef_sc_hd__decap_12
XTAP_TAPCELL_ROW_28_609 VGND VPWR sky130_fd_sc_hd__tapvpwrvgnd_1
X_08694_ _03451_ _03454_ _03472_ _04791_ VGND VGND VPWR VPWR _03473_ sky130_fd_sc_hd__o31a_2
XTAP_TAPCELL_ROW_0_245 VGND VPWR sky130_fd_sc_hd__tapvpwrvgnd_1
X_07645_ _02447_ _02448_ VGND VGND VPWR VPWR _02449_ sky130_fd_sc_hd__and2_2
XTAP_TAPCELL_ROW_0_256 VGND VPWR sky130_fd_sc_hd__tapvpwrvgnd_1
XTAP_TAPCELL_ROW_0_267 VGND VPWR sky130_fd_sc_hd__tapvpwrvgnd_1
XFILLER_0_94_149 VGND VGND VPWR VPWR sky130_fd_sc_hd__decap_3
X_07576_ _02380_ _02381_ VGND VGND VPWR VPWR _02382_ sky130_fd_sc_hd__xnor2_2
XFILLER_0_48_533 VPWR VGND VPWR VGND sky130_ef_sc_hd__decap_12
XFILLER_0_118_421 VGND VGND VPWR VPWR sky130_fd_sc_hd__decap_4
X_06527_ tanh_inst.divider.y_\[5\] _01444_ VGND VGND VPWR VPWR _01445_ sky130_fd_sc_hd__or2_2
X_09315_ tanh_inst.divider.y\[-14\] _04049_ VGND VGND VPWR VPWR _04051_ sky130_fd_sc_hd__or2_2
XFILLER_0_63_503 VGND VGND VPWR VPWR sky130_fd_sc_hd__fill_1
X_06458_ _01370_ _01375_ _01381_ VGND VGND VPWR VPWR _01382_ sky130_fd_sc_hd__o21ai_2
X_09246_ _03982_ _03983_ VGND VGND VPWR VPWR _03984_ sky130_fd_sc_hd__nand2_2
XFILLER_0_106_638 VGND VGND VPWR VPWR sky130_fd_sc_hd__fill_1
XFILLER_0_63_569 VGND VGND VPWR VPWR sky130_fd_sc_hd__decap_4
X_05409_ _00348_ _00351_ mac_inst.i\[2\] VGND VGND VPWR VPWR _00413_ sky130_fd_sc_hd__mux2_1
X_06389_ tanh_inst.divider.y\[-7\] tanh_inst.div_en tanh_inst.divider.y_\[-7\] _01092_
+ VGND VGND VPWR VPWR _01319_ sky130_fd_sc_hd__a22o_2
XFILLER_0_105_137 VPWR VGND VPWR VGND sky130_ef_sc_hd__decap_12
X_09177_ _04769_ _02022_ VGND VGND VPWR VPWR _03916_ sky130_fd_sc_hd__nand2_2
XFILLER_0_31_400 VGND VGND VPWR VPWR sky130_fd_sc_hd__decap_8
X_08128_ _02881_ _02904_ _02018_ VGND VGND VPWR VPWR _02922_ sky130_fd_sc_hd__a21oi_2
XFILLER_0_43_293 VGND VGND VPWR VPWR sky130_fd_sc_hd__decap_4
X_08059_ _02837_ _02853_ VGND VGND VPWR VPWR _02854_ sky130_fd_sc_hd__xnor2_2
XFILLER_0_31_499 VGND VGND VPWR VPWR sky130_fd_sc_hd__fill_1
X_10021_ _04714_ _04718_ _04734_ tanh_inst.z_\[7\] VGND VGND VPWR VPWR _04736_ sky130_fd_sc_hd__a31o_2
XTAP_TAPCELL_ROW_8_367 VGND VPWR sky130_fd_sc_hd__tapvpwrvgnd_1
XTAP_TAPCELL_ROW_8_356 VGND VPWR sky130_fd_sc_hd__tapvpwrvgnd_1
XFILLER_0_98_433 VPWR VGND VPWR VGND sky130_ef_sc_hd__decap_12
XFILLER_0_98_466 VGND VGND VPWR VPWR sky130_fd_sc_hd__decap_8
XTAP_TAPCELL_ROW_55_951 VGND VPWR sky130_fd_sc_hd__tapvpwrvgnd_1
XPHY_EDGE_ROW_19_Right_19 VGND VGND VPWR VPWR sky130_fd_sc_hd__decap_3
XFILLER_0_109_410 VGND VGND VPWR VPWR sky130_fd_sc_hd__fill_2
XFILLER_0_94_672 VPWR VGND VPWR VGND sky130_ef_sc_hd__decap_12
XFILLER_0_66_363 VGND VGND VPWR VPWR sky130_fd_sc_hd__fill_1
XFILLER_0_105_671 VGND VGND VPWR VPWR sky130_fd_sc_hd__fill_1
XFILLER_0_78_17 VGND VGND VPWR VPWR sky130_fd_sc_hd__decap_8
XFILLER_0_1_305 VPWR VGND VPWR VGND sky130_ef_sc_hd__decap_12
XFILLER_0_105_693 VGND VGND VPWR VPWR sky130_fd_sc_hd__decap_4
XFILLER_0_1_349 VPWR VGND VPWR VGND sky130_ef_sc_hd__decap_12
XPHY_EDGE_ROW_28_Right_28 VGND VGND VPWR VPWR sky130_fd_sc_hd__decap_3
XFILLER_0_94_27 VGND VGND VPWR VPWR sky130_fd_sc_hd__fill_1
X_10219_ clknet_leaf_30_clk mac_inst.y\[13\] _00000_ VGND VGND VPWR VPWR mac_y_out[13]
+ sky130_fd_sc_hd__dfrtp_2
X_05760_ _04944_ _00704_ _00718_ _00693_ _00695_ VGND VGND VPWR VPWR _00733_ sky130_fd_sc_hd__o2111a_2
XTAP_TAPCELL_ROW_85_1323 VGND VPWR sky130_fd_sc_hd__tapvpwrvgnd_1
XPHY_EDGE_ROW_37_Right_37 VGND VGND VPWR VPWR sky130_fd_sc_hd__decap_3
X_05691_ _04981_ _00666_ _04944_ VGND VGND VPWR VPWR _00669_ sky130_fd_sc_hd__a21oi_2
XFILLER_0_49_319 VGND VGND VPWR VPWR sky130_fd_sc_hd__decap_3
X_07430_ _02237_ VGND VGND VPWR VPWR _02238_ sky130_fd_sc_hd__inv_2
XFILLER_0_76_127 VPWR VGND VPWR VGND sky130_ef_sc_hd__decap_12
X_07361_ _02139_ _02155_ _02168_ VGND VGND VPWR VPWR _02170_ sky130_fd_sc_hd__nand3_2
XFILLER_0_9_449 VGND VGND VPWR VPWR sky130_fd_sc_hd__decap_4
X_06312_ tanh_inst.divider.i\[3\] _01139_ _01187_ VGND VGND VPWR VPWR _01247_ sky130_fd_sc_hd__o21a_2
X_09100_ tanh_inst.divider.y\[-19\] _03834_ VGND VGND VPWR VPWR _03841_ sky130_fd_sc_hd__xnor2_2
XFILLER_0_72_300 VGND VGND VPWR VPWR sky130_fd_sc_hd__fill_1
XFILLER_0_17_205 VPWR VGND VPWR VGND sky130_ef_sc_hd__decap_12
XTAP_TAPCELL_ROW_33_678 VGND VPWR sky130_fd_sc_hd__tapvpwrvgnd_1
X_07292_ tanh_inst.divider.y\[-24\] _02099_ VGND VGND VPWR VPWR _02102_ sky130_fd_sc_hd__or2_2
X_09031_ tanh_inst.divider.y\[-21\] _03773_ VGND VGND VPWR VPWR _03774_ sky130_fd_sc_hd__and2_2
XFILLER_0_72_333 VPWR VGND VPWR VGND sky130_ef_sc_hd__decap_12
XFILLER_0_17_249 VPWR VGND VPWR VGND sky130_ef_sc_hd__decap_12
X_06243_ _01151_ _01153_ _01168_ _01150_ VGND VGND VPWR VPWR _01184_ sky130_fd_sc_hd__a211o_2
XFILLER_0_72_377 VGND VGND VPWR VPWR sky130_fd_sc_hd__decap_4
XFILLER_0_4_121 VPWR VGND VPWR VGND sky130_ef_sc_hd__decap_12
XPHY_EDGE_ROW_46_Right_46 VGND VGND VPWR VPWR sky130_fd_sc_hd__decap_3
XPHY_EDGE_ROW_107_Left_229 VGND VGND VPWR VPWR sky130_fd_sc_hd__decap_3
X_06174_ _04769_ tanh_inst.divider.i\[2\] VGND VGND VPWR VPWR _01118_ sky130_fd_sc_hd__nand2_2
XFILLER_0_4_165 VPWR VGND VPWR VGND sky130_ef_sc_hd__decap_12
XFILLER_0_25_293 VPWR VGND VPWR VGND sky130_ef_sc_hd__decap_12
XTAP_TAPCELL_ROW_96_1463 VGND VPWR sky130_fd_sc_hd__tapvpwrvgnd_1
X_05125_ current_state\[1\] mac_counter\[0\] VGND VGND VPWR VPWR _04832_ sky130_fd_sc_hd__and2b_2
XFILLER_0_40_263 VPWR VGND VPWR VGND sky130_ef_sc_hd__decap_12
X_09933_ tanh_inst.divider.y\[4\] _04649_ VGND VGND VPWR VPWR _04651_ sky130_fd_sc_hd__nor2_2
X_05056_ mac_complete VGND VGND VPWR VPWR _04780_ sky130_fd_sc_hd__inv_2
XTAP_TAPCELL_ROW_5_326 VGND VPWR sky130_fd_sc_hd__tapvpwrvgnd_1
XFILLER_0_0_393 VPWR VGND VPWR VGND sky130_ef_sc_hd__decap_12
X_09864_ _04577_ _04578_ _04582_ VGND VGND VPWR VPWR _04584_ sky130_fd_sc_hd__o21ai_2
X_08815_ tanh_inst.divider.x\[-7\] _02028_ _03508_ VGND VGND VPWR VPWR _03561_ sky130_fd_sc_hd__o21ai_2
XPHY_EDGE_ROW_116_Left_238 VGND VGND VPWR VPWR sky130_fd_sc_hd__decap_3
XFILLER_0_84_82 VGND VGND VPWR VPWR sky130_fd_sc_hd__fill_2
XPHY_EDGE_ROW_55_Right_55 VGND VGND VPWR VPWR sky130_fd_sc_hd__decap_3
X_09795_ tanh_inst.divider.y\[0\] _04516_ VGND VGND VPWR VPWR _04517_ sky130_fd_sc_hd__and2_2
X_05958_ mac_inst.z\[21\] _00915_ VGND VGND VPWR VPWR _00916_ sky130_fd_sc_hd__or2_2
X_08746_ mac_inst.i\[21\] _03502_ VGND VGND VPWR VPWR _00286_ sky130_fd_sc_hd__xor2_2
X_08677_ tanh_inst.divider.y\[6\] _03456_ VGND VGND VPWR VPWR _03457_ sky130_fd_sc_hd__nor2_2
X_05889_ mac_inst.z\[31\] _00851_ _00848_ VGND VGND VPWR VPWR _00852_ sky130_fd_sc_hd__o21ai_2
XFILLER_0_95_447 VGND VGND VPWR VPWR sky130_fd_sc_hd__fill_1
X_07628_ tanh_inst.divider.x\[-19\] _02014_ _02415_ _02432_ _01470_ VGND VGND VPWR
+ VPWR _00238_ sky130_fd_sc_hd__o221a_2
XTAP_TAPCELL_ROW_52_910 VGND VPWR sky130_fd_sc_hd__tapvpwrvgnd_1
XTAP_TAPCELL_ROW_105_1570 VGND VPWR sky130_fd_sc_hd__tapvpwrvgnd_1
X_07559_ _04791_ _02363_ _02364_ _02018_ VGND VGND VPWR VPWR _02365_ sky130_fd_sc_hd__a31o_2
XFILLER_0_106_413 VGND VGND VPWR VPWR sky130_fd_sc_hd__decap_6
XPHY_EDGE_ROW_64_Right_64 VGND VGND VPWR VPWR sky130_fd_sc_hd__decap_3
X_09229_ _03964_ _03966_ tanh_inst.z_\[7\] VGND VGND VPWR VPWR _03967_ sky130_fd_sc_hd__o21ai_2
XFILLER_0_106_446 VGND VGND VPWR VPWR sky130_fd_sc_hd__decap_6
XFILLER_0_90_152 VGND VGND VPWR VPWR sky130_fd_sc_hd__fill_1
XFILLER_0_63_377 VGND VGND VPWR VPWR sky130_fd_sc_hd__fill_1
XFILLER_0_51_517 VPWR VGND VPWR VGND sky130_ef_sc_hd__decap_12
XFILLER_0_121_405 VGND VGND VPWR VPWR sky130_fd_sc_hd__decap_8
XFILLER_0_121_449 VPWR VGND VPWR VGND sky130_ef_sc_hd__decap_12
XFILLER_0_31_230 VPWR VGND VPWR VGND sky130_ef_sc_hd__decap_12
XFILLER_0_102_685 VGND VGND VPWR VPWR sky130_fd_sc_hd__decap_4
XPHY_EDGE_ROW_73_Right_73 VGND VGND VPWR VPWR sky130_fd_sc_hd__decap_3
X_10004_ tanh_inst.divider.x\[6\] _04719_ VGND VGND VPWR VPWR _04720_ sky130_fd_sc_hd__nor2_2
XFILLER_0_86_414 VGND VGND VPWR VPWR sky130_fd_sc_hd__decap_6
XFILLER_0_59_639 VGND VGND VPWR VPWR sky130_fd_sc_hd__decap_3
XFILLER_0_59_617 VGND VGND VPWR VPWR sky130_fd_sc_hd__fill_1
XFILLER_0_98_296 VPWR VGND VPWR VGND sky130_ef_sc_hd__decap_12
XFILLER_0_80_29 VPWR VGND VPWR VGND sky130_ef_sc_hd__decap_12
XTAP_TAPCELL_ROW_67_1097 VGND VPWR sky130_fd_sc_hd__tapvpwrvgnd_1
XFILLER_0_27_503 VGND VGND VPWR VPWR sky130_fd_sc_hd__fill_1
XFILLER_0_104_58 VPWR VGND VPWR VGND sky130_ef_sc_hd__decap_12
XPHY_EDGE_ROW_82_Right_82 VGND VGND VPWR VPWR sky130_fd_sc_hd__decap_3
XFILLER_0_67_694 VGND VGND VPWR VPWR sky130_fd_sc_hd__fill_1
XFILLER_0_66_160 VPWR VGND VPWR VGND sky130_ef_sc_hd__decap_12
XFILLER_0_27_525 VGND VGND VPWR VPWR sky130_fd_sc_hd__decap_3
XTAP_TAPCELL_ROW_80_1264 VGND VPWR sky130_fd_sc_hd__tapvpwrvgnd_1
XFILLER_0_54_344 VPWR VGND VPWR VGND sky130_ef_sc_hd__decap_12
XFILLER_0_6_419 VGND VGND VPWR VPWR sky130_fd_sc_hd__fill_1
XTAP_TAPCELL_ROW_30_637 VGND VPWR sky130_fd_sc_hd__tapvpwrvgnd_1
XFILLER_0_89_27 VGND VGND VPWR VPWR sky130_fd_sc_hd__decap_3
XFILLER_0_42_517 VGND VGND VPWR VPWR sky130_fd_sc_hd__fill_1
XTAP_TAPCELL_ROW_10_383 VGND VPWR sky130_fd_sc_hd__tapvpwrvgnd_1
XFILLER_0_1_113 VPWR VGND VPWR VGND sky130_ef_sc_hd__decap_12
X_06930_ _01774_ _01775_ VGND VGND VPWR VPWR _00197_ sky130_fd_sc_hd__nor2_2
XPHY_EDGE_ROW_91_Right_91 VGND VGND VPWR VPWR sky130_fd_sc_hd__decap_3
X_08600_ _03380_ _03381_ VGND VGND VPWR VPWR _03382_ sky130_fd_sc_hd__nand2_2
X_06861_ _01736_ _01746_ _01747_ VGND VGND VPWR VPWR _01748_ sky130_fd_sc_hd__o21a_2
X_09580_ _04193_ _04307_ VGND VGND VPWR VPWR _04308_ sky130_fd_sc_hd__nand2_2
X_06792_ tanh_inst.LOOKUP.index\[1\] tanh_inst.LOOKUP.index\[0\] _01477_ _01531_ VGND
+ VGND VPWR VPWR _01687_ sky130_fd_sc_hd__o31a_2
XFILLER_0_54_41 VGND VGND VPWR VPWR sky130_fd_sc_hd__decap_6
X_05812_ _00755_ _00756_ _00769_ _00780_ VGND VGND VPWR VPWR _00781_ sky130_fd_sc_hd__o31ai_2
XTAP_TAPCELL_ROW_38_737 VGND VPWR sky130_fd_sc_hd__tapvpwrvgnd_1
X_05743_ _04908_ _04932_ _04935_ VGND VGND VPWR VPWR _00717_ sky130_fd_sc_hd__a21o_2
XFILLER_0_49_105 VGND VGND VPWR VPWR sky130_fd_sc_hd__fill_1
X_08531_ tanh_inst.divider.x\[1\] _03250_ _03264_ VGND VGND VPWR VPWR _03315_ sky130_fd_sc_hd__a21oi_2
XFILLER_0_54_85 VGND VGND VPWR VPWR sky130_fd_sc_hd__fill_1
X_05674_ mac_inst.y\[30\] _00654_ VGND VGND VPWR VPWR _00655_ sky130_fd_sc_hd__xor2_2
X_08462_ _03246_ _03247_ VGND VGND VPWR VPWR _03248_ sky130_fd_sc_hd__nand2_2
XFILLER_0_92_406 VGND VGND VPWR VPWR sky130_fd_sc_hd__fill_2
X_07413_ _02218_ _02220_ _02025_ VGND VGND VPWR VPWR _02221_ sky130_fd_sc_hd__mux2_1
XFILLER_0_58_661 VGND VGND VPWR VPWR sky130_fd_sc_hd__decap_3
XTAP_TAPCELL_ROW_18_483 VGND VPWR sky130_fd_sc_hd__tapvpwrvgnd_1
XFILLER_0_58_683 VGND VGND VPWR VPWR sky130_fd_sc_hd__fill_1
X_08393_ tanh_inst.divider.y\[-1\] _03178_ VGND VGND VPWR VPWR _03180_ sky130_fd_sc_hd__and2_2
XFILLER_0_116_722 VGND VGND VPWR VPWR sky130_fd_sc_hd__fill_2
XFILLER_0_85_491 VGND VGND VPWR VPWR sky130_fd_sc_hd__decap_4
X_07344_ _02151_ _02152_ _02026_ VGND VGND VPWR VPWR _02153_ sky130_fd_sc_hd__mux2_1
XFILLER_0_57_193 VGND VGND VPWR VPWR sky130_fd_sc_hd__fill_2
XFILLER_0_9_279 VGND VGND VPWR VPWR sky130_fd_sc_hd__fill_1
XFILLER_0_92_3 VPWR VGND VPWR VGND sky130_ef_sc_hd__decap_12
X_07275_ tanh_inst.divider.y\[-4\] _02028_ _02029_ VGND VGND VPWR VPWR _02085_ sky130_fd_sc_hd__o21a_2
XFILLER_0_60_303 VGND VGND VPWR VPWR sky130_fd_sc_hd__decap_4
XFILLER_0_33_517 VGND VGND VPWR VPWR sky130_fd_sc_hd__decap_8
X_06226_ tanh_inst.divider.y_\[-19\] _01165_ VGND VGND VPWR VPWR _01168_ sky130_fd_sc_hd__and2_2
XFILLER_0_115_243 VGND VGND VPWR VPWR sky130_fd_sc_hd__decap_4
XFILLER_0_26_580 VGND VGND VPWR VPWR sky130_fd_sc_hd__fill_1
X_09014_ tanh_inst.divider.x\[-5\] tanh_inst.divider.x\[-4\] tanh_inst.divider.x\[-3\]
+ tanh_inst.divider.x\[-2\] tanh_inst.LOOKUP.index\[0\] tanh_inst.LOOKUP.index\[1\]
+ VGND VGND VPWR VPWR _03757_ sky130_fd_sc_hd__mux4_2
XFILLER_0_103_449 VGND VGND VPWR VPWR sky130_fd_sc_hd__decap_6
XFILLER_0_41_561 VGND VGND VPWR VPWR sky130_fd_sc_hd__decap_3
X_06157_ _01100_ _01101_ _04777_ VGND VGND VPWR VPWR _01102_ sky130_fd_sc_hd__mux2_1
X_06088_ tanh_inst.divider.i\[1\] tanh_inst.divider.i\[0\] VGND VGND VPWR VPWR _01035_
+ sky130_fd_sc_hd__nand2b_2
X_05108_ mac_counter\[7\] _04820_ current_state\[1\] VGND VGND VPWR VPWR _04821_ sky130_fd_sc_hd__o21ba_2
X_05039_ tanh_inst.divider.y\[6\] VGND VGND VPWR VPWR _04763_ sky130_fd_sc_hd__inv_2
X_09916_ _04633_ _04634_ VGND VGND VPWR VPWR _04635_ sky130_fd_sc_hd__nand2b_2
X_09847_ _04565_ _04567_ VGND VGND VPWR VPWR _04568_ sky130_fd_sc_hd__xor2_2
X_09778_ _02019_ _04492_ _04499_ _04500_ _02015_ VGND VGND VPWR VPWR _04501_ sky130_fd_sc_hd__a221oi_2
XFILLER_0_96_723 VGND VGND VPWR VPWR sky130_fd_sc_hd__fill_1
X_08729_ _00962_ _03493_ VGND VGND VPWR VPWR _00278_ sky130_fd_sc_hd__and2b_2
XFILLER_0_95_277 VGND VGND VPWR VPWR sky130_fd_sc_hd__decap_3
XFILLER_0_83_428 VGND VGND VPWR VPWR sky130_fd_sc_hd__fill_1
XFILLER_0_36_333 VPWR VGND VPWR VGND sky130_ef_sc_hd__decap_12
XFILLER_0_63_152 VPWR VGND VPWR VGND sky130_ef_sc_hd__decap_12
XFILLER_0_24_517 VPWR VGND VPWR VGND sky130_ef_sc_hd__decap_12
X_10484_ clknet_leaf_33_clk _00341_ _00085_ VGND VGND VPWR VPWR tanh_counter\[7\]
+ sky130_fd_sc_hd__dfrtp_2
XFILLER_0_20_701 VGND VGND VPWR VPWR sky130_fd_sc_hd__fill_2
XFILLER_0_51_358 VPWR VGND VPWR VGND sky130_ef_sc_hd__decap_12
XFILLER_0_102_471 VGND VGND VPWR VPWR sky130_fd_sc_hd__decap_4
XTAP_TAPCELL_ROW_69_1126 VGND VPWR sky130_fd_sc_hd__tapvpwrvgnd_1
XFILLER_0_99_561 VGND VGND VPWR VPWR sky130_fd_sc_hd__fill_2
XFILLER_0_91_39 VGND VGND VPWR VPWR sky130_fd_sc_hd__decap_8
XFILLER_0_59_425 VGND VGND VPWR VPWR sky130_fd_sc_hd__decap_4
XFILLER_0_115_57 VPWR VGND VPWR VGND sky130_ef_sc_hd__decap_12
XTAP_TAPCELL_ROW_15_453 VGND VPWR sky130_fd_sc_hd__tapvpwrvgnd_1
XFILLER_0_24_77 VGND VGND VPWR VPWR sky130_fd_sc_hd__decap_6
XFILLER_0_39_160 VGND VGND VPWR VPWR sky130_fd_sc_hd__decap_8
XFILLER_0_117_519 VGND VGND VPWR VPWR sky130_fd_sc_hd__decap_6
X_05390_ mac_inst.y\[5\] _00394_ VGND VGND VPWR VPWR _00396_ sky130_fd_sc_hd__nand2_2
XTAP_TAPCELL_ROW_43_795 VGND VPWR sky130_fd_sc_hd__tapvpwrvgnd_1
XFILLER_0_55_686 VGND VGND VPWR VPWR sky130_fd_sc_hd__decap_3
X_07060_ _01881_ _01889_ _01890_ VGND VGND VPWR VPWR _01892_ sky130_fd_sc_hd__nand3_2
XFILLER_0_54_174 VGND VGND VPWR VPWR sky130_fd_sc_hd__fill_2
XFILLER_0_27_399 VGND VGND VPWR VPWR sky130_fd_sc_hd__decap_3
XFILLER_0_42_314 VGND VGND VPWR VPWR sky130_fd_sc_hd__decap_8
X_06011_ mac_inst.i\[14\] _00962_ _00964_ VGND VGND VPWR VPWR _00965_ sky130_fd_sc_hd__and3_2
XTAP_TAPCELL_ROW_93_1422 VGND VPWR sky130_fd_sc_hd__tapvpwrvgnd_1
XFILLER_0_10_233 VPWR VGND VPWR VGND sky130_ef_sc_hd__decap_12
XFILLER_0_2_477 VGND VGND VPWR VPWR sky130_fd_sc_hd__fill_1
XFILLER_0_10_277 VPWR VGND VPWR VGND sky130_ef_sc_hd__decap_12
X_07962_ _02757_ _02758_ VGND VGND VPWR VPWR _02759_ sky130_fd_sc_hd__and2b_2
X_09701_ tanh_inst.LOOKUP.index\[4\] _03853_ _04213_ VGND VGND VPWR VPWR _04426_ sky130_fd_sc_hd__o21a_2
X_06913_ tanh_inst.div_en tanh_inst.divider.z_\[-5\] VGND VGND VPWR VPWR _00184_ sky130_fd_sc_hd__and2b_2
X_07893_ tanh_inst.divider.y\[7\] _02342_ _02343_ _02338_ _02023_ _02052_ VGND VGND
+ VPWR VPWR _02691_ sky130_fd_sc_hd__mux4_2
XFILLER_0_4_65 VPWR VGND VPWR VGND sky130_ef_sc_hd__decap_12
XFILLER_0_65_62 VGND VGND VPWR VPWR sky130_fd_sc_hd__decap_3
X_06844_ tanh_inst.z_\[2\] _01667_ VGND VGND VPWR VPWR _01733_ sky130_fd_sc_hd__and2_2
X_09632_ _04357_ _04358_ VGND VGND VPWR VPWR _04359_ sky130_fd_sc_hd__or2_2
XFILLER_0_78_701 VGND VGND VPWR VPWR sky130_fd_sc_hd__decap_4
X_09563_ tanh_inst.divider.y\[-7\] _04290_ VGND VGND VPWR VPWR _04292_ sky130_fd_sc_hd__or2_2
XFILLER_0_78_723 VGND VGND VPWR VPWR sky130_fd_sc_hd__fill_1
XFILLER_0_77_222 VGND VGND VPWR VPWR sky130_fd_sc_hd__fill_2
XFILLER_0_77_200 VGND VGND VPWR VPWR sky130_fd_sc_hd__decap_8
X_06775_ _01511_ _01528_ VGND VGND VPWR VPWR _01672_ sky130_fd_sc_hd__nor2_2
X_08514_ tanh_inst.divider.y\[2\] tanh_inst.divider.x\[2\] VGND VGND VPWR VPWR _03298_
+ sky130_fd_sc_hd__and2_2
XFILLER_0_81_50 VGND VGND VPWR VPWR sky130_fd_sc_hd__fill_1
X_09494_ _04121_ _04155_ VGND VGND VPWR VPWR _04224_ sky130_fd_sc_hd__or2_2
X_05726_ _00685_ _00689_ _00699_ VGND VGND VPWR VPWR _00702_ sky130_fd_sc_hd__a21o_2
XTAP_TAPCELL_ROW_102_1540 VGND VPWR sky130_fd_sc_hd__tapvpwrvgnd_1
XFILLER_0_77_288 VGND VGND VPWR VPWR sky130_fd_sc_hd__decap_6
XFILLER_0_65_417 VPWR VGND VPWR VGND sky130_ef_sc_hd__decap_12
X_08445_ _03229_ _03230_ VGND VGND VPWR VPWR _03231_ sky130_fd_sc_hd__or2_2
X_05657_ mac_inst.y\[27\] _00629_ _00620_ VGND VGND VPWR VPWR _00640_ sky130_fd_sc_hd__o21ai_2
X_08376_ _02053_ _02490_ _02834_ VGND VGND VPWR VPWR _03163_ sky130_fd_sc_hd__o21a_2
XFILLER_0_18_333 VPWR VGND VPWR VGND sky130_ef_sc_hd__decap_12
X_05588_ mac_inst.z\[31\] _00576_ VGND VGND VPWR VPWR _00577_ sky130_fd_sc_hd__or2_2
X_07327_ _02134_ _02135_ _02025_ VGND VGND VPWR VPWR _02136_ sky130_fd_sc_hd__mux2_1
XFILLER_0_45_152 VGND VGND VPWR VPWR sky130_fd_sc_hd__decap_4
XFILLER_0_61_645 VPWR VGND VPWR VGND sky130_ef_sc_hd__decap_12
XFILLER_0_46_697 VGND VGND VPWR VPWR sky130_fd_sc_hd__decap_3
XFILLER_0_116_585 VGND VGND VPWR VPWR sky130_fd_sc_hd__decap_3
X_07258_ tanh_inst.divider.y\[6\] _02028_ _02029_ VGND VGND VPWR VPWR _02068_ sky130_fd_sc_hd__o21a_2
X_07189_ _02003_ _02004_ VGND VGND VPWR VPWR _02005_ sky130_fd_sc_hd__and2_2
X_06209_ _01150_ _01151_ VGND VGND VPWR VPWR _01152_ sky130_fd_sc_hd__and2b_2
XFILLER_0_5_293 VPWR VGND VPWR VGND sky130_ef_sc_hd__decap_12
XFILLER_0_41_391 VGND VGND VPWR VPWR sky130_fd_sc_hd__fill_1
XTAP_TAPCELL_ROW_113_1680 VGND VPWR sky130_fd_sc_hd__tapvpwrvgnd_1
XFILLER_0_69_723 VGND VGND VPWR VPWR sky130_fd_sc_hd__fill_1
XFILLER_0_83_225 VPWR VGND VPWR VGND sky130_ef_sc_hd__decap_12
XTAP_TAPCELL_ROW_64_1056 VGND VPWR sky130_fd_sc_hd__tapvpwrvgnd_1
XTAP_TAPCELL_ROW_64_1067 VGND VPWR sky130_fd_sc_hd__tapvpwrvgnd_1
XTAP_TAPCELL_ROW_12_412 VGND VPWR sky130_fd_sc_hd__tapvpwrvgnd_1
XFILLER_0_101_15 VPWR VGND VPWR VGND sky130_ef_sc_hd__decap_12
XFILLER_0_64_483 VGND VGND VPWR VPWR sky130_fd_sc_hd__fill_1
XFILLER_0_52_645 VGND VGND VPWR VPWR sky130_fd_sc_hd__fill_1
XTAP_TAPCELL_ROW_40_765 VGND VPWR sky130_fd_sc_hd__tapvpwrvgnd_1
XFILLER_0_51_111 VGND VGND VPWR VPWR sky130_fd_sc_hd__fill_1
XTAP_TAPCELL_ROW_116_1709 VGND VPWR sky130_fd_sc_hd__tapvpwrvgnd_1
XFILLER_0_107_585 VPWR VGND VPWR VGND sky130_ef_sc_hd__decap_12
XFILLER_0_52_678 VPWR VGND VPWR VGND sky130_ef_sc_hd__decap_12
XPHY_EDGE_ROW_108_Right_108 VGND VGND VPWR VPWR sky130_fd_sc_hd__decap_3
X_10467_ clknet_leaf_43_clk _00324_ VGND VGND VPWR VPWR tanh_inst.divider.y\[3\] sky130_fd_sc_hd__dfxtp_2
XFILLER_0_20_531 VGND VGND VPWR VPWR sky130_fd_sc_hd__fill_1
XFILLER_0_32_380 VGND VGND VPWR VPWR sky130_fd_sc_hd__decap_6
XTAP_TAPCELL_ROW_75_1196 VGND VPWR sky130_fd_sc_hd__tapvpwrvgnd_1
X_10398_ clknet_leaf_39_clk _00255_ VGND VGND VPWR VPWR tanh_inst.divider.x\[-2\]
+ sky130_fd_sc_hd__dfxtp_2
XFILLER_0_19_55 VGND VGND VPWR VPWR sky130_fd_sc_hd__fill_1
XTAP_TAPCELL_ROW_48_865 VGND VPWR sky130_fd_sc_hd__tapvpwrvgnd_1
X_06560_ tanh_inst.LOOKUP.index\[0\] _01474_ VGND VGND VPWR VPWR _01475_ sky130_fd_sc_hd__nor2_2
X_06491_ _01410_ _01411_ VGND VGND VPWR VPWR _01412_ sky130_fd_sc_hd__xor2_2
XFILLER_0_59_277 VGND VGND VPWR VPWR sky130_fd_sc_hd__decap_3
X_05511_ _00503_ _00504_ _00506_ VGND VGND VPWR VPWR _00508_ sky130_fd_sc_hd__nand3_2
X_05442_ _00442_ _00443_ VGND VGND VPWR VPWR _00444_ sky130_fd_sc_hd__xnor2_2
X_08230_ _03018_ _03020_ VGND VGND VPWR VPWR _03021_ sky130_fd_sc_hd__xnor2_2
XFILLER_0_7_525 VGND VGND VPWR VPWR sky130_fd_sc_hd__fill_1
XFILLER_0_27_130 VPWR VGND VPWR VGND sky130_ef_sc_hd__decap_12
XFILLER_0_28_686 VGND VGND VPWR VPWR sky130_fd_sc_hd__fill_1
XFILLER_0_55_494 VGND VGND VPWR VPWR sky130_fd_sc_hd__decap_8
X_05373_ mac_inst.y\[4\] _00379_ VGND VGND VPWR VPWR _00380_ sky130_fd_sc_hd__nand2_2
X_08161_ tanh_inst.divider.x\[-7\] _02014_ _02953_ _01470_ VGND VGND VPWR VPWR _00250_
+ sky130_fd_sc_hd__o211a_2
X_08092_ _02718_ _02885_ _02547_ VGND VGND VPWR VPWR _02886_ sky130_fd_sc_hd__or3b_2
X_07112_ _01919_ _01920_ _01928_ _01937_ _01936_ VGND VGND VPWR VPWR _01938_ sky130_fd_sc_hd__a41o_2
XFILLER_0_15_369 VGND VGND VPWR VPWR sky130_fd_sc_hd__decap_3
XFILLER_0_43_678 VGND VGND VPWR VPWR sky130_fd_sc_hd__decap_3
X_07043_ tanh_inst.divider.z_\[-12\] _01092_ _01876_ _01088_ VGND VGND VPWR VPWR _00209_
+ sky130_fd_sc_hd__a22o_2
XFILLER_0_70_475 VGND VGND VPWR VPWR sky130_fd_sc_hd__fill_1
Xclkload40 clknet_leaf_24_clk VGND VGND VPWR VPWR clkload40/Y sky130_fd_sc_hd__clkinv_8
XFILLER_0_113_588 VGND VGND VPWR VPWR sky130_fd_sc_hd__fill_2
XFILLER_0_11_553 VGND VGND VPWR VPWR sky130_fd_sc_hd__decap_6
X_08994_ _03734_ _03736_ _02025_ VGND VGND VPWR VPWR _03737_ sky130_fd_sc_hd__mux2_1
XFILLER_0_55_3 VGND VGND VPWR VPWR sky130_fd_sc_hd__decap_6
XFILLER_0_76_83 VGND VGND VPWR VPWR sky130_fd_sc_hd__fill_1
X_07945_ _02572_ _02607_ _02649_ _02685_ VGND VGND VPWR VPWR _02743_ sky130_fd_sc_hd__or4_2
X_07876_ _02633_ _02637_ _02673_ tanh_inst.z_\[7\] VGND VGND VPWR VPWR _02675_ sky130_fd_sc_hd__a31o_2
X_09615_ _04317_ _04319_ _04340_ VGND VGND VPWR VPWR _04342_ sky130_fd_sc_hd__o21a_2
X_06827_ mac_y_out[23] _01469_ _01502_ _01718_ VGND VGND VPWR VPWR _00151_ sky130_fd_sc_hd__a22o_2
X_09546_ tanh_inst.divider.y\[-7\] _04269_ VGND VGND VPWR VPWR _04275_ sky130_fd_sc_hd__and2_2
X_06758_ tanh_inst.z_\[7\] _01653_ _01656_ VGND VGND VPWR VPWR _01657_ sky130_fd_sc_hd__o21a_2
X_09477_ _04206_ _04207_ VGND VGND VPWR VPWR _04208_ sky130_fd_sc_hd__nand2_2
X_05709_ mac_inst.z\[2\] _00683_ VGND VGND VPWR VPWR _00686_ sky130_fd_sc_hd__and2_2
X_06689_ _01594_ _01595_ VGND VGND VPWR VPWR _01596_ sky130_fd_sc_hd__nor2_2
XFILLER_0_65_225 VGND VGND VPWR VPWR sky130_fd_sc_hd__decap_6
XFILLER_0_19_642 VGND VGND VPWR VPWR sky130_fd_sc_hd__decap_8
X_08428_ _03151_ _03183_ _03210_ _03156_ VGND VGND VPWR VPWR _03214_ sky130_fd_sc_hd__o22a_2
XFILLER_0_108_338 VGND VGND VPWR VPWR sky130_fd_sc_hd__fill_1
XFILLER_0_18_141 VPWR VGND VPWR VGND sky130_ef_sc_hd__decap_12
Xclkload1 clknet_2_1__leaf_clk VGND VGND VPWR VPWR clkload1/Y sky130_fd_sc_hd__inv_8
XFILLER_0_34_634 VGND VGND VPWR VPWR sky130_fd_sc_hd__decap_8
XFILLER_0_34_645 VGND VGND VPWR VPWR sky130_fd_sc_hd__decap_8
X_08359_ tanh_inst.divider.x\[-2\] _03129_ VGND VGND VPWR VPWR _03147_ sky130_fd_sc_hd__xnor2_2
XFILLER_0_46_494 VGND VGND VPWR VPWR sky130_fd_sc_hd__fill_1
XFILLER_0_116_382 VGND VGND VPWR VPWR sky130_fd_sc_hd__decap_8
XFILLER_0_61_442 VGND VGND VPWR VPWR sky130_fd_sc_hd__decap_6
X_10321_ clknet_leaf_21_clk _00178_ VGND VGND VPWR VPWR tanh_out[13] sky130_fd_sc_hd__dfxtp_2
XFILLER_0_21_317 VPWR VGND VPWR VGND sky130_ef_sc_hd__decap_12
X_10252_ clknet_leaf_32_clk mac_inst.x\[14\] _00000_ VGND VGND VPWR VPWR mac_x_out[14]
+ sky130_fd_sc_hd__dfrtp_2
X_10183_ x_in[9] _00000_ VGND VGND VPWR VPWR mac_inst.x\[9\] sky130_fd_sc_hd__dlxtn_1
XFILLER_0_69_542 VGND VGND VPWR VPWR sky130_fd_sc_hd__decap_6
XTAP_TAPCELL_ROW_45_824 VGND VPWR sky130_fd_sc_hd__tapvpwrvgnd_1
XFILLER_0_56_225 VGND VGND VPWR VPWR sky130_fd_sc_hd__decap_3
XFILLER_0_84_589 VGND VGND VPWR VPWR sky130_fd_sc_hd__decap_6
XFILLER_0_72_718 VGND VGND VPWR VPWR sky130_fd_sc_hd__decap_6
XTAP_TAPCELL_ROW_25_570 VGND VPWR sky130_fd_sc_hd__tapvpwrvgnd_1
XFILLER_0_37_461 VPWR VGND VPWR VGND sky130_ef_sc_hd__decap_12
XFILLER_0_71_217 VGND VGND VPWR VPWR sky130_fd_sc_hd__decap_6
XFILLER_0_97_27 VPWR VGND VPWR VGND sky130_ef_sc_hd__decap_12
XTAP_TAPCELL_ROW_77_1225 VGND VPWR sky130_fd_sc_hd__tapvpwrvgnd_1
XFILLER_0_0_701 VGND VGND VPWR VPWR sky130_fd_sc_hd__fill_2
XFILLER_0_41_9 VGND VGND VPWR VPWR sky130_fd_sc_hd__fill_1
X_07730_ _02023_ _02097_ VGND VGND VPWR VPWR _02532_ sky130_fd_sc_hd__or2_2
X_05991_ _00908_ _00942_ _00945_ VGND VGND VPWR VPWR _00946_ sky130_fd_sc_hd__a21o_2
X_07661_ tanh_inst.z_\[7\] _02464_ _02453_ _02019_ VGND VGND VPWR VPWR _02465_ sky130_fd_sc_hd__o211a_2
XTAP_TAPCELL_ROW_88_1365 VGND VPWR sky130_fd_sc_hd__tapvpwrvgnd_1
X_09400_ tanh_inst.divider.y\[-11\] _04131_ VGND VGND VPWR VPWR _04133_ sky130_fd_sc_hd__or2_2
XFILLER_0_94_309 VGND VGND VPWR VPWR sky130_fd_sc_hd__decap_6
X_07592_ _02346_ _02348_ _02396_ VGND VGND VPWR VPWR _02397_ sky130_fd_sc_hd__o21a_2
XFILLER_0_1_55 VGND VGND VPWR VPWR sky130_fd_sc_hd__fill_1
X_06612_ _04757_ tanh_inst.LOOKUP.index\[3\] VGND VGND VPWR VPWR _01525_ sky130_fd_sc_hd__nand2_2
X_09331_ _04064_ _04065_ VGND VGND VPWR VPWR _04066_ sky130_fd_sc_hd__or2_2
X_06543_ _01447_ _01449_ _01457_ _01445_ VGND VGND VPWR VPWR _01460_ sky130_fd_sc_hd__o211a_2
XFILLER_0_62_85 VGND VGND VPWR VPWR sky130_fd_sc_hd__decap_6
XFILLER_0_47_225 VGND VGND VPWR VPWR sky130_fd_sc_hd__fill_1
XFILLER_0_117_113 VPWR VGND VPWR VGND sky130_ef_sc_hd__decap_12
X_06474_ _01351_ _01393_ _01395_ _01396_ VGND VGND VPWR VPWR _01397_ sky130_fd_sc_hd__a211o_2
X_09262_ tanh_inst.divider.x\[-15\] _03998_ VGND VGND VPWR VPWR _03999_ sky130_fd_sc_hd__xor2_2
XFILLER_0_47_258 VGND VGND VPWR VPWR sky130_fd_sc_hd__fill_1
X_09193_ _02503_ _03919_ VGND VGND VPWR VPWR _03932_ sky130_fd_sc_hd__nor2_2
XFILLER_0_15_111 VGND VGND VPWR VPWR sky130_fd_sc_hd__fill_1
X_05425_ _04782_ _04862_ _04868_ _04781_ VGND VGND VPWR VPWR _00428_ sky130_fd_sc_hd__a211o_2
X_08213_ _02999_ _03003_ VGND VGND VPWR VPWR _03004_ sky130_fd_sc_hd__nor2_2
X_08144_ _02935_ _02936_ VGND VGND VPWR VPWR _02937_ sky130_fd_sc_hd__nor2_2
XFILLER_0_16_645 VGND VGND VPWR VPWR sky130_fd_sc_hd__decap_6
XFILLER_0_16_667 VGND VGND VPWR VPWR sky130_fd_sc_hd__fill_2
X_05356_ _04927_ _05008_ _05030_ mac_inst.z\[31\] VGND VGND VPWR VPWR _00364_ sky130_fd_sc_hd__a31o_2
XFILLER_0_43_453 VGND VGND VPWR VPWR sky130_fd_sc_hd__fill_1
XTAP_TAPCELL_ROW_99_1494 VGND VPWR sky130_fd_sc_hd__tapvpwrvgnd_1
XFILLER_0_101_503 VGND VGND VPWR VPWR sky130_fd_sc_hd__fill_1
X_08075_ tanh_inst.divider.x\[-8\] _02868_ VGND VGND VPWR VPWR _02869_ sky130_fd_sc_hd__and2_2
XFILLER_0_3_561 VGND VGND VPWR VPWR sky130_fd_sc_hd__decap_3
X_05287_ _04869_ _04872_ mac_inst.i\[0\] VGND VGND VPWR VPWR _04987_ sky130_fd_sc_hd__mux2_1
X_07026_ _01039_ _01791_ _01847_ VGND VGND VPWR VPWR _01861_ sky130_fd_sc_hd__o21a_2
XFILLER_0_3_583 VGND VGND VPWR VPWR sky130_fd_sc_hd__decap_8
XFILLER_0_11_361 VPWR VGND VPWR VGND sky130_ef_sc_hd__decap_12
X_08977_ _02018_ _03720_ _02015_ VGND VGND VPWR VPWR _03721_ sky130_fd_sc_hd__a21o_2
XFILLER_0_98_604 VGND VGND VPWR VPWR sky130_fd_sc_hd__fill_1
X_07928_ _02656_ _02671_ _02633_ VGND VGND VPWR VPWR _02726_ sky130_fd_sc_hd__a21oi_2
X_07859_ tanh_inst.divider.x\[-13\] _02656_ VGND VGND VPWR VPWR _02658_ sky130_fd_sc_hd__nor2_2
XTAP_TAPCELL_ROW_3_298 VGND VPWR sky130_fd_sc_hd__tapvpwrvgnd_1
XFILLER_0_97_169 VGND VGND VPWR VPWR sky130_fd_sc_hd__decap_4
X_09529_ tanh_inst.divider.x\[-8\] _04258_ VGND VGND VPWR VPWR _04259_ sky130_fd_sc_hd__nor2_2
XTAP_TAPCELL_ROW_61_1026 VGND VPWR sky130_fd_sc_hd__tapvpwrvgnd_1
XTAP_TAPCELL_ROW_121_1790 VGND VPWR sky130_fd_sc_hd__tapvpwrvgnd_1
XFILLER_0_19_483 VGND VGND VPWR VPWR sky130_fd_sc_hd__decap_4
XTAP_TAPCELL_ROW_22_540 VGND VPWR sky130_fd_sc_hd__tapvpwrvgnd_1
XFILLER_0_81_559 VGND VGND VPWR VPWR sky130_fd_sc_hd__fill_1
XTAP_TAPCELL_ROW_50_882 VGND VPWR sky130_fd_sc_hd__tapvpwrvgnd_1
XTAP_TAPCELL_ROW_50_893 VGND VPWR sky130_fd_sc_hd__tapvpwrvgnd_1
XFILLER_0_34_475 VGND VGND VPWR VPWR sky130_fd_sc_hd__fill_1
XFILLER_0_61_294 VGND VGND VPWR VPWR sky130_fd_sc_hd__fill_1
XFILLER_0_21_125 VPWR VGND VPWR VGND sky130_ef_sc_hd__decap_12
X_10304_ clknet_leaf_13_clk _00161_ VGND VGND VPWR VPWR tanh_inst.divider.i\[1\] sky130_fd_sc_hd__dfxtp_2
XFILLER_0_21_169 VPWR VGND VPWR VGND sky130_ef_sc_hd__decap_12
X_10235_ clknet_leaf_22_clk mac_inst.y\[29\] _00000_ VGND VGND VPWR VPWR mac_y_out[29]
+ sky130_fd_sc_hd__dfrtp_2
XTAP_TAPCELL_ROW_72_1166 VGND VPWR sky130_fd_sc_hd__tapvpwrvgnd_1
X_10097_ clknet_leaf_10_clk _00114_ VGND VGND VPWR VPWR tanh_inst.divider.y_\[4\]
+ sky130_fd_sc_hd__dfxtp_2
XFILLER_0_88_125 VPWR VGND VPWR VGND sky130_ef_sc_hd__decap_12
XFILLER_0_107_69 VPWR VGND VPWR VGND sky130_ef_sc_hd__decap_12
XTAP_TAPCELL_ROW_58_993 VGND VPWR sky130_fd_sc_hd__tapvpwrvgnd_1
XTAP_TAPCELL_ROW_58_982 VGND VPWR sky130_fd_sc_hd__tapvpwrvgnd_1
XFILLER_0_97_681 VPWR VGND VPWR VGND sky130_ef_sc_hd__decap_12
XFILLER_0_76_309 VPWR VGND VPWR VGND sky130_ef_sc_hd__decap_12
XFILLER_0_69_361 VPWR VGND VPWR VGND sky130_ef_sc_hd__decap_12
XTAP_TAPCELL_ROW_83_1295 VGND VPWR sky130_fd_sc_hd__tapvpwrvgnd_1
XFILLER_0_57_556 VGND VGND VPWR VPWR sky130_fd_sc_hd__decap_4
XFILLER_0_115_606 VGND VGND VPWR VPWR sky130_fd_sc_hd__decap_8
XFILLER_0_72_515 VGND VGND VPWR VPWR sky130_fd_sc_hd__decap_4
XFILLER_0_32_66 VGND VGND VPWR VPWR sky130_fd_sc_hd__fill_1
XFILLER_0_113_3 VPWR VGND VPWR VGND sky130_ef_sc_hd__decap_12
X_06190_ _01132_ _01133_ VGND VGND VPWR VPWR _01134_ sky130_fd_sc_hd__nor2_2
XFILLER_0_72_559 VGND VGND VPWR VPWR sky130_fd_sc_hd__decap_3
X_05210_ mac_inst.x\[4\] _04852_ _04853_ mac_inst.i\[0\] VGND VGND VPWR VPWR _04914_
+ sky130_fd_sc_hd__a211o_2
X_05141_ mac_inst.i\[27\] mac_inst.i\[29\] VGND VGND VPWR VPWR _04845_ sky130_fd_sc_hd__or2_2
XFILLER_0_52_283 VGND VGND VPWR VPWR sky130_fd_sc_hd__fill_2
X_05072_ mac_inst.z\[0\] VGND VGND VPWR VPWR _04796_ sky130_fd_sc_hd__inv_2
XFILLER_0_110_333 VGND VGND VPWR VPWR sky130_fd_sc_hd__decap_4
X_08900_ _01525_ _03643_ _03644_ _03640_ VGND VGND VPWR VPWR _03645_ sky130_fd_sc_hd__o211a_2
X_09880_ _04552_ _04555_ _04597_ VGND VGND VPWR VPWR _04600_ sky130_fd_sc_hd__or3_2
X_08831_ tanh_inst.divider.x\[-20\] tanh_inst.divider.x\[-19\] tanh_inst.LOOKUP.index\[0\]
+ VGND VGND VPWR VPWR _03577_ sky130_fd_sc_hd__mux2_1
XPHY_EDGE_ROW_29_Left_151 VGND VGND VPWR VPWR sky130_fd_sc_hd__decap_3
X_08762_ tanh_inst.LOOKUP.index\[4\] tanh_inst.divider.x\[7\] _02020_ VGND VGND VPWR
+ VPWR _03508_ sky130_fd_sc_hd__or3b_2
X_05974_ mac_inst.i\[2\] _00691_ _00717_ _00847_ VGND VGND VPWR VPWR _00930_ sky130_fd_sc_hd__or4_2
X_08693_ _04769_ _03470_ VGND VGND VPWR VPWR _03472_ sky130_fd_sc_hd__xnor2_2
X_07713_ _02373_ _02375_ _02424_ _02474_ VGND VGND VPWR VPWR _02516_ sky130_fd_sc_hd__and4b_2
X_07644_ _02393_ _02395_ _02446_ VGND VGND VPWR VPWR _02448_ sky130_fd_sc_hd__or3_2
XFILLER_0_18_3 VPWR VGND VPWR VGND sky130_ef_sc_hd__decap_12
XFILLER_0_79_169 VGND VGND VPWR VPWR sky130_fd_sc_hd__decap_3
XTAP_TAPCELL_ROW_0_246 VGND VPWR sky130_fd_sc_hd__tapvpwrvgnd_1
XTAP_TAPCELL_ROW_0_257 VGND VPWR sky130_fd_sc_hd__tapvpwrvgnd_1
XTAP_TAPCELL_ROW_0_268 VGND VPWR sky130_fd_sc_hd__tapvpwrvgnd_1
XFILLER_0_48_501 VPWR VGND VPWR VGND sky130_ef_sc_hd__decap_12
XFILLER_0_94_139 VGND VGND VPWR VPWR sky130_fd_sc_hd__fill_1
XFILLER_0_94_128 VGND VGND VPWR VPWR sky130_fd_sc_hd__fill_2
X_07575_ _02329_ _02330_ _02327_ VGND VGND VPWR VPWR _02381_ sky130_fd_sc_hd__a21o_2
XFILLER_0_48_545 VGND VGND VPWR VPWR sky130_fd_sc_hd__fill_1
X_06526_ _01441_ _01443_ VGND VGND VPWR VPWR _01444_ sky130_fd_sc_hd__xor2_2
X_09314_ tanh_inst.divider.y\[-14\] _04049_ VGND VGND VPWR VPWR _04050_ sky130_fd_sc_hd__nand2_2
XPHY_EDGE_ROW_38_Left_160 VGND VGND VPWR VPWR sky130_fd_sc_hd__decap_3
X_06457_ tanh_inst.divider.y_\[-1\] _01380_ VGND VGND VPWR VPWR _01381_ sky130_fd_sc_hd__xor2_2
X_09245_ tanh_inst.divider.y\[-16\] _03981_ VGND VGND VPWR VPWR _03983_ sky130_fd_sc_hd__nand2_2
XFILLER_0_48_589 VGND VGND VPWR VPWR sky130_fd_sc_hd__decap_3
XFILLER_0_105_105 VGND VGND VPWR VPWR sky130_fd_sc_hd__decap_6
XFILLER_0_63_559 VGND VGND VPWR VPWR sky130_fd_sc_hd__fill_1
X_05408_ mac_inst.i\[3\] _04788_ VGND VGND VPWR VPWR _00412_ sky130_fd_sc_hd__nand2_2
X_06388_ _01316_ _01317_ VGND VGND VPWR VPWR _01318_ sky130_fd_sc_hd__xor2_2
XFILLER_0_105_149 VPWR VGND VPWR VGND sky130_ef_sc_hd__decap_12
X_09176_ _02022_ _03914_ _02052_ VGND VGND VPWR VPWR _03915_ sky130_fd_sc_hd__o21a_2
XFILLER_0_16_475 VGND VGND VPWR VPWR sky130_fd_sc_hd__fill_1
X_08127_ _04771_ _02015_ VGND VGND VPWR VPWR _02921_ sky130_fd_sc_hd__nand2_2
X_05339_ _04858_ _04863_ _04864_ _04866_ mac_inst.i\[1\] mac_inst.i\[0\] VGND VGND
+ VPWR VPWR _00347_ sky130_fd_sc_hd__mux4_2
X_08058_ _02851_ _02852_ VGND VGND VPWR VPWR _02853_ sky130_fd_sc_hd__or2_2
X_07009_ _01038_ _01767_ VGND VGND VPWR VPWR _01846_ sky130_fd_sc_hd__nand2_2
XFILLER_0_113_193 VGND VGND VPWR VPWR sky130_fd_sc_hd__decap_6
XFILLER_0_101_355 VGND VGND VPWR VPWR sky130_fd_sc_hd__fill_1
XFILLER_0_101_333 VGND VGND VPWR VPWR sky130_fd_sc_hd__decap_3
X_10020_ _04714_ _04718_ _04734_ VGND VGND VPWR VPWR _04735_ sky130_fd_sc_hd__a21oi_2
XTAP_TAPCELL_ROW_8_368 VGND VPWR sky130_fd_sc_hd__tapvpwrvgnd_1
XTAP_TAPCELL_ROW_8_357 VGND VPWR sky130_fd_sc_hd__tapvpwrvgnd_1
XFILLER_0_98_445 VPWR VGND VPWR VGND sky130_ef_sc_hd__decap_12
XTAP_TAPCELL_ROW_55_952 VGND VPWR sky130_fd_sc_hd__tapvpwrvgnd_1
XFILLER_0_85_128 VGND VGND VPWR VPWR sky130_fd_sc_hd__fill_2
XFILLER_0_94_640 VGND VGND VPWR VPWR sky130_fd_sc_hd__decap_4
XFILLER_0_93_161 VGND VGND VPWR VPWR sky130_fd_sc_hd__decap_6
XFILLER_0_54_515 VGND VGND VPWR VPWR sky130_fd_sc_hd__fill_1
XFILLER_0_62_570 VGND VGND VPWR VPWR sky130_fd_sc_hd__fill_1
XFILLER_0_78_29 VGND VGND VPWR VPWR sky130_fd_sc_hd__fill_2
XFILLER_0_34_294 VGND VGND VPWR VPWR sky130_fd_sc_hd__decap_4
XFILLER_0_1_317 VPWR VGND VPWR VGND sky130_ef_sc_hd__decap_12
XFILLER_0_22_456 VGND VGND VPWR VPWR sky130_fd_sc_hd__fill_2
XFILLER_0_10_629 VGND VGND VPWR VPWR sky130_fd_sc_hd__fill_2
XFILLER_0_120_697 VGND VGND VPWR VPWR sky130_fd_sc_hd__decap_3
X_10218_ clknet_leaf_30_clk mac_inst.y\[12\] _00000_ VGND VGND VPWR VPWR mac_y_out[12]
+ sky130_fd_sc_hd__dfrtp_2
XFILLER_0_27_55 VGND VGND VPWR VPWR sky130_fd_sc_hd__fill_1
XFILLER_0_89_445 VGND VGND VPWR VPWR sky130_fd_sc_hd__decap_3
XTAP_TAPCELL_ROW_85_1324 VGND VPWR sky130_fd_sc_hd__tapvpwrvgnd_1
XFILLER_0_89_467 VGND VGND VPWR VPWR sky130_fd_sc_hd__fill_1
X_05690_ mac_inst.z\[31\] _04980_ _00666_ _04944_ VGND VGND VPWR VPWR _00668_ sky130_fd_sc_hd__o22a_2
XFILLER_0_119_208 VGND VGND VPWR VPWR sky130_fd_sc_hd__decap_8
XFILLER_0_76_139 VGND VGND VPWR VPWR sky130_fd_sc_hd__fill_1
X_07360_ _02139_ _02155_ _02168_ VGND VGND VPWR VPWR _02169_ sky130_fd_sc_hd__and3_2
XFILLER_0_69_191 VPWR VGND VPWR VGND sky130_ef_sc_hd__decap_12
X_06311_ tanh_inst.divider.y\[-13\] tanh_inst.div_en tanh_inst.divider.y_\[-13\] _01092_
+ _01246_ VGND VGND VPWR VPWR _00097_ sky130_fd_sc_hd__a221o_2
XFILLER_0_57_386 VGND VGND VPWR VPWR sky130_fd_sc_hd__decap_6
XFILLER_0_17_217 VGND VGND VPWR VPWR sky130_fd_sc_hd__decap_6
XTAP_TAPCELL_ROW_33_679 VGND VPWR sky130_fd_sc_hd__tapvpwrvgnd_1
XFILLER_0_115_414 VGND VGND VPWR VPWR sky130_fd_sc_hd__fill_1
X_07291_ tanh_inst.divider.y\[-24\] _02099_ VGND VGND VPWR VPWR _02101_ sky130_fd_sc_hd__nand2_2
XFILLER_0_72_345 VPWR VGND VPWR VGND sky130_ef_sc_hd__decap_12
X_09030_ _03771_ _03772_ VGND VGND VPWR VPWR _03773_ sky130_fd_sc_hd__xnor2_2
X_06242_ _01167_ _01170_ VGND VGND VPWR VPWR _01183_ sky130_fd_sc_hd__and2_2
XFILLER_0_4_133 VGND VGND VPWR VPWR sky130_fd_sc_hd__decap_6
XFILLER_0_25_261 VPWR VGND VPWR VGND sky130_ef_sc_hd__decap_12
X_06173_ _01115_ _01116_ tanh_inst.divider.i\[2\] VGND VGND VPWR VPWR _01117_ sky130_fd_sc_hd__mux2_1
XTAP_TAPCELL_ROW_96_1464 VGND VPWR sky130_fd_sc_hd__tapvpwrvgnd_1
X_05124_ _04824_ _04831_ VGND VGND VPWR VPWR _00121_ sky130_fd_sc_hd__nor2_2
XFILLER_0_4_177 VPWR VGND VPWR VGND sky130_ef_sc_hd__decap_12
XFILLER_0_110_141 VGND VGND VPWR VPWR sky130_fd_sc_hd__decap_4
X_09932_ tanh_inst.divider.y\[4\] _04649_ VGND VGND VPWR VPWR _04650_ sky130_fd_sc_hd__and2_2
X_05055_ current_state\[0\] VGND VGND VPWR VPWR _04779_ sky130_fd_sc_hd__inv_2
XFILLER_0_40_275 VGND VGND VPWR VPWR sky130_fd_sc_hd__decap_6
XFILLER_0_110_152 VGND VGND VPWR VPWR sky130_fd_sc_hd__decap_3
XFILLER_0_0_361 VGND VGND VPWR VPWR sky130_fd_sc_hd__decap_3
XTAP_TAPCELL_ROW_5_327 VGND VPWR sky130_fd_sc_hd__tapvpwrvgnd_1
X_09863_ _04577_ _04578_ _04582_ VGND VGND VPWR VPWR _04583_ sky130_fd_sc_hd__or3_2
X_08814_ tanh_inst.divider.x\[-7\] _02028_ _03508_ VGND VGND VPWR VPWR _03560_ sky130_fd_sc_hd__o21a_2
X_09794_ _02053_ _03954_ _04193_ VGND VGND VPWR VPWR _04516_ sky130_fd_sc_hd__o21a_2
X_08745_ _03501_ _03502_ VGND VGND VPWR VPWR _00285_ sky130_fd_sc_hd__nor2_2
X_05957_ _04795_ _00911_ _00914_ VGND VGND VPWR VPWR _00915_ sky130_fd_sc_hd__o21ai_2
X_08676_ tanh_inst.divider.x\[6\] _03445_ VGND VGND VPWR VPWR _03456_ sky130_fd_sc_hd__xnor2_2
X_05888_ _00799_ _00838_ _00840_ VGND VGND VPWR VPWR _00851_ sky130_fd_sc_hd__and3_2
X_07627_ _02018_ _02431_ _02015_ VGND VGND VPWR VPWR _02432_ sky130_fd_sc_hd__a21o_2
XTAP_TAPCELL_ROW_52_911 VGND VPWR sky130_fd_sc_hd__tapvpwrvgnd_1
XTAP_TAPCELL_ROW_105_1571 VGND VPWR sky130_fd_sc_hd__tapvpwrvgnd_1
X_07558_ _02304_ _02308_ _02362_ VGND VGND VPWR VPWR _02364_ sky130_fd_sc_hd__or3_2
X_06509_ tanh_inst.divider.y\[3\] tanh_inst.div_en tanh_inst.divider.y_\[3\] _01092_
+ VGND VGND VPWR VPWR _01429_ sky130_fd_sc_hd__a22o_2
X_07489_ _02227_ _02228_ _02231_ VGND VGND VPWR VPWR _02296_ sky130_fd_sc_hd__a21oi_2
X_09228_ _03868_ _03884_ _03927_ _03965_ VGND VGND VPWR VPWR _03966_ sky130_fd_sc_hd__a31o_2
XFILLER_0_91_687 VGND VGND VPWR VPWR sky130_fd_sc_hd__fill_1
XFILLER_0_51_529 VGND VGND VPWR VPWR sky130_fd_sc_hd__decap_8
XFILLER_0_106_458 VGND VGND VPWR VPWR sky130_fd_sc_hd__decap_8
X_09159_ _01480_ _03706_ _03709_ _01486_ _03898_ VGND VGND VPWR VPWR _03899_ sky130_fd_sc_hd__o221a_2
XFILLER_0_31_220 VGND VGND VPWR VPWR sky130_fd_sc_hd__decap_4
XFILLER_0_44_570 VGND VGND VPWR VPWR sky130_fd_sc_hd__fill_1
XFILLER_0_121_428 VGND VGND VPWR VPWR sky130_fd_sc_hd__fill_1
XFILLER_0_31_242 VGND VGND VPWR VPWR sky130_fd_sc_hd__fill_1
XFILLER_0_7_3 VPWR VGND VPWR VGND sky130_ef_sc_hd__decap_12
X_10003_ tanh_inst.divider.y\[6\] _04713_ VGND VGND VPWR VPWR _04719_ sky130_fd_sc_hd__xnor2_2
XFILLER_0_104_15 VPWR VGND VPWR VGND sky130_ef_sc_hd__decap_12
XTAP_TAPCELL_ROW_67_1098 VGND VPWR sky130_fd_sc_hd__tapvpwrvgnd_1
XFILLER_0_66_172 VGND VGND VPWR VPWR sky130_fd_sc_hd__decap_4
XFILLER_0_13_57 VPWR VGND VPWR VGND sky130_ef_sc_hd__decap_12
XTAP_TAPCELL_ROW_80_1265 VGND VPWR sky130_fd_sc_hd__tapvpwrvgnd_1
XFILLER_0_27_537 VPWR VGND VPWR VGND sky130_ef_sc_hd__decap_12
XTAP_TAPCELL_ROW_30_638 VGND VPWR sky130_fd_sc_hd__tapvpwrvgnd_1
XFILLER_0_54_356 VGND VGND VPWR VPWR sky130_fd_sc_hd__decap_8
XFILLER_0_14_209 VPWR VGND VPWR VGND sky130_ef_sc_hd__decap_12
XFILLER_0_23_721 VGND VGND VPWR VPWR sky130_fd_sc_hd__decap_3
XTAP_TAPCELL_ROW_10_384 VGND VPWR sky130_fd_sc_hd__tapvpwrvgnd_1
XFILLER_0_1_125 VPWR VGND VPWR VGND sky130_ef_sc_hd__decap_12
XFILLER_0_22_253 VPWR VGND VPWR VGND sky130_ef_sc_hd__decap_12
XFILLER_0_10_404 VGND VGND VPWR VPWR sky130_fd_sc_hd__fill_2
XFILLER_0_10_448 VGND VGND VPWR VPWR sky130_fd_sc_hd__fill_1
XFILLER_0_1_169 VPWR VGND VPWR VGND sky130_ef_sc_hd__decap_12
XFILLER_0_38_54 VGND VGND VPWR VPWR sky130_fd_sc_hd__fill_1
XTAP_TAPCELL_ROW_91_1394 VGND VPWR sky130_fd_sc_hd__tapvpwrvgnd_1
X_06860_ tanh_inst.z_\[3\] tanh_inst.z_\[2\] _01667_ VGND VGND VPWR VPWR _01747_ sky130_fd_sc_hd__o21ai_2
XFILLER_0_38_65 VPWR VGND VPWR VGND sky130_ef_sc_hd__decap_12
X_05811_ _00753_ _00767_ _00766_ VGND VGND VPWR VPWR _00780_ sky130_fd_sc_hd__a21o_2
X_06791_ mac_y_out[19] _01469_ _01502_ _01686_ VGND VGND VPWR VPWR _00147_ sky130_fd_sc_hd__a22o_2
XTAP_TAPCELL_ROW_38_738 VGND VPWR sky130_fd_sc_hd__tapvpwrvgnd_1
XFILLER_0_54_64 VGND VGND VPWR VPWR sky130_fd_sc_hd__decap_3
X_05742_ _04908_ _04932_ _04935_ VGND VGND VPWR VPWR _00716_ sky130_fd_sc_hd__a21oi_2
X_08530_ _03312_ _03313_ VGND VGND VPWR VPWR _03314_ sky130_fd_sc_hd__nor2_2
XFILLER_0_89_297 VPWR VGND VPWR VGND sky130_ef_sc_hd__decap_12
X_08461_ _03240_ _03245_ VGND VGND VPWR VPWR _03247_ sky130_fd_sc_hd__nand2_2
X_05673_ _00652_ _00653_ VGND VGND VPWR VPWR _00654_ sky130_fd_sc_hd__xnor2_2
X_07412_ _02084_ _02089_ _02091_ _02086_ _04760_ _04761_ VGND VGND VPWR VPWR _02220_
+ sky130_fd_sc_hd__mux4_2
XFILLER_0_58_651 VGND VGND VPWR VPWR sky130_fd_sc_hd__decap_3
XFILLER_0_9_225 VPWR VGND VPWR VGND sky130_ef_sc_hd__decap_12
XTAP_TAPCELL_ROW_18_484 VGND VPWR sky130_fd_sc_hd__tapvpwrvgnd_1
XFILLER_0_57_150 VGND VGND VPWR VPWR sky130_fd_sc_hd__decap_3
X_08392_ tanh_inst.divider.y\[-1\] _03178_ VGND VGND VPWR VPWR _03179_ sky130_fd_sc_hd__nor2_2
XFILLER_0_45_301 VGND VGND VPWR VPWR sky130_fd_sc_hd__decap_8
XFILLER_0_116_701 VGND VGND VPWR VPWR sky130_fd_sc_hd__decap_4
X_07343_ tanh_inst.divider.y\[-23\] tanh_inst.divider.y\[-22\] tanh_inst.LOOKUP.index\[0\]
+ VGND VGND VPWR VPWR _02152_ sky130_fd_sc_hd__mux2_1
XFILLER_0_70_85 VGND VGND VPWR VPWR sky130_fd_sc_hd__decap_6
XFILLER_0_45_334 VGND VGND VPWR VPWR sky130_fd_sc_hd__fill_2
XFILLER_0_73_665 VGND VGND VPWR VPWR sky130_fd_sc_hd__fill_1
X_07274_ tanh_inst.divider.y\[-3\] _02028_ _02029_ VGND VGND VPWR VPWR _02084_ sky130_fd_sc_hd__o21ai_2
X_06225_ tanh_inst.divider.y_\[-19\] _01165_ VGND VGND VPWR VPWR _01167_ sky130_fd_sc_hd__or2_2
X_09013_ tanh_inst.z_\[7\] _03748_ _03755_ VGND VGND VPWR VPWR _03756_ sky130_fd_sc_hd__a21o_2
XFILLER_0_85_3 VGND VGND VPWR VPWR sky130_fd_sc_hd__decap_8
XFILLER_0_72_197 VGND VGND VPWR VPWR sky130_fd_sc_hd__decap_4
XFILLER_0_14_721 VGND VGND VPWR VPWR sky130_fd_sc_hd__decap_3
XFILLER_0_115_288 VGND VGND VPWR VPWR sky130_fd_sc_hd__decap_6
XFILLER_0_115_277 VGND VGND VPWR VPWR sky130_fd_sc_hd__decap_3
X_06156_ tanh_inst.divider.x\[-22\] tanh_inst.divider.x\[-21\] tanh_inst.divider.x\[-20\]
+ tanh_inst.divider.x\[-19\] tanh_inst.divider.i\[0\] tanh_inst.divider.i\[1\] VGND
+ VGND VPWR VPWR _01101_ sky130_fd_sc_hd__mux4_2
X_06087_ tanh_inst.divider.i\[1\] tanh_inst.divider.i\[0\] VGND VGND VPWR VPWR _01034_
+ sky130_fd_sc_hd__or2_2
X_05107_ mac_counter\[4\] _04819_ mac_counter\[6\] mac_counter\[5\] VGND VGND VPWR
+ VPWR _04820_ sky130_fd_sc_hd__a211o_2
X_05038_ tanh_inst.divider.y\[7\] VGND VGND VPWR VPWR _04762_ sky130_fd_sc_hd__inv_2
X_09915_ _04632_ tanh_inst.divider.y\[3\] VGND VGND VPWR VPWR _04634_ sky130_fd_sc_hd__nand2b_2
X_09846_ _04508_ _04566_ VGND VGND VPWR VPWR _04567_ sky130_fd_sc_hd__nand2_2
X_06989_ _01827_ _01828_ tanh_inst.divider.z_\[-18\] _01092_ VGND VGND VPWR VPWR _00203_
+ sky130_fd_sc_hd__a2bb2o_2
XTAP_TAPCELL_ROW_107_1600 VGND VPWR sky130_fd_sc_hd__tapvpwrvgnd_1
X_09777_ _04439_ _04445_ _04498_ _02018_ VGND VGND VPWR VPWR _04500_ sky130_fd_sc_hd__o31a_2
X_08728_ mac_inst.i\[11\] mac_inst.i\[12\] _00960_ mac_inst.i\[13\] VGND VGND VPWR
+ VPWR _03493_ sky130_fd_sc_hd__a31o_2
X_08659_ _03437_ _03438_ VGND VGND VPWR VPWR _03439_ sky130_fd_sc_hd__xnor2_2
XFILLER_0_48_150 VGND VGND VPWR VPWR sky130_fd_sc_hd__decap_8
XFILLER_0_119_561 VGND VGND VPWR VPWR sky130_fd_sc_hd__decap_4
XFILLER_0_64_643 VGND VGND VPWR VPWR sky130_fd_sc_hd__fill_1
XFILLER_0_36_345 VGND VGND VPWR VPWR sky130_fd_sc_hd__decap_6
XFILLER_0_63_164 VGND VGND VPWR VPWR sky130_fd_sc_hd__decap_4
XFILLER_0_24_529 VGND VGND VPWR VPWR sky130_fd_sc_hd__decap_3
XFILLER_0_121_225 VPWR VGND VPWR VGND sky130_ef_sc_hd__decap_12
XTAP_TAPCELL_ROW_118_1740 VGND VPWR sky130_fd_sc_hd__tapvpwrvgnd_1
X_10483_ clknet_leaf_33_clk _00340_ _00084_ VGND VGND VPWR VPWR tanh_counter\[6\]
+ sky130_fd_sc_hd__dfrtp_2
XTAP_TAPCELL_ROW_69_1127 VGND VPWR sky130_fd_sc_hd__tapvpwrvgnd_1
XFILLER_0_59_437 VGND VGND VPWR VPWR sky130_fd_sc_hd__decap_8
XFILLER_0_115_69 VPWR VGND VPWR VGND sky130_ef_sc_hd__decap_12
XFILLER_0_74_429 VGND VGND VPWR VPWR sky130_fd_sc_hd__fill_2
XTAP_TAPCELL_ROW_15_454 VGND VPWR sky130_fd_sc_hd__tapvpwrvgnd_1
XTAP_TAPCELL_ROW_43_796 VGND VPWR sky130_fd_sc_hd__tapvpwrvgnd_1
XFILLER_0_82_473 VGND VGND VPWR VPWR sky130_fd_sc_hd__decap_3
XFILLER_0_82_451 VGND VGND VPWR VPWR sky130_fd_sc_hd__fill_1
XFILLER_0_82_484 VGND VGND VPWR VPWR sky130_fd_sc_hd__fill_1
XFILLER_0_54_197 VGND VGND VPWR VPWR sky130_fd_sc_hd__fill_2
XFILLER_0_54_186 VGND VGND VPWR VPWR sky130_fd_sc_hd__decap_8
XFILLER_0_2_401 VGND VGND VPWR VPWR sky130_fd_sc_hd__decap_8
X_06010_ mac_inst.i\[15\] mac_inst.i\[17\] _00963_ VGND VGND VPWR VPWR _00964_ sky130_fd_sc_hd__and3_2
XTAP_TAPCELL_ROW_93_1423 VGND VPWR sky130_fd_sc_hd__tapvpwrvgnd_1
XFILLER_0_11_702 VGND VGND VPWR VPWR sky130_fd_sc_hd__fill_1
XFILLER_0_50_381 VGND VGND VPWR VPWR sky130_fd_sc_hd__fill_2
X_07961_ _02692_ _02695_ _02756_ VGND VGND VPWR VPWR _02758_ sky130_fd_sc_hd__o21ai_2
XFILLER_0_10_245 VGND VGND VPWR VPWR sky130_fd_sc_hd__decap_6
X_06912_ tanh_inst.div_en tanh_inst.divider.z_\[-6\] VGND VGND VPWR VPWR _00183_ sky130_fd_sc_hd__and2b_2
XFILLER_0_10_289 VPWR VGND VPWR VGND sky130_ef_sc_hd__decap_12
X_09700_ _02018_ _04424_ VGND VGND VPWR VPWR _04425_ sky130_fd_sc_hd__nor2_2
X_07892_ _02022_ _02342_ _02488_ VGND VGND VPWR VPWR _02690_ sky130_fd_sc_hd__o21ai_2
X_06843_ tanh_inst.z_\[2\] _01667_ VGND VGND VPWR VPWR _01732_ sky130_fd_sc_hd__nor2_2
XFILLER_0_4_77 VGND VGND VPWR VPWR sky130_fd_sc_hd__decap_6
X_09631_ tanh_inst.divider.y\[-5\] _04356_ VGND VGND VPWR VPWR _04358_ sky130_fd_sc_hd__and2_2
XFILLER_0_65_96 VGND VGND VPWR VPWR sky130_fd_sc_hd__fill_1
X_06774_ mac_y_out[17] _01469_ _01502_ _01671_ VGND VGND VPWR VPWR _00145_ sky130_fd_sc_hd__a22o_2
X_09562_ tanh_inst.divider.y\[-7\] _04290_ VGND VGND VPWR VPWR _04291_ sky130_fd_sc_hd__nand2_2
X_05725_ _00699_ _00700_ VGND VGND VPWR VPWR _00701_ sky130_fd_sc_hd__nand2_2
X_08513_ tanh_inst.divider.y\[2\] tanh_inst.divider.x\[2\] VGND VGND VPWR VPWR _03297_
+ sky130_fd_sc_hd__nor2_2
X_09493_ _04154_ _04167_ _04168_ _04217_ _04222_ VGND VGND VPWR VPWR _04223_ sky130_fd_sc_hd__o41a_2
XFILLER_0_77_256 VPWR VGND VPWR VGND sky130_ef_sc_hd__decap_12
XFILLER_0_65_429 VGND VGND VPWR VPWR sky130_fd_sc_hd__fill_2
XFILLER_0_18_301 VGND VGND VPWR VPWR sky130_fd_sc_hd__decap_6
X_05656_ _00637_ _00638_ VGND VGND VPWR VPWR _00639_ sky130_fd_sc_hd__nand2_2
X_08444_ _03199_ _03228_ VGND VGND VPWR VPWR _03230_ sky130_fd_sc_hd__and2_2
XFILLER_0_108_509 VGND VGND VPWR VPWR sky130_fd_sc_hd__fill_2
XTAP_TAPCELL_ROW_102_1541 VGND VPWR sky130_fd_sc_hd__tapvpwrvgnd_1
X_08375_ tanh_inst.divider.x\[-2\] _02014_ _03162_ _01470_ VGND VGND VPWR VPWR _00255_
+ sky130_fd_sc_hd__o211a_2
X_05587_ _00524_ _00555_ _00561_ _00569_ VGND VGND VPWR VPWR _00576_ sky130_fd_sc_hd__and4_2
XFILLER_0_46_621 VGND VGND VPWR VPWR sky130_fd_sc_hd__decap_4
XFILLER_0_46_643 VGND VGND VPWR VPWR sky130_fd_sc_hd__fill_1
X_07326_ _02085_ _02090_ _02092_ _02088_ _04760_ _04761_ VGND VGND VPWR VPWR _02135_
+ sky130_fd_sc_hd__mux4_2
XFILLER_0_18_345 VGND VGND VPWR VPWR sky130_fd_sc_hd__decap_6
XFILLER_0_61_635 VGND VGND VPWR VPWR sky130_fd_sc_hd__fill_1
XFILLER_0_60_101 VPWR VGND VPWR VGND sky130_ef_sc_hd__decap_12
XFILLER_0_33_326 VGND VGND VPWR VPWR sky130_fd_sc_hd__fill_1
XFILLER_0_104_715 VGND VGND VPWR VPWR sky130_fd_sc_hd__decap_8
X_07257_ tanh_inst.divider.y\[4\] _02028_ _02029_ VGND VGND VPWR VPWR _02067_ sky130_fd_sc_hd__o21a_2
XFILLER_0_61_657 VGND VGND VPWR VPWR sky130_fd_sc_hd__fill_2
XFILLER_0_5_261 VPWR VGND VPWR VGND sky130_ef_sc_hd__decap_12
XFILLER_0_33_359 VPWR VGND VPWR VGND sky130_ef_sc_hd__decap_12
X_07188_ tanh_inst.divider.z_\[6\] _01975_ VGND VGND VPWR VPWR _02004_ sky130_fd_sc_hd__or2_2
X_06208_ tanh_inst.divider.y_\[-20\] _01149_ VGND VGND VPWR VPWR _01151_ sky130_fd_sc_hd__or2_2
XFILLER_0_103_225 VGND VGND VPWR VPWR sky130_fd_sc_hd__fill_2
XFILLER_0_60_167 VGND VGND VPWR VPWR sky130_fd_sc_hd__decap_8
XFILLER_0_14_573 VGND VGND VPWR VPWR sky130_fd_sc_hd__decap_8
X_06139_ _01083_ _01084_ VGND VGND VPWR VPWR _01085_ sky130_fd_sc_hd__xor2_2
XTAP_TAPCELL_ROW_113_1670 VGND VPWR sky130_fd_sc_hd__tapvpwrvgnd_1
X_09829_ _04538_ _04541_ _04549_ VGND VGND VPWR VPWR _04550_ sky130_fd_sc_hd__a21oi_2
XTAP_TAPCELL_ROW_64_1057 VGND VPWR sky130_fd_sc_hd__tapvpwrvgnd_1
XFILLER_0_83_237 VGND VGND VPWR VPWR sky130_fd_sc_hd__decap_8
XTAP_TAPCELL_ROW_64_1068 VGND VPWR sky130_fd_sc_hd__tapvpwrvgnd_1
XFILLER_0_49_481 VGND VGND VPWR VPWR sky130_fd_sc_hd__fill_2
XTAP_TAPCELL_ROW_12_413 VGND VPWR sky130_fd_sc_hd__tapvpwrvgnd_1
XFILLER_0_91_281 VGND VGND VPWR VPWR sky130_fd_sc_hd__decap_8
XTAP_TAPCELL_ROW_40_766 VGND VPWR sky130_fd_sc_hd__tapvpwrvgnd_1
XFILLER_0_107_597 VGND VGND VPWR VPWR sky130_fd_sc_hd__decap_3
XFILLER_0_101_27 VPWR VGND VPWR VGND sky130_ef_sc_hd__decap_12
X_10466_ clknet_leaf_43_clk _00323_ VGND VGND VPWR VPWR tanh_inst.divider.y\[2\] sky130_fd_sc_hd__dfxtp_2
XFILLER_0_51_167 VGND VGND VPWR VPWR sky130_fd_sc_hd__fill_1
XFILLER_0_102_280 VGND VGND VPWR VPWR sky130_fd_sc_hd__decap_4
X_10397_ clknet_leaf_39_clk _00254_ VGND VGND VPWR VPWR tanh_inst.divider.x\[-3\]
+ sky130_fd_sc_hd__dfxtp_2
XTAP_TAPCELL_ROW_75_1197 VGND VPWR sky130_fd_sc_hd__tapvpwrvgnd_1
XFILLER_0_59_201 VGND VGND VPWR VPWR sky130_fd_sc_hd__fill_1
XTAP_TAPCELL_ROW_48_866 VGND VPWR sky130_fd_sc_hd__tapvpwrvgnd_1
X_06490_ _01385_ _01386_ _01401_ _04793_ VGND VGND VPWR VPWR _01411_ sky130_fd_sc_hd__o31a_2
XFILLER_0_87_576 VGND VGND VPWR VPWR sky130_fd_sc_hd__decap_3
X_05510_ _00504_ _00506_ _00503_ VGND VGND VPWR VPWR _00507_ sky130_fd_sc_hd__a21o_2
XFILLER_0_74_248 VGND VGND VPWR VPWR sky130_fd_sc_hd__decap_4
X_05441_ _00419_ _00420_ _00431_ mac_inst.z\[31\] VGND VGND VPWR VPWR _00443_ sky130_fd_sc_hd__a31o_2
XFILLER_0_27_142 VGND VGND VPWR VPWR sky130_fd_sc_hd__decap_8
X_08160_ _02018_ _02943_ _02951_ _02952_ _02014_ VGND VGND VPWR VPWR _02953_ sky130_fd_sc_hd__o221ai_2
X_07111_ _01916_ _01926_ VGND VGND VPWR VPWR _01937_ sky130_fd_sc_hd__nand2_2
XFILLER_0_70_421 VGND VGND VPWR VPWR sky130_fd_sc_hd__decap_4
XFILLER_0_7_559 VGND VGND VPWR VPWR sky130_fd_sc_hd__fill_1
X_05372_ _00376_ _00378_ VGND VGND VPWR VPWR _00379_ sky130_fd_sc_hd__xnor2_2
XFILLER_0_113_501 VGND VGND VPWR VPWR sky130_fd_sc_hd__decap_3
X_08091_ _02711_ _02712_ _02764_ _02883_ VGND VGND VPWR VPWR _02885_ sky130_fd_sc_hd__or4_2
XFILLER_0_3_721 VGND VGND VPWR VPWR sky130_fd_sc_hd__decap_3
XFILLER_0_15_337 VPWR VGND VPWR VGND sky130_ef_sc_hd__decap_12
XFILLER_0_113_545 VGND VGND VPWR VPWR sky130_fd_sc_hd__fill_1
Xclkload30 clknet_leaf_13_clk VGND VGND VPWR VPWR clkload30/Y sky130_fd_sc_hd__inv_12
X_07042_ _01874_ _01875_ VGND VGND VPWR VPWR _01876_ sky130_fd_sc_hd__nor2_2
Xclkload41 clknet_leaf_25_clk VGND VGND VPWR VPWR clkload41/Y sky130_fd_sc_hd__inv_6
XFILLER_0_2_253 VPWR VGND VPWR VGND sky130_ef_sc_hd__decap_12
X_08993_ _03550_ _03552_ _03554_ _03564_ _04761_ tanh_inst.LOOKUP.index\[1\] VGND
+ VGND VPWR VPWR _03736_ sky130_fd_sc_hd__mux4_2
XFILLER_0_11_587 VPWR VGND VPWR VGND sky130_ef_sc_hd__decap_12
XPHY_EDGE_ROW_10_Left_132 VGND VGND VPWR VPWR sky130_fd_sc_hd__decap_3
X_07944_ _02649_ _02685_ VGND VGND VPWR VPWR _02742_ sky130_fd_sc_hd__nor2_2
XFILLER_0_48_3 VPWR VGND VPWR VGND sky130_ef_sc_hd__decap_12
X_07875_ _02633_ _02637_ _02673_ VGND VGND VPWR VPWR _02674_ sky130_fd_sc_hd__a21oi_2
X_06826_ _01716_ _01717_ VGND VGND VPWR VPWR _01718_ sky130_fd_sc_hd__xor2_2
X_09614_ _04317_ _04319_ _04340_ VGND VGND VPWR VPWR _04341_ sky130_fd_sc_hd__nor3_2
X_06757_ tanh_inst.z_\[7\] _01655_ _01654_ VGND VGND VPWR VPWR _01656_ sky130_fd_sc_hd__o21ai_2
X_09545_ _04244_ _04247_ _04272_ tanh_inst.z_\[7\] VGND VGND VPWR VPWR _04274_ sky130_fd_sc_hd__a31o_2
X_09476_ _02851_ _02852_ _04196_ VGND VGND VPWR VPWR _04207_ sky130_fd_sc_hd__o21ai_2
X_06688_ _01584_ _01586_ _01583_ VGND VGND VPWR VPWR _01595_ sky130_fd_sc_hd__a21bo_2
XFILLER_0_65_204 VGND VGND VPWR VPWR sky130_fd_sc_hd__fill_1
X_05708_ _00678_ _00679_ mac_inst.z\[2\] VGND VGND VPWR VPWR _00685_ sky130_fd_sc_hd__a21bo_2
XFILLER_0_65_248 VGND VGND VPWR VPWR sky130_fd_sc_hd__fill_2
X_08427_ _03042_ _03211_ _03212_ _02879_ VGND VGND VPWR VPWR _03213_ sky130_fd_sc_hd__a22o_2
X_05639_ _00603_ _00614_ _00615_ VGND VGND VPWR VPWR _00624_ sky130_fd_sc_hd__o21bai_2
XFILLER_0_18_153 VPWR VGND VPWR VGND sky130_ef_sc_hd__decap_12
XFILLER_0_46_440 VGND VGND VPWR VPWR sky130_fd_sc_hd__decap_4
Xclkload2 clknet_2_2__leaf_clk VGND VGND VPWR VPWR clkload2/Y sky130_fd_sc_hd__inv_8
XFILLER_0_73_281 VGND VGND VPWR VPWR sky130_fd_sc_hd__fill_1
XFILLER_0_34_613 VGND VGND VPWR VPWR sky130_fd_sc_hd__decap_4
X_08358_ tanh_inst.divider.x\[-2\] _03129_ VGND VGND VPWR VPWR _03146_ sky130_fd_sc_hd__and2_2
XFILLER_0_18_197 VPWR VGND VPWR VGND sky130_ef_sc_hd__decap_12
X_08289_ _02920_ _02950_ _03076_ _03078_ VGND VGND VPWR VPWR _03079_ sky130_fd_sc_hd__o31a_2
X_07309_ tanh_inst.divider.y\[-8\] tanh_inst.divider.y\[-7\] tanh_inst.divider.y\[-6\]
+ tanh_inst.divider.y\[-5\] tanh_inst.LOOKUP.index\[0\] tanh_inst.LOOKUP.index\[1\]
+ VGND VGND VPWR VPWR _02119_ sky130_fd_sc_hd__mux4_2
X_10320_ clknet_leaf_21_clk _00177_ VGND VGND VPWR VPWR tanh_out[12] sky130_fd_sc_hd__dfxtp_2
XFILLER_0_21_329 VGND VGND VPWR VPWR sky130_fd_sc_hd__decap_6
XFILLER_0_33_167 VGND VGND VPWR VPWR sky130_fd_sc_hd__fill_1
X_10251_ clknet_leaf_32_clk mac_inst.x\[13\] _00000_ VGND VGND VPWR VPWR mac_x_out[13]
+ sky130_fd_sc_hd__dfrtp_2
X_10182_ x_in[8] _00000_ VGND VGND VPWR VPWR mac_inst.x\[8\] sky130_fd_sc_hd__dlxtn_1
XTAP_TAPCELL_ROW_45_825 VGND VPWR sky130_fd_sc_hd__tapvpwrvgnd_1
XFILLER_0_96_373 VGND VGND VPWR VPWR sky130_fd_sc_hd__decap_3
XFILLER_0_29_429 VGND VGND VPWR VPWR sky130_fd_sc_hd__decap_4
XFILLER_0_112_15 VPWR VGND VPWR VGND sky130_ef_sc_hd__decap_12
XTAP_TAPCELL_ROW_25_571 VGND VPWR sky130_fd_sc_hd__tapvpwrvgnd_1
XFILLER_0_25_602 VGND VGND VPWR VPWR sky130_fd_sc_hd__fill_1
XFILLER_0_37_473 VPWR VGND VPWR VGND sky130_ef_sc_hd__decap_12
XFILLER_0_114_309 VGND VGND VPWR VPWR sky130_fd_sc_hd__fill_2
XFILLER_0_21_57 VPWR VGND VPWR VGND sky130_ef_sc_hd__decap_12
XFILLER_0_24_134 VGND VGND VPWR VPWR sky130_fd_sc_hd__fill_1
XFILLER_0_25_646 VPWR VGND VPWR VGND sky130_ef_sc_hd__decap_12
XTAP_TAPCELL_ROW_77_1226 VGND VPWR sky130_fd_sc_hd__tapvpwrvgnd_1
XFILLER_0_12_307 VGND VGND VPWR VPWR sky130_fd_sc_hd__fill_1
XFILLER_0_40_605 VGND VGND VPWR VPWR sky130_fd_sc_hd__fill_1
XFILLER_0_97_39 VPWR VGND VPWR VGND sky130_ef_sc_hd__decap_12
XFILLER_0_24_189 VGND VGND VPWR VPWR sky130_fd_sc_hd__fill_1
X_10449_ clknet_leaf_9_clk _00306_ VGND VGND VPWR VPWR tanh_inst.divider.y\[-15\]
+ sky130_fd_sc_hd__dfxtp_2
X_05990_ mac_inst.z\[23\] _00931_ _00941_ _00927_ _00944_ VGND VGND VPWR VPWR _00945_
+ sky130_fd_sc_hd__a221o_2
X_07660_ _02462_ _02463_ VGND VGND VPWR VPWR _02464_ sky130_fd_sc_hd__xnor2_2
XTAP_TAPCELL_ROW_88_1366 VGND VPWR sky130_fd_sc_hd__tapvpwrvgnd_1
X_07591_ tanh_inst.divider.y\[-19\] _02394_ VGND VGND VPWR VPWR _02396_ sky130_fd_sc_hd__xor2_2
X_06611_ tanh_inst.LOOKUP.index\[4\] _04758_ VGND VGND VPWR VPWR _01524_ sky130_fd_sc_hd__nor2_2
X_09330_ tanh_inst.divider.y\[-13\] _04059_ VGND VGND VPWR VPWR _04065_ sky130_fd_sc_hd__nor2_2
X_06542_ _01457_ _01458_ VGND VGND VPWR VPWR _01459_ sky130_fd_sc_hd__nor2_2
X_09261_ _03996_ _03997_ VGND VGND VPWR VPWR _03998_ sky130_fd_sc_hd__nand2_2
XFILLER_0_75_546 VGND VGND VPWR VPWR sky130_fd_sc_hd__decap_4
XFILLER_0_75_535 VGND VGND VPWR VPWR sky130_fd_sc_hd__decap_3
XFILLER_0_117_125 VPWR VGND VPWR VGND sky130_ef_sc_hd__decap_12
X_06473_ _01372_ _01373_ _01381_ VGND VGND VPWR VPWR _01396_ sky130_fd_sc_hd__and3_2
XFILLER_0_75_568 VGND VGND VPWR VPWR sky130_fd_sc_hd__fill_2
X_08212_ _03001_ _03002_ VGND VGND VPWR VPWR _03003_ sky130_fd_sc_hd__and2_2
X_09192_ _03930_ VGND VGND VPWR VPWR _03931_ sky130_fd_sc_hd__inv_2
XFILLER_0_55_270 VGND VGND VPWR VPWR sky130_fd_sc_hd__decap_8
X_05424_ _00426_ _00427_ VGND VGND VPWR VPWR _05424_/X sky130_fd_sc_hd__xor2_2
XFILLER_0_117_169 VGND VGND VPWR VPWR sky130_fd_sc_hd__decap_3
X_08143_ tanh_inst.divider.y\[-7\] _02934_ VGND VGND VPWR VPWR _02936_ sky130_fd_sc_hd__and2_2
XFILLER_0_55_281 VGND VGND VPWR VPWR sky130_fd_sc_hd__decap_4
X_05355_ _04911_ _00362_ _00354_ _05020_ VGND VGND VPWR VPWR _00363_ sky130_fd_sc_hd__a211o_2
XFILLER_0_113_320 VGND VGND VPWR VPWR sky130_fd_sc_hd__fill_1
XTAP_TAPCELL_ROW_99_1495 VGND VPWR sky130_fd_sc_hd__tapvpwrvgnd_1
X_08074_ _02053_ _02098_ _02834_ VGND VGND VPWR VPWR _02868_ sky130_fd_sc_hd__o21a_2
XFILLER_0_15_167 VGND VGND VPWR VPWR sky130_fd_sc_hd__fill_1
XFILLER_0_31_627 VGND VGND VPWR VPWR sky130_fd_sc_hd__decap_4
X_07025_ _01850_ _01856_ _01857_ _01854_ VGND VGND VPWR VPWR _01860_ sky130_fd_sc_hd__a31o_2
X_05286_ _04984_ _04985_ mac_inst.i\[2\] VGND VGND VPWR VPWR _04986_ sky130_fd_sc_hd__mux2_1
XFILLER_0_113_375 VGND VGND VPWR VPWR sky130_fd_sc_hd__fill_2
XFILLER_0_30_159 VGND VGND VPWR VPWR sky130_fd_sc_hd__fill_1
XFILLER_0_101_559 VGND VGND VPWR VPWR sky130_fd_sc_hd__fill_1
XFILLER_0_87_83 VGND VGND VPWR VPWR sky130_fd_sc_hd__decap_6
XFILLER_0_11_373 VPWR VGND VPWR VGND sky130_ef_sc_hd__decap_12
XTAP_TAPCELL_ROW_110_1640 VGND VPWR sky130_fd_sc_hd__tapvpwrvgnd_1
X_08976_ _03718_ _03719_ VGND VGND VPWR VPWR _03720_ sky130_fd_sc_hd__xor2_2
X_07927_ _02634_ _02673_ VGND VGND VPWR VPWR _02725_ sky130_fd_sc_hd__nor2_2
X_07858_ tanh_inst.divider.x\[-13\] _02656_ VGND VGND VPWR VPWR _02657_ sky130_fd_sc_hd__and2_2
X_07789_ tanh_inst.divider.x\[-15\] _02579_ VGND VGND VPWR VPWR _02590_ sky130_fd_sc_hd__nand2_2
X_06809_ tanh_inst.LOOKUP.index\[0\] _01480_ _01515_ VGND VGND VPWR VPWR _01702_ sky130_fd_sc_hd__o21a_2
XTAP_TAPCELL_ROW_3_299 VGND VPWR sky130_fd_sc_hd__tapvpwrvgnd_1
X_09528_ _04256_ _04257_ VGND VGND VPWR VPWR _04258_ sky130_fd_sc_hd__or2_2
XFILLER_0_93_332 VGND VGND VPWR VPWR sky130_fd_sc_hd__decap_4
XTAP_TAPCELL_ROW_121_1780 VGND VPWR sky130_fd_sc_hd__tapvpwrvgnd_1
X_09459_ _02018_ _04171_ _04190_ VGND VGND VPWR VPWR _04191_ sky130_fd_sc_hd__a21oi_2
XFILLER_0_81_505 VGND VGND VPWR VPWR sky130_fd_sc_hd__decap_6
XFILLER_0_66_568 VGND VGND VPWR VPWR sky130_fd_sc_hd__decap_6
XTAP_TAPCELL_ROW_61_1027 VGND VPWR sky130_fd_sc_hd__tapvpwrvgnd_1
XTAP_TAPCELL_ROW_121_1791 VGND VPWR sky130_fd_sc_hd__tapvpwrvgnd_1
XFILLER_0_108_147 VGND VGND VPWR VPWR sky130_fd_sc_hd__fill_1
XFILLER_0_81_527 VGND VGND VPWR VPWR sky130_fd_sc_hd__decap_8
XTAP_TAPCELL_ROW_22_541 VGND VPWR sky130_fd_sc_hd__tapvpwrvgnd_1
XFILLER_0_34_421 VGND VGND VPWR VPWR sky130_fd_sc_hd__decap_3
XTAP_TAPCELL_ROW_50_883 VGND VPWR sky130_fd_sc_hd__tapvpwrvgnd_1
X_10303_ clknet_leaf_19_clk _00160_ VGND VGND VPWR VPWR tanh_inst.divider.i\[0\] sky130_fd_sc_hd__dfxtp_2
XFILLER_0_21_137 VPWR VGND VPWR VGND sky130_ef_sc_hd__decap_12
X_10234_ clknet_leaf_23_clk mac_inst.y\[28\] _00000_ VGND VGND VPWR VPWR mac_y_out[28]
+ sky130_fd_sc_hd__dfrtp_2
XTAP_TAPCELL_ROW_72_1167 VGND VPWR sky130_fd_sc_hd__tapvpwrvgnd_1
XTAP_TAPCELL_ROW_72_1156 VGND VPWR sky130_fd_sc_hd__tapvpwrvgnd_1
XFILLER_0_107_15 VPWR VGND VPWR VGND sky130_ef_sc_hd__decap_12
X_10096_ clknet_leaf_6_clk _00113_ VGND VGND VPWR VPWR tanh_inst.divider.y_\[3\] sky130_fd_sc_hd__dfxtp_2
XFILLER_0_88_137 VGND VGND VPWR VPWR sky130_fd_sc_hd__decap_3
XTAP_TAPCELL_ROW_58_983 VGND VPWR sky130_fd_sc_hd__tapvpwrvgnd_1
XFILLER_0_57_502 VGND VGND VPWR VPWR sky130_fd_sc_hd__fill_2
XFILLER_0_97_693 VGND VGND VPWR VPWR sky130_fd_sc_hd__decap_8
XFILLER_0_69_373 VPWR VGND VPWR VGND sky130_ef_sc_hd__decap_12
XFILLER_0_8_109 VPWR VGND VPWR VGND sky130_ef_sc_hd__decap_12
XFILLER_0_84_365 VPWR VGND VPWR VGND sky130_ef_sc_hd__decap_12
XTAP_TAPCELL_ROW_83_1296 VGND VPWR sky130_fd_sc_hd__tapvpwrvgnd_1
XFILLER_0_65_590 VGND VGND VPWR VPWR sky130_fd_sc_hd__decap_6
XFILLER_0_114_139 VGND VGND VPWR VPWR sky130_fd_sc_hd__fill_1
XFILLER_0_106_3 VPWR VGND VPWR VGND sky130_ef_sc_hd__decap_12
X_05140_ _04838_ _04839_ _04842_ _04843_ VGND VGND VPWR VPWR _04844_ sky130_fd_sc_hd__or4_2
XFILLER_0_52_251 VGND VGND VPWR VPWR sky130_fd_sc_hd__fill_1
X_05071_ mac_inst.z\[31\] VGND VGND VPWR VPWR _04795_ sky130_fd_sc_hd__inv_2
X_08830_ _01476_ _02108_ _03533_ _03535_ _01481_ VGND VGND VPWR VPWR _03576_ sky130_fd_sc_hd__a32o_2
XFILLER_0_0_576 VPWR VGND VPWR VGND sky130_ef_sc_hd__decap_12
X_05973_ _00925_ _00928_ VGND VGND VPWR VPWR _05973_/X sky130_fd_sc_hd__xor2_2
X_08761_ mac_inst.i\[30\] _00970_ mac_inst.i\[31\] VGND VGND VPWR VPWR _00296_ sky130_fd_sc_hd__a21boi_2
X_08692_ tanh_inst.divider.x\[7\] _03470_ VGND VGND VPWR VPWR _03471_ sky130_fd_sc_hd__xnor2_2
X_07712_ _02512_ _02514_ VGND VGND VPWR VPWR _02515_ sky130_fd_sc_hd__nand2_2
X_07643_ _02393_ _02395_ _02446_ VGND VGND VPWR VPWR _02447_ sky130_fd_sc_hd__o21ai_2
XFILLER_0_73_41 VGND VGND VPWR VPWR sky130_fd_sc_hd__decap_8
XFILLER_0_88_660 VGND VGND VPWR VPWR sky130_fd_sc_hd__fill_2
XTAP_TAPCELL_ROW_0_247 VGND VPWR sky130_fd_sc_hd__tapvpwrvgnd_1
XTAP_TAPCELL_ROW_0_258 VGND VPWR sky130_fd_sc_hd__tapvpwrvgnd_1
XFILLER_0_87_181 VGND VGND VPWR VPWR sky130_fd_sc_hd__fill_2
X_07574_ _02378_ _02379_ VGND VGND VPWR VPWR _02380_ sky130_fd_sc_hd__nor2_2
X_09313_ _04046_ _04048_ VGND VGND VPWR VPWR _04049_ sky130_fd_sc_hd__xnor2_2
XFILLER_0_48_513 VGND VGND VPWR VPWR sky130_fd_sc_hd__decap_4
XFILLER_0_118_412 VGND VGND VPWR VPWR sky130_fd_sc_hd__fill_2
X_06525_ _04793_ _01442_ VGND VGND VPWR VPWR _01443_ sky130_fd_sc_hd__and2_2
XFILLER_0_75_332 VGND VGND VPWR VPWR sky130_fd_sc_hd__decap_4
XFILLER_0_63_505 VPWR VGND VPWR VGND sky130_ef_sc_hd__decap_12
X_06456_ _01378_ _01379_ VGND VGND VPWR VPWR _01380_ sky130_fd_sc_hd__xor2_2
XFILLER_0_90_302 VGND VGND VPWR VPWR sky130_fd_sc_hd__decap_6
X_09244_ tanh_inst.divider.y\[-16\] _03981_ VGND VGND VPWR VPWR _03982_ sky130_fd_sc_hd__or2_2
XFILLER_0_8_643 VGND VGND VPWR VPWR sky130_fd_sc_hd__fill_1
XFILLER_0_8_632 VGND VGND VPWR VPWR sky130_fd_sc_hd__decap_6
X_09175_ _03725_ _03727_ _02025_ VGND VGND VPWR VPWR _03914_ sky130_fd_sc_hd__mux2_1
XFILLER_0_8_698 VGND VGND VPWR VPWR sky130_fd_sc_hd__fill_2
XFILLER_0_16_421 VGND VGND VPWR VPWR sky130_fd_sc_hd__decap_3
X_05407_ _00410_ _00411_ VGND VGND VPWR VPWR _05407_/X sky130_fd_sc_hd__and2_2
X_06387_ _01303_ _01308_ VGND VGND VPWR VPWR _01317_ sky130_fd_sc_hd__nand2_2
X_08126_ _02906_ _02907_ _02910_ _02918_ VGND VGND VPWR VPWR _02920_ sky130_fd_sc_hd__a31o_2
XFILLER_0_120_109 VPWR VGND VPWR VGND sky130_ef_sc_hd__decap_12
X_05338_ _00345_ _00346_ VGND VGND VPWR VPWR _05338_/Y sky130_fd_sc_hd__xnor2_2
X_08057_ _02801_ _02807_ _02850_ VGND VGND VPWR VPWR _02852_ sky130_fd_sc_hd__a21oi_2
XFILLER_0_101_323 VGND VGND VPWR VPWR sky130_fd_sc_hd__decap_3
XPHY_EDGE_ROW_1_Right_1 VGND VGND VPWR VPWR sky130_fd_sc_hd__decap_3
X_05269_ mac_inst.i\[5\] _04837_ _04843_ _04936_ VGND VGND VPWR VPWR _04970_ sky130_fd_sc_hd__or4_2
XFILLER_0_31_446 VGND VGND VPWR VPWR sky130_fd_sc_hd__fill_2
X_07008_ _01088_ _01843_ _01845_ _01092_ tanh_inst.divider.z_\[-16\] VGND VGND VPWR
+ VPWR _00205_ sky130_fd_sc_hd__a32o_2
XFILLER_0_11_181 VPWR VGND VPWR VGND sky130_ef_sc_hd__decap_12
XTAP_TAPCELL_ROW_8_358 VGND VPWR sky130_fd_sc_hd__tapvpwrvgnd_1
X_08959_ tanh_inst.divider.x\[7\] _03653_ _04760_ VGND VGND VPWR VPWR _03703_ sky130_fd_sc_hd__mux2_1
XTAP_TAPCELL_ROW_27_600 VGND VPWR sky130_fd_sc_hd__tapvpwrvgnd_1
XTAP_TAPCELL_ROW_55_953 VGND VPWR sky130_fd_sc_hd__tapvpwrvgnd_1
XFILLER_0_79_693 VGND VGND VPWR VPWR sky130_fd_sc_hd__fill_2
XFILLER_0_39_513 VGND VGND VPWR VPWR sky130_fd_sc_hd__fill_1
XFILLER_0_39_546 VGND VGND VPWR VPWR sky130_fd_sc_hd__fill_2
XFILLER_0_109_434 VGND VGND VPWR VPWR sky130_fd_sc_hd__decap_3
XFILLER_0_66_365 VGND VGND VPWR VPWR sky130_fd_sc_hd__decap_4
XFILLER_0_26_218 VPWR VGND VPWR VGND sky130_ef_sc_hd__decap_12
XFILLER_0_81_324 VGND VGND VPWR VPWR sky130_fd_sc_hd__decap_4
XFILLER_0_19_281 VPWR VGND VPWR VGND sky130_ef_sc_hd__decap_12
XFILLER_0_22_402 VPWR VGND VPWR VGND sky130_ef_sc_hd__decap_12
XFILLER_0_34_240 VPWR VGND VPWR VGND sky130_ef_sc_hd__decap_12
XFILLER_0_34_273 VGND VGND VPWR VPWR sky130_fd_sc_hd__fill_2
XFILLER_0_50_722 VGND VGND VPWR VPWR sky130_fd_sc_hd__fill_2
XFILLER_0_105_673 VGND VGND VPWR VPWR sky130_fd_sc_hd__decap_3
XFILLER_0_104_161 VGND VGND VPWR VPWR sky130_fd_sc_hd__decap_8
XFILLER_0_1_329 VGND VGND VPWR VPWR sky130_fd_sc_hd__decap_6
XFILLER_0_120_687 VGND VGND VPWR VPWR sky130_fd_sc_hd__decap_3
X_10217_ clknet_leaf_30_clk mac_inst.y\[11\] _00000_ VGND VGND VPWR VPWR mac_y_out[11]
+ sky130_fd_sc_hd__dfrtp_2
XFILLER_0_94_29 VPWR VGND VPWR VGND sky130_ef_sc_hd__decap_12
X_10079_ clknet_leaf_11_clk _00096_ VGND VGND VPWR VPWR tanh_inst.divider.y_\[-14\]
+ sky130_fd_sc_hd__dfxtp_2
XTAP_TAPCELL_ROW_85_1325 VGND VPWR sky130_fd_sc_hd__tapvpwrvgnd_1
XFILLER_0_9_429 VGND VGND VPWR VPWR sky130_fd_sc_hd__decap_4
X_06310_ _01243_ _01244_ _01245_ VGND VGND VPWR VPWR _01246_ sky130_fd_sc_hd__o21a_2
X_07290_ _02053_ _02098_ _02065_ VGND VGND VPWR VPWR _02100_ sky130_fd_sc_hd__a21o_2
XTAP_TAPCELL_ROW_33_669 VGND VPWR sky130_fd_sc_hd__tapvpwrvgnd_1
XFILLER_0_45_505 VPWR VGND VPWR VGND sky130_ef_sc_hd__decap_12
X_06241_ tanh_inst.divider.y_\[-18\] _01181_ VGND VGND VPWR VPWR _01182_ sky130_fd_sc_hd__xor2_2
XFILLER_0_84_195 VGND VGND VPWR VPWR sky130_fd_sc_hd__fill_1
XFILLER_0_72_357 VGND VGND VPWR VPWR sky130_fd_sc_hd__decap_6
XFILLER_0_115_459 VGND VGND VPWR VPWR sky130_fd_sc_hd__fill_1
X_06172_ tanh_inst.divider.x\[-1\] tanh_inst.divider.x\[0\] tanh_inst.divider.x\[1\]
+ tanh_inst.divider.x\[2\] tanh_inst.divider.i\[0\] tanh_inst.divider.i\[1\] VGND
+ VGND VPWR VPWR _01116_ sky130_fd_sc_hd__mux4_2
XFILLER_0_25_273 VGND VGND VPWR VPWR sky130_fd_sc_hd__decap_6
XFILLER_0_102_109 VGND VGND VPWR VPWR sky130_fd_sc_hd__decap_6
XTAP_TAPCELL_ROW_96_1465 VGND VPWR sky130_fd_sc_hd__tapvpwrvgnd_1
X_05123_ mac_counter\[3\] _04822_ _00000_ VGND VGND VPWR VPWR _04831_ sky130_fd_sc_hd__o21ai_2
XFILLER_0_4_189 VGND VGND VPWR VPWR sky130_fd_sc_hd__decap_6
X_05054_ tanh_inst.divider.i\[1\] VGND VGND VPWR VPWR _04778_ sky130_fd_sc_hd__inv_2
X_09931_ _02053_ _04086_ _04193_ VGND VGND VPWR VPWR _04649_ sky130_fd_sc_hd__o21a_2
XFILLER_0_68_41 VPWR VGND VPWR VGND sky130_ef_sc_hd__decap_12
XFILLER_0_7_55 VGND VGND VPWR VPWR sky130_fd_sc_hd__fill_1
XFILLER_0_68_85 VGND VGND VPWR VPWR sky130_fd_sc_hd__fill_1
XFILLER_0_110_197 VGND VGND VPWR VPWR sky130_fd_sc_hd__fill_1
XTAP_TAPCELL_ROW_5_328 VGND VPWR sky130_fd_sc_hd__tapvpwrvgnd_1
X_09862_ _04506_ _04580_ _04581_ VGND VGND VPWR VPWR _04582_ sky130_fd_sc_hd__o21a_2
X_08813_ tanh_inst.divider.x\[-8\] _02028_ _03508_ VGND VGND VPWR VPWR _03559_ sky130_fd_sc_hd__o21ai_2
X_09793_ _02018_ _04514_ VGND VGND VPWR VPWR _04515_ sky130_fd_sc_hd__nand2_2
X_05956_ _00900_ _00912_ mac_inst.z\[31\] VGND VGND VPWR VPWR _00914_ sky130_fd_sc_hd__a21o_2
X_08744_ mac_inst.i\[20\] _04953_ _03497_ VGND VGND VPWR VPWR _03502_ sky130_fd_sc_hd__and3_2
XFILLER_0_30_3 VPWR VGND VPWR VGND sky130_ef_sc_hd__decap_12
X_08675_ _03452_ _03453_ _04791_ VGND VGND VPWR VPWR _03455_ sky130_fd_sc_hd__o21ai_2
X_05887_ _00825_ _00838_ mac_inst.z\[31\] VGND VGND VPWR VPWR _00850_ sky130_fd_sc_hd__a21o_2
XFILLER_0_95_449 VPWR VGND VPWR VGND sky130_ef_sc_hd__decap_12
X_07626_ _02416_ _02430_ VGND VGND VPWR VPWR _02431_ sky130_fd_sc_hd__xnor2_2
XTAP_TAPCELL_ROW_52_912 VGND VPWR sky130_fd_sc_hd__tapvpwrvgnd_1
XTAP_TAPCELL_ROW_105_1572 VGND VPWR sky130_fd_sc_hd__tapvpwrvgnd_1
XFILLER_0_88_490 VGND VGND VPWR VPWR sky130_fd_sc_hd__decap_3
X_07557_ _02304_ _02308_ _02362_ VGND VGND VPWR VPWR _02363_ sky130_fd_sc_hd__o21ai_2
X_06508_ _01425_ _01426_ _01413_ _01419_ VGND VGND VPWR VPWR _01428_ sky130_fd_sc_hd__o211ai_2
XFILLER_0_75_140 VPWR VGND VPWR VGND sky130_ef_sc_hd__decap_12
XFILLER_0_63_302 VGND VGND VPWR VPWR sky130_fd_sc_hd__decap_8
Xclkbuf_leaf_33_clk clknet_2_1__leaf_clk VGND VGND VPWR VPWR clknet_leaf_33_clk sky130_fd_sc_hd__clkbuf_8
XFILLER_0_36_527 VGND VGND VPWR VPWR sky130_fd_sc_hd__decap_4
XFILLER_0_48_365 VPWR VGND VPWR VGND sky130_ef_sc_hd__decap_12
XFILLER_0_118_253 VGND VGND VPWR VPWR sky130_fd_sc_hd__decap_8
X_07488_ _02292_ _02293_ VGND VGND VPWR VPWR _02295_ sky130_fd_sc_hd__xnor2_2
XFILLER_0_63_335 VGND VGND VPWR VPWR sky130_fd_sc_hd__fill_1
X_06439_ _01363_ _01364_ VGND VGND VPWR VPWR _01365_ sky130_fd_sc_hd__xor2_2
X_09227_ _03882_ _03925_ _03926_ VGND VGND VPWR VPWR _03965_ sky130_fd_sc_hd__o21ai_2
XFILLER_0_16_251 VGND VGND VPWR VPWR sky130_fd_sc_hd__fill_1
X_09158_ _01525_ _03897_ VGND VGND VPWR VPWR _03898_ sky130_fd_sc_hd__or2_2
XFILLER_0_114_470 VGND VGND VPWR VPWR sky130_fd_sc_hd__fill_2
X_09089_ _02022_ _03827_ _03828_ _03829_ _02053_ VGND VGND VPWR VPWR _03830_ sky130_fd_sc_hd__a221o_2
XFILLER_0_71_390 VGND VGND VPWR VPWR sky130_fd_sc_hd__fill_2
X_08109_ _02894_ _02901_ _04791_ VGND VGND VPWR VPWR _02903_ sky130_fd_sc_hd__o21a_2
XPHY_EDGE_ROW_2_Left_124 VGND VGND VPWR VPWR sky130_fd_sc_hd__decap_3
XFILLER_0_101_131 VGND VGND VPWR VPWR sky130_fd_sc_hd__fill_1
X_10002_ _04679_ _04680_ _04682_ _04715_ VGND VGND VPWR VPWR _04718_ sky130_fd_sc_hd__a211o_2
XFILLER_0_58_118 VGND VGND VPWR VPWR sky130_fd_sc_hd__fill_1
XFILLER_0_104_27 VGND VGND VPWR VPWR sky130_fd_sc_hd__fill_1
XTAP_TAPCELL_ROW_67_1099 VGND VPWR sky130_fd_sc_hd__tapvpwrvgnd_1
XFILLER_0_67_663 VGND VGND VPWR VPWR sky130_fd_sc_hd__decap_8
Xclkbuf_leaf_24_clk clknet_2_3__leaf_clk VGND VGND VPWR VPWR clknet_leaf_24_clk sky130_fd_sc_hd__clkbuf_8
XFILLER_0_109_253 VGND VGND VPWR VPWR sky130_fd_sc_hd__fill_1
XTAP_TAPCELL_ROW_80_1266 VGND VPWR sky130_fd_sc_hd__tapvpwrvgnd_1
XFILLER_0_13_69 VPWR VGND VPWR VGND sky130_ef_sc_hd__decap_12
XFILLER_0_120_15 VPWR VGND VPWR VGND sky130_ef_sc_hd__decap_12
XFILLER_0_81_165 VGND VGND VPWR VPWR sky130_fd_sc_hd__decap_3
XTAP_TAPCELL_ROW_30_639 VGND VPWR sky130_fd_sc_hd__tapvpwrvgnd_1
XPHY_EDGE_ROW_57_Left_179 VGND VGND VPWR VPWR sky130_fd_sc_hd__decap_3
XFILLER_0_35_582 VGND VGND VPWR VPWR sky130_fd_sc_hd__decap_8
XTAP_TAPCELL_ROW_10_385 VGND VPWR sky130_fd_sc_hd__tapvpwrvgnd_1
XFILLER_0_22_221 VPWR VGND VPWR VGND sky130_ef_sc_hd__decap_12
XFILLER_0_1_137 VPWR VGND VPWR VGND sky130_ef_sc_hd__decap_12
XFILLER_0_22_265 VPWR VGND VPWR VGND sky130_ef_sc_hd__decap_12
XFILLER_0_50_563 VGND VGND VPWR VPWR sky130_fd_sc_hd__fill_1
XFILLER_0_120_473 VGND VGND VPWR VPWR sky130_fd_sc_hd__decap_3
XFILLER_0_38_11 VGND VGND VPWR VPWR sky130_fd_sc_hd__decap_3
XTAP_TAPCELL_ROW_91_1395 VGND VPWR sky130_fd_sc_hd__tapvpwrvgnd_1
XFILLER_0_38_77 VGND VGND VPWR VPWR sky130_fd_sc_hd__decap_6
X_05810_ _04800_ _00774_ VGND VGND VPWR VPWR _00779_ sky130_fd_sc_hd__xnor2_2
XPHY_EDGE_ROW_66_Left_188 VGND VGND VPWR VPWR sky130_fd_sc_hd__decap_3
X_06790_ _01684_ _01685_ VGND VGND VPWR VPWR _01686_ sky130_fd_sc_hd__xor2_2
XFILLER_0_54_54 VGND VGND VPWR VPWR sky130_fd_sc_hd__decap_3
X_05741_ _00714_ _00715_ VGND VGND VPWR VPWR _05741_/Y sky130_fd_sc_hd__nor2_2
XTAP_TAPCELL_ROW_38_739 VGND VPWR sky130_fd_sc_hd__tapvpwrvgnd_1
XFILLER_0_77_416 VGND VGND VPWR VPWR sky130_fd_sc_hd__decap_4
X_05672_ mac_inst.z\[31\] _04912_ _00488_ _00644_ VGND VGND VPWR VPWR _00653_ sky130_fd_sc_hd__o31a_2
X_08460_ _03240_ _03245_ VGND VGND VPWR VPWR _03246_ sky130_fd_sc_hd__or2_2
X_07411_ _02073_ _02079_ _02081_ _02075_ _04760_ _04761_ VGND VGND VPWR VPWR _02219_
+ sky130_fd_sc_hd__mux4_2
XFILLER_0_77_449 VGND VGND VPWR VPWR sky130_fd_sc_hd__decap_6
XTAP_TAPCELL_ROW_18_485 VGND VPWR sky130_fd_sc_hd__tapvpwrvgnd_1
X_08391_ tanh_inst.divider.x\[-1\] _03163_ VGND VGND VPWR VPWR _03178_ sky130_fd_sc_hd__xnor2_2
Xclkbuf_leaf_15_clk clknet_2_3__leaf_clk VGND VGND VPWR VPWR clknet_leaf_15_clk sky130_fd_sc_hd__clkbuf_8
X_07342_ _02028_ _02150_ _02029_ VGND VGND VPWR VPWR _02151_ sky130_fd_sc_hd__o21a_2
XFILLER_0_73_611 VGND VGND VPWR VPWR sky130_fd_sc_hd__decap_4
XFILLER_0_9_237 VPWR VGND VPWR VGND sky130_ef_sc_hd__decap_12
XFILLER_0_73_622 VGND VGND VPWR VPWR sky130_fd_sc_hd__fill_1
XFILLER_0_18_538 VGND VGND VPWR VPWR sky130_fd_sc_hd__decap_4
XFILLER_0_18_549 VGND VGND VPWR VPWR sky130_fd_sc_hd__decap_3
XFILLER_0_45_324 VGND VGND VPWR VPWR sky130_fd_sc_hd__decap_3
XFILLER_0_115_223 VGND VGND VPWR VPWR sky130_fd_sc_hd__fill_1
X_07273_ tanh_inst.divider.y\[-3\] _02028_ _02029_ VGND VGND VPWR VPWR _02083_ sky130_fd_sc_hd__o21a_2
XPHY_EDGE_ROW_75_Left_197 VGND VGND VPWR VPWR sky130_fd_sc_hd__decap_3
X_06224_ tanh_inst.divider.y_\[-19\] _01165_ VGND VGND VPWR VPWR _01166_ sky130_fd_sc_hd__nor2_2
X_09012_ _04791_ _03753_ _03754_ _02018_ VGND VGND VPWR VPWR _03755_ sky130_fd_sc_hd__a31o_2
XFILLER_0_60_316 VGND VGND VPWR VPWR sky130_fd_sc_hd__fill_1
X_06155_ tanh_inst.divider.x\[-18\] tanh_inst.divider.x\[-17\] tanh_inst.divider.x\[-16\]
+ tanh_inst.divider.x\[-15\] tanh_inst.divider.i\[0\] tanh_inst.divider.i\[1\] VGND
+ VGND VPWR VPWR _01100_ sky130_fd_sc_hd__mux4_2
XFILLER_0_78_3 VGND VGND VPWR VPWR sky130_fd_sc_hd__decap_8
X_05106_ mac_counter\[2\] mac_counter\[1\] mac_counter\[0\] mac_counter\[3\] VGND
+ VGND VPWR VPWR _04819_ sky130_fd_sc_hd__a31o_2
X_06086_ tanh_inst.divider.i\[1\] _01032_ VGND VGND VPWR VPWR _01033_ sky130_fd_sc_hd__nand2_2
XFILLER_0_1_660 VGND VGND VPWR VPWR sky130_fd_sc_hd__decap_4
X_05037_ tanh_inst.LOOKUP.index\[0\] VGND VGND VPWR VPWR _04761_ sky130_fd_sc_hd__inv_2
XFILLER_0_0_181 VPWR VGND VPWR VGND sky130_ef_sc_hd__decap_12
X_09914_ tanh_inst.divider.y\[3\] _04632_ VGND VGND VPWR VPWR _04633_ sky130_fd_sc_hd__and2b_2
X_09845_ _04791_ _04507_ VGND VGND VPWR VPWR _04566_ sky130_fd_sc_hd__nand2_2
X_06988_ _01824_ _01826_ _01089_ VGND VGND VPWR VPWR _01828_ sky130_fd_sc_hd__a21o_2
XTAP_TAPCELL_ROW_107_1601 VGND VPWR sky130_fd_sc_hd__tapvpwrvgnd_1
X_09776_ _04439_ _04445_ _04498_ VGND VGND VPWR VPWR _04499_ sky130_fd_sc_hd__o21ai_2
X_05939_ _00706_ _00846_ VGND VGND VPWR VPWR _00898_ sky130_fd_sc_hd__nand2_2
X_08727_ mac_inst.i\[12\] _00961_ VGND VGND VPWR VPWR _00277_ sky130_fd_sc_hd__xnor2_2
XFILLER_0_95_202 VGND VGND VPWR VPWR sky130_fd_sc_hd__fill_2
X_08658_ _03427_ _03428_ _04791_ VGND VGND VPWR VPWR _03438_ sky130_fd_sc_hd__o21a_2
XFILLER_0_95_257 VPWR VGND VPWR VGND sky130_ef_sc_hd__decap_12
X_07609_ _02360_ _02363_ _02409_ _02412_ VGND VGND VPWR VPWR _02414_ sky130_fd_sc_hd__and4_2
XFILLER_0_49_652 VPWR VGND VPWR VGND sky130_ef_sc_hd__decap_12
X_08589_ _03367_ _03368_ _03369_ _03318_ _03366_ VGND VGND VPWR VPWR _03371_ sky130_fd_sc_hd__o221a_2
XFILLER_0_64_633 VGND VGND VPWR VPWR sky130_fd_sc_hd__fill_1
XFILLER_0_48_184 VPWR VGND VPWR VGND sky130_ef_sc_hd__decap_12
XFILLER_0_106_234 VPWR VGND VPWR VGND sky130_ef_sc_hd__decap_12
XFILLER_0_64_699 VGND VGND VPWR VPWR sky130_fd_sc_hd__fill_1
X_10482_ clknet_leaf_33_clk _00339_ _00083_ VGND VGND VPWR VPWR tanh_counter\[5\]
+ sky130_fd_sc_hd__dfrtp_2
XTAP_TAPCELL_ROW_118_1741 VGND VPWR sky130_fd_sc_hd__tapvpwrvgnd_1
XFILLER_0_121_237 VPWR VGND VPWR VGND sky130_ef_sc_hd__decap_12
XFILLER_0_99_541 VPWR VGND VPWR VGND sky130_ef_sc_hd__decap_12
XTAP_TAPCELL_ROW_69_1128 VGND VPWR sky130_fd_sc_hd__tapvpwrvgnd_1
XFILLER_0_59_405 VGND VGND VPWR VPWR sky130_fd_sc_hd__decap_8
XFILLER_0_115_15 VPWR VGND VPWR VGND sky130_ef_sc_hd__decap_12
XFILLER_0_67_471 VPWR VGND VPWR VGND sky130_ef_sc_hd__decap_12
XTAP_TAPCELL_ROW_15_444 VGND VPWR sky130_fd_sc_hd__tapvpwrvgnd_1
XTAP_TAPCELL_ROW_15_455 VGND VPWR sky130_fd_sc_hd__tapvpwrvgnd_1
XTAP_TAPCELL_ROW_43_797 VGND VPWR sky130_fd_sc_hd__tapvpwrvgnd_1
XTAP_TAPCELL_ROW_93_1424 VGND VPWR sky130_fd_sc_hd__tapvpwrvgnd_1
XFILLER_0_64_9 VGND VGND VPWR VPWR sky130_fd_sc_hd__fill_1
XFILLER_0_2_468 VGND VGND VPWR VPWR sky130_fd_sc_hd__decap_3
XFILLER_0_49_32 VGND VGND VPWR VPWR sky130_fd_sc_hd__decap_4
XFILLER_0_49_54 VGND VGND VPWR VPWR sky130_fd_sc_hd__fill_2
X_07960_ _02692_ _02695_ _02756_ VGND VGND VPWR VPWR _02757_ sky130_fd_sc_hd__nor3_2
Xclkbuf_leaf_4_clk clknet_2_2__leaf_clk VGND VGND VPWR VPWR clknet_leaf_4_clk sky130_fd_sc_hd__clkbuf_8
X_06911_ tanh_inst.div_en tanh_inst.divider.z_\[-7\] VGND VGND VPWR VPWR _00182_ sky130_fd_sc_hd__and2b_2
X_07891_ tanh_inst.divider.x\[-13\] _02014_ _02677_ _02689_ _01470_ VGND VGND VPWR
+ VPWR _00244_ sky130_fd_sc_hd__o221a_2
X_06842_ mac_y_out[25] _01469_ _01502_ _01731_ VGND VGND VPWR VPWR _00153_ sky130_fd_sc_hd__a22o_2
X_09630_ tanh_inst.divider.y\[-5\] _04356_ VGND VGND VPWR VPWR _04357_ sky130_fd_sc_hd__nor2_2
X_06773_ _01669_ _01670_ VGND VGND VPWR VPWR _01671_ sky130_fd_sc_hd__xor2_2
X_09561_ _04288_ _04289_ VGND VGND VPWR VPWR _04290_ sky130_fd_sc_hd__xnor2_2
X_08512_ _02053_ _02612_ _02834_ VGND VGND VPWR VPWR _03296_ sky130_fd_sc_hd__o21a_2
X_05724_ _00684_ _00688_ _00686_ VGND VGND VPWR VPWR _00700_ sky130_fd_sc_hd__a21oi_2
X_09492_ tanh_inst.divider.y\[-9\] _04216_ _04221_ VGND VGND VPWR VPWR _04222_ sky130_fd_sc_hd__o21ai_2
XTAP_TAPCELL_ROW_102_1531 VGND VPWR sky130_fd_sc_hd__tapvpwrvgnd_1
XFILLER_0_77_268 VPWR VGND VPWR VGND sky130_ef_sc_hd__decap_12
X_05655_ mac_inst.y\[28\] _00636_ VGND VGND VPWR VPWR _00638_ sky130_fd_sc_hd__or2_2
X_08443_ _03199_ _03228_ VGND VGND VPWR VPWR _03229_ sky130_fd_sc_hd__nor2_2
XFILLER_0_105_81 VPWR VGND VPWR VGND sky130_ef_sc_hd__decap_12
XTAP_TAPCELL_ROW_102_1542 VGND VPWR sky130_fd_sc_hd__tapvpwrvgnd_1
XPHY_EDGE_ROW_83_Left_205 VGND VGND VPWR VPWR sky130_fd_sc_hd__decap_3
X_08374_ _02019_ _03160_ _03161_ _02015_ VGND VGND VPWR VPWR _03162_ sky130_fd_sc_hd__a211o_2
X_05586_ _04911_ _00400_ _00509_ VGND VGND VPWR VPWR _00575_ sky130_fd_sc_hd__a21oi_2
XFILLER_0_116_521 VGND VGND VPWR VPWR sky130_fd_sc_hd__decap_4
X_07325_ _02075_ _02081_ _02083_ _02079_ _04760_ _04761_ VGND VGND VPWR VPWR _02134_
+ sky130_fd_sc_hd__mux4_2
XFILLER_0_73_441 VGND VGND VPWR VPWR sky130_fd_sc_hd__decap_6
X_07256_ tanh_inst.divider.y\[5\] _02028_ _02029_ VGND VGND VPWR VPWR _02066_ sky130_fd_sc_hd__o21a_2
XFILLER_0_60_113 VGND VGND VPWR VPWR sky130_fd_sc_hd__decap_8
X_06207_ tanh_inst.divider.y_\[-20\] _01149_ VGND VGND VPWR VPWR _01150_ sky130_fd_sc_hd__and2_2
XFILLER_0_5_273 VGND VGND VPWR VPWR sky130_fd_sc_hd__decap_6
X_07187_ tanh_inst.divider.z_\[6\] _01975_ VGND VGND VPWR VPWR _02003_ sky130_fd_sc_hd__nand2_2
X_06138_ _01027_ _01037_ _01043_ tanh_inst.divider.y_\[7\] VGND VGND VPWR VPWR _01084_
+ sky130_fd_sc_hd__a31oi_2
XFILLER_0_41_393 VGND VGND VPWR VPWR sky130_fd_sc_hd__fill_1
XFILLER_0_111_281 VGND VGND VPWR VPWR sky130_fd_sc_hd__decap_3
X_06069_ _04795_ _01003_ _01009_ VGND VGND VPWR VPWR _01017_ sky130_fd_sc_hd__and3_2
XTAP_TAPCELL_ROW_113_1671 VGND VPWR sky130_fd_sc_hd__tapvpwrvgnd_1
XPHY_EDGE_ROW_92_Left_214 VGND VGND VPWR VPWR sky130_fd_sc_hd__decap_3
X_09828_ _04547_ _04548_ VGND VGND VPWR VPWR _04549_ sky130_fd_sc_hd__or2_2
XFILLER_0_69_703 VGND VGND VPWR VPWR sky130_fd_sc_hd__fill_1
X_09759_ _04480_ _04481_ VGND VGND VPWR VPWR _04482_ sky130_fd_sc_hd__or2_2
XFILLER_0_96_555 VGND VGND VPWR VPWR sky130_fd_sc_hd__fill_1
XTAP_TAPCELL_ROW_64_1058 VGND VPWR sky130_fd_sc_hd__tapvpwrvgnd_1
XFILLER_0_36_110 VGND VGND VPWR VPWR sky130_fd_sc_hd__decap_6
XFILLER_0_64_452 VPWR VGND VPWR VGND sky130_ef_sc_hd__decap_12
XTAP_TAPCELL_ROW_12_414 VGND VPWR sky130_fd_sc_hd__tapvpwrvgnd_1
XFILLER_0_107_554 VGND VGND VPWR VPWR sky130_fd_sc_hd__decap_6
XFILLER_0_107_543 VGND VGND VPWR VPWR sky130_fd_sc_hd__fill_2
XTAP_TAPCELL_ROW_40_756 VGND VPWR sky130_fd_sc_hd__tapvpwrvgnd_1
XTAP_TAPCELL_ROW_40_767 VGND VPWR sky130_fd_sc_hd__tapvpwrvgnd_1
XFILLER_0_51_113 VPWR VGND VPWR VGND sky130_ef_sc_hd__decap_12
XFILLER_0_101_39 VGND VGND VPWR VPWR sky130_fd_sc_hd__decap_8
XFILLER_0_10_15 VPWR VGND VPWR VGND sky130_ef_sc_hd__decap_12
XFILLER_0_51_146 VGND VGND VPWR VPWR sky130_fd_sc_hd__decap_3
X_10465_ clknet_leaf_41_clk _00322_ VGND VGND VPWR VPWR tanh_inst.divider.y\[1\] sky130_fd_sc_hd__dfxtp_2
XFILLER_0_60_680 VPWR VGND VPWR VGND sky130_ef_sc_hd__decap_12
X_10396_ clknet_leaf_39_clk _00253_ VGND VGND VPWR VPWR tanh_inst.divider.x\[-4\]
+ sky130_fd_sc_hd__dfxtp_2
XTAP_TAPCELL_ROW_75_1198 VGND VPWR sky130_fd_sc_hd__tapvpwrvgnd_1
XFILLER_0_19_57 VPWR VGND VPWR VGND sky130_ef_sc_hd__decap_12
XTAP_TAPCELL_ROW_48_856 VGND VPWR sky130_fd_sc_hd__tapvpwrvgnd_1
XTAP_TAPCELL_ROW_48_867 VGND VPWR sky130_fd_sc_hd__tapvpwrvgnd_1
XFILLER_0_99_393 VPWR VGND VPWR VGND sky130_ef_sc_hd__decap_12
XFILLER_0_87_588 VGND VGND VPWR VPWR sky130_fd_sc_hd__decap_4
XFILLER_0_28_600 VGND VGND VPWR VPWR sky130_fd_sc_hd__decap_4
XFILLER_0_74_227 VGND VGND VPWR VPWR sky130_fd_sc_hd__decap_4
X_05440_ _04836_ _00441_ _00440_ _05021_ VGND VGND VPWR VPWR _00442_ sky130_fd_sc_hd__o211ai_2
XFILLER_0_51_22 VGND VGND VPWR VPWR sky130_fd_sc_hd__fill_1
X_05371_ mac_inst.z\[31\] _00377_ VGND VGND VPWR VPWR _00378_ sky130_fd_sc_hd__or2_2
XFILLER_0_51_55 VGND VGND VPWR VPWR sky130_fd_sc_hd__fill_1
X_07110_ _01917_ _01927_ _01928_ VGND VGND VPWR VPWR _01936_ sky130_fd_sc_hd__o21a_2
XFILLER_0_15_305 VPWR VGND VPWR VGND sky130_ef_sc_hd__decap_12
XFILLER_0_27_176 VPWR VGND VPWR VGND sky130_ef_sc_hd__decap_12
X_08090_ _02806_ _02883_ VGND VGND VPWR VPWR _02884_ sky130_fd_sc_hd__or2_2
Xclkload20 clknet_leaf_1_clk VGND VGND VPWR VPWR clkload20/Y sky130_fd_sc_hd__inv_6
XFILLER_0_15_349 VPWR VGND VPWR VGND sky130_ef_sc_hd__decap_12
Xclkload31 clknet_leaf_14_clk VGND VGND VPWR VPWR clkload31/Y sky130_fd_sc_hd__clkinv_8
X_07041_ _01864_ _01872_ _01873_ VGND VGND VPWR VPWR _01875_ sky130_fd_sc_hd__and3_2
Xclkload42 clknet_leaf_26_clk VGND VGND VPWR VPWR clkload42/Y sky130_fd_sc_hd__inv_12
XFILLER_0_70_477 VPWR VGND VPWR VGND sky130_ef_sc_hd__decap_12
XFILLER_0_2_221 VPWR VGND VPWR VGND sky130_ef_sc_hd__decap_12
XFILLER_0_2_265 VPWR VGND VPWR VGND sky130_ef_sc_hd__decap_12
XFILLER_0_23_382 VGND VGND VPWR VPWR sky130_fd_sc_hd__decap_4
XFILLER_0_100_218 VGND VGND VPWR VPWR sky130_fd_sc_hd__decap_4
X_08992_ _03551_ _03553_ _03555_ _03565_ _04761_ tanh_inst.LOOKUP.index\[1\] VGND
+ VGND VPWR VPWR _03735_ sky130_fd_sc_hd__mux4_2
XFILLER_0_76_41 VPWR VGND VPWR VGND sky130_ef_sc_hd__decap_12
XFILLER_0_11_599 VGND VGND VPWR VPWR sky130_fd_sc_hd__decap_4
X_07943_ _02739_ _02740_ VGND VGND VPWR VPWR _02741_ sky130_fd_sc_hd__nand2_2
X_07874_ _02656_ _02671_ VGND VGND VPWR VPWR _02673_ sky130_fd_sc_hd__xnor2_2
X_06825_ _01704_ _01711_ VGND VGND VPWR VPWR _01717_ sky130_fd_sc_hd__nand2_2
X_09613_ _04338_ _04339_ VGND VGND VPWR VPWR _04340_ sky130_fd_sc_hd__nor2_2
XFILLER_0_92_73 VGND VGND VPWR VPWR sky130_fd_sc_hd__fill_2
XFILLER_0_78_544 VPWR VGND VPWR VGND sky130_ef_sc_hd__decap_12
X_06756_ tanh_inst.LOOKUP.index\[2\] _01526_ _01534_ _01474_ _01519_ VGND VGND VPWR
+ VPWR _01655_ sky130_fd_sc_hd__o2111a_2
X_09544_ _04244_ _04247_ _04272_ VGND VGND VPWR VPWR _04273_ sky130_fd_sc_hd__a21oi_2
X_09475_ _02851_ _02852_ _04196_ VGND VGND VPWR VPWR _04206_ sky130_fd_sc_hd__or3_2
X_06687_ _01593_ VGND VGND VPWR VPWR _01594_ sky130_fd_sc_hd__inv_2
X_05707_ mac_inst.z\[2\] _00683_ VGND VGND VPWR VPWR _00684_ sky130_fd_sc_hd__or2_2
XFILLER_0_19_622 VGND VGND VPWR VPWR sky130_fd_sc_hd__fill_1
XFILLER_0_19_633 VGND VGND VPWR VPWR sky130_fd_sc_hd__fill_2
X_08426_ _03039_ _03211_ VGND VGND VPWR VPWR _03212_ sky130_fd_sc_hd__and2_2
X_05638_ _00614_ _00615_ _00605_ VGND VGND VPWR VPWR _00623_ sky130_fd_sc_hd__or3b_2
XFILLER_0_18_121 VPWR VGND VPWR VGND sky130_ef_sc_hd__decap_12
XFILLER_0_73_271 VGND VGND VPWR VPWR sky130_fd_sc_hd__decap_8
Xclkload3 clknet_leaf_0_clk VGND VGND VPWR VPWR clkload3/Y sky130_fd_sc_hd__inv_4
XFILLER_0_18_165 VPWR VGND VPWR VGND sky130_ef_sc_hd__decap_12
X_08357_ _03141_ _03143_ _04791_ VGND VGND VPWR VPWR _03145_ sky130_fd_sc_hd__o21a_2
XFILLER_0_34_625 VGND VGND VPWR VPWR sky130_fd_sc_hd__fill_2
X_05569_ _00559_ _00560_ VGND VGND VPWR VPWR _05569_/X sky130_fd_sc_hd__xor2_2
XFILLER_0_104_513 VGND VGND VPWR VPWR sky130_fd_sc_hd__fill_1
X_07308_ tanh_inst.divider.y\[-4\] tanh_inst.divider.y\[-3\] tanh_inst.divider.y\[-2\]
+ tanh_inst.divider.y\[-1\] tanh_inst.LOOKUP.index\[0\] tanh_inst.LOOKUP.index\[1\]
+ VGND VGND VPWR VPWR _02118_ sky130_fd_sc_hd__mux4_2
X_08288_ _02948_ _02993_ _03076_ _03077_ _03023_ VGND VGND VPWR VPWR _03078_ sky130_fd_sc_hd__o311a_2
XTAP_TAPCELL_ROW_115_1700 VGND VPWR sky130_fd_sc_hd__tapvpwrvgnd_1
X_07239_ _02041_ _02045_ _02046_ _02043_ _04760_ _04761_ VGND VGND VPWR VPWR _02049_
+ sky130_fd_sc_hd__mux4_2
XFILLER_0_104_579 VGND VGND VPWR VPWR sky130_fd_sc_hd__fill_2
X_10250_ clknet_leaf_32_clk mac_inst.x\[12\] _00000_ VGND VGND VPWR VPWR mac_x_out[12]
+ sky130_fd_sc_hd__dfrtp_2
X_10181_ x_in[7] _00000_ VGND VGND VPWR VPWR mac_inst.x\[7\] sky130_fd_sc_hd__dlxtn_1
XTAP_TAPCELL_ROW_45_826 VGND VPWR sky130_fd_sc_hd__tapvpwrvgnd_1
XFILLER_0_96_341 VGND VGND VPWR VPWR sky130_fd_sc_hd__decap_8
XTAP_TAPCELL_ROW_25_572 VGND VPWR sky130_fd_sc_hd__tapvpwrvgnd_1
XFILLER_0_37_441 VGND VGND VPWR VPWR sky130_fd_sc_hd__decap_6
XFILLER_0_112_27 VGND VGND VPWR VPWR sky130_fd_sc_hd__fill_1
XFILLER_0_37_485 VPWR VGND VPWR VGND sky130_ef_sc_hd__decap_12
XFILLER_0_21_69 VPWR VGND VPWR VGND sky130_ef_sc_hd__decap_12
XFILLER_0_25_658 VGND VGND VPWR VPWR sky130_fd_sc_hd__fill_1
XTAP_TAPCELL_ROW_77_1227 VGND VPWR sky130_fd_sc_hd__tapvpwrvgnd_1
X_10448_ clknet_leaf_7_clk _00305_ VGND VGND VPWR VPWR tanh_inst.divider.y\[-16\]
+ sky130_fd_sc_hd__dfxtp_2
XFILLER_0_20_341 VGND VGND VPWR VPWR sky130_fd_sc_hd__fill_1
X_10379_ clknet_leaf_9_clk _00236_ VGND VGND VPWR VPWR tanh_inst.divider.x\[-21\]
+ sky130_fd_sc_hd__dfxtp_2
XTAP_TAPCELL_ROW_88_1367 VGND VPWR sky130_fd_sc_hd__tapvpwrvgnd_1
XTAP_TAPCELL_ROW_88_1356 VGND VPWR sky130_fd_sc_hd__tapvpwrvgnd_1
X_07590_ tanh_inst.divider.y\[-19\] _02394_ VGND VGND VPWR VPWR _02395_ sky130_fd_sc_hd__nor2_2
X_06610_ tanh_inst.LOOKUP.index\[1\] tanh_inst.LOOKUP.index\[0\] VGND VGND VPWR VPWR
+ _01523_ sky130_fd_sc_hd__or2_2
X_06541_ _01447_ _01449_ _01445_ VGND VGND VPWR VPWR _01458_ sky130_fd_sc_hd__o21a_2
XFILLER_0_75_503 VGND VGND VPWR VPWR sky130_fd_sc_hd__fill_1
XFILLER_0_1_57 VPWR VGND VPWR VGND sky130_ef_sc_hd__decap_12
X_09260_ tanh_inst.divider.y\[-15\] _03990_ VGND VGND VPWR VPWR _03997_ sky130_fd_sc_hd__or2_2
X_06472_ tanh_inst.divider.y_\[-1\] _01380_ _01394_ VGND VGND VPWR VPWR _01395_ sky130_fd_sc_hd__a21o_2
XFILLER_0_118_638 VGND VGND VPWR VPWR sky130_fd_sc_hd__fill_1
XFILLER_0_75_558 VGND VGND VPWR VPWR sky130_fd_sc_hd__fill_2
X_05423_ _00406_ _00410_ VGND VGND VPWR VPWR _00427_ sky130_fd_sc_hd__and2_2
X_08211_ _02971_ _02975_ _03000_ VGND VGND VPWR VPWR _03002_ sky130_fd_sc_hd__a21o_2
XFILLER_0_117_137 VPWR VGND VPWR VGND sky130_ef_sc_hd__decap_12
X_09191_ _02503_ _03919_ VGND VGND VPWR VPWR _03930_ sky130_fd_sc_hd__nand2_2
XFILLER_0_71_720 VGND VGND VPWR VPWR sky130_fd_sc_hd__decap_4
XFILLER_0_7_335 VGND VGND VPWR VPWR sky130_fd_sc_hd__fill_1
XFILLER_0_28_474 VGND VGND VPWR VPWR sky130_fd_sc_hd__fill_2
X_08142_ tanh_inst.divider.y\[-7\] _02934_ VGND VGND VPWR VPWR _02935_ sky130_fd_sc_hd__nor2_2
XFILLER_0_15_113 VPWR VGND VPWR VGND sky130_ef_sc_hd__decap_12
X_05354_ _04781_ _00357_ _00359_ _00361_ VGND VGND VPWR VPWR _00362_ sky130_fd_sc_hd__o211a_2
XTAP_TAPCELL_ROW_99_1496 VGND VPWR sky130_fd_sc_hd__tapvpwrvgnd_1
X_08073_ tanh_inst.divider.x\[-9\] _02014_ _02867_ _01470_ VGND VGND VPWR VPWR _00248_
+ sky130_fd_sc_hd__o211a_2
X_05285_ _04863_ _04865_ _04866_ _04870_ mac_inst.i\[1\] mac_inst.i\[0\] VGND VGND
+ VPWR VPWR _04985_ sky130_fd_sc_hd__mux4_2
X_07024_ _01858_ _01859_ tanh_inst.divider.z_\[-14\] _01092_ VGND VGND VPWR VPWR _00207_
+ sky130_fd_sc_hd__a2bb2o_2
XFILLER_0_60_3 VPWR VGND VPWR VGND sky130_ef_sc_hd__decap_12
XFILLER_0_30_138 VGND VGND VPWR VPWR sky130_fd_sc_hd__fill_2
XFILLER_0_87_62 VGND VGND VPWR VPWR sky130_fd_sc_hd__decap_6
XFILLER_0_11_385 VGND VGND VPWR VPWR sky130_fd_sc_hd__decap_6
XTAP_TAPCELL_ROW_110_1641 VGND VPWR sky130_fd_sc_hd__tapvpwrvgnd_1
X_08975_ _03662_ _03663_ _03661_ VGND VGND VPWR VPWR _03719_ sky130_fd_sc_hd__a21o_2
X_07926_ _02722_ _02723_ VGND VGND VPWR VPWR _02724_ sky130_fd_sc_hd__nor2_2
X_07857_ tanh_inst.divider.y\[7\] _02281_ _02285_ _02273_ _02023_ _02052_ VGND VGND
+ VPWR VPWR _02656_ sky130_fd_sc_hd__mux4_2
X_07788_ _02552_ _02561_ _02587_ _04791_ VGND VGND VPWR VPWR _02589_ sky130_fd_sc_hd__o31a_2
XFILLER_0_97_127 VGND VGND VPWR VPWR sky130_fd_sc_hd__fill_1
X_06808_ mac_y_out[21] _01469_ _01502_ _01701_ VGND VGND VPWR VPWR _00149_ sky130_fd_sc_hd__a22o_2
X_09527_ tanh_inst.divider.y\[-8\] _04243_ VGND VGND VPWR VPWR _04257_ sky130_fd_sc_hd__nor2_2
X_06739_ tanh_inst.z_\[-10\] _01638_ VGND VGND VPWR VPWR _01640_ sky130_fd_sc_hd__nand2_2
XTAP_TAPCELL_ROW_121_1770 VGND VPWR sky130_fd_sc_hd__tapvpwrvgnd_1
X_09458_ tanh_inst.z_\[7\] _04189_ _04184_ _02019_ VGND VGND VPWR VPWR _04190_ sky130_fd_sc_hd__o211a_2
XTAP_TAPCELL_ROW_61_1028 VGND VPWR sky130_fd_sc_hd__tapvpwrvgnd_1
XFILLER_0_38_249 VGND VGND VPWR VPWR sky130_fd_sc_hd__decap_3
XTAP_TAPCELL_ROW_121_1792 VGND VPWR sky130_fd_sc_hd__tapvpwrvgnd_1
XTAP_TAPCELL_ROW_121_1781 VGND VPWR sky130_fd_sc_hd__tapvpwrvgnd_1
X_09389_ _03984_ _04014_ _04052_ _04082_ VGND VGND VPWR VPWR _04123_ sky130_fd_sc_hd__or4_2
XTAP_TAPCELL_ROW_22_531 VGND VPWR sky130_fd_sc_hd__tapvpwrvgnd_1
XTAP_TAPCELL_ROW_22_542 VGND VPWR sky130_fd_sc_hd__tapvpwrvgnd_1
X_08409_ _03122_ _03128_ _03195_ VGND VGND VPWR VPWR _03196_ sky130_fd_sc_hd__a21oi_2
XTAP_TAPCELL_ROW_50_884 VGND VPWR sky130_fd_sc_hd__tapvpwrvgnd_1
XFILLER_0_116_170 VGND VGND VPWR VPWR sky130_fd_sc_hd__decap_3
XFILLER_0_34_477 VGND VGND VPWR VPWR sky130_fd_sc_hd__decap_6
XFILLER_0_116_192 VGND VGND VPWR VPWR sky130_fd_sc_hd__decap_4
X_10302_ clknet_leaf_22_clk _00159_ VGND VGND VPWR VPWR tanh_inst.z_\[7\] sky130_fd_sc_hd__dfxtp_2
XFILLER_0_21_105 VGND VGND VPWR VPWR sky130_fd_sc_hd__decap_6
XFILLER_0_21_149 VPWR VGND VPWR VGND sky130_ef_sc_hd__decap_12
X_10233_ clknet_leaf_23_clk mac_inst.y\[27\] _00000_ VGND VGND VPWR VPWR mac_y_out[27]
+ sky130_fd_sc_hd__dfrtp_2
XTAP_TAPCELL_ROW_72_1168 VGND VPWR sky130_fd_sc_hd__tapvpwrvgnd_1
XTAP_TAPCELL_ROW_72_1157 VGND VPWR sky130_fd_sc_hd__tapvpwrvgnd_1
X_10095_ clknet_leaf_6_clk _00112_ VGND VGND VPWR VPWR tanh_inst.divider.y_\[2\] sky130_fd_sc_hd__dfxtp_2
XFILLER_0_107_27 VPWR VGND VPWR VGND sky130_ef_sc_hd__decap_12
XFILLER_0_88_149 VGND VGND VPWR VPWR sky130_fd_sc_hd__decap_4
XTAP_TAPCELL_ROW_58_984 VGND VPWR sky130_fd_sc_hd__tapvpwrvgnd_1
XFILLER_0_69_385 VGND VGND VPWR VPWR sky130_fd_sc_hd__decap_6
XFILLER_0_96_193 VGND VGND VPWR VPWR sky130_fd_sc_hd__decap_3
XFILLER_0_84_355 VGND VGND VPWR VPWR sky130_fd_sc_hd__decap_8
XFILLER_0_84_333 VGND VGND VPWR VPWR sky130_fd_sc_hd__decap_4
XTAP_TAPCELL_ROW_83_1297 VGND VPWR sky130_fd_sc_hd__tapvpwrvgnd_1
XFILLER_0_84_388 VPWR VGND VPWR VGND sky130_ef_sc_hd__decap_12
XFILLER_0_84_377 VGND VGND VPWR VPWR sky130_fd_sc_hd__decap_4
XFILLER_0_53_720 VGND VGND VPWR VPWR sky130_fd_sc_hd__decap_4
XFILLER_0_80_561 VGND VGND VPWR VPWR sky130_fd_sc_hd__fill_2
XFILLER_0_13_617 VGND VGND VPWR VPWR sky130_fd_sc_hd__fill_2
XFILLER_0_80_594 VGND VGND VPWR VPWR sky130_fd_sc_hd__decap_3
X_05070_ mac_inst.y\[1\] VGND VGND VPWR VPWR _04794_ sky130_fd_sc_hd__inv_2
XFILLER_0_0_533 VGND VGND VPWR VPWR sky130_fd_sc_hd__decap_6
XFILLER_0_57_98 VGND VGND VPWR VPWR sky130_fd_sc_hd__fill_1
X_05972_ mac_inst.z\[20\] _00901_ _00915_ mac_inst.z\[21\] VGND VGND VPWR VPWR _00929_
+ sky130_fd_sc_hd__a22o_2
X_08760_ mac_inst.i\[30\] _00970_ VGND VGND VPWR VPWR _00295_ sky130_fd_sc_hd__xor2_2
X_08691_ _03447_ _03449_ _03446_ VGND VGND VPWR VPWR _03470_ sky130_fd_sc_hd__a21boi_2
XFILLER_0_73_31 VGND VGND VPWR VPWR sky130_fd_sc_hd__decap_3
X_07711_ _04757_ _02511_ _02513_ _01525_ VGND VGND VPWR VPWR _02514_ sky130_fd_sc_hd__o22a_2
X_07642_ _02444_ _02445_ VGND VGND VPWR VPWR _02446_ sky130_fd_sc_hd__nor2_2
XFILLER_0_88_650 VGND VGND VPWR VPWR sky130_fd_sc_hd__decap_3
XTAP_TAPCELL_ROW_0_248 VGND VPWR sky130_fd_sc_hd__tapvpwrvgnd_1
XTAP_TAPCELL_ROW_0_259 VGND VPWR sky130_fd_sc_hd__tapvpwrvgnd_1
X_07573_ tanh_inst.divider.x\[-20\] _02377_ VGND VGND VPWR VPWR _02379_ sky130_fd_sc_hd__nor2_2
X_09312_ _03944_ _03945_ _03979_ _04008_ tanh_inst.z_\[7\] VGND VGND VPWR VPWR _04048_
+ sky130_fd_sc_hd__a41o_2
X_06524_ _01421_ _01422_ _01430_ VGND VGND VPWR VPWR _01442_ sky130_fd_sc_hd__or3_2
X_06455_ _01357_ _01358_ _01367_ _04793_ VGND VGND VPWR VPWR _01379_ sky130_fd_sc_hd__o31a_2
XFILLER_0_63_517 VPWR VGND VPWR VGND sky130_ef_sc_hd__decap_12
X_09243_ _03979_ _03980_ VGND VGND VPWR VPWR _03981_ sky130_fd_sc_hd__xnor2_2
X_06386_ _01314_ _01315_ VGND VGND VPWR VPWR _01316_ sky130_fd_sc_hd__nor2_2
XFILLER_0_113_81 VPWR VGND VPWR VGND sky130_ef_sc_hd__decap_12
X_09174_ _02022_ _03912_ VGND VGND VPWR VPWR _03913_ sky130_fd_sc_hd__nand2_2
X_05406_ _00395_ _00409_ _00408_ VGND VGND VPWR VPWR _00411_ sky130_fd_sc_hd__o21ai_2
XFILLER_0_105_129 VGND VGND VPWR VPWR sky130_fd_sc_hd__fill_1
X_08125_ _02906_ _02907_ _02910_ _02918_ VGND VGND VPWR VPWR _02919_ sky130_fd_sc_hd__nand4_2
XFILLER_0_43_252 VGND VGND VPWR VPWR sky130_fd_sc_hd__decap_3
X_05337_ _04928_ _05012_ _05011_ VGND VGND VPWR VPWR _00346_ sky130_fd_sc_hd__a21o_2
XFILLER_0_43_274 VGND VGND VPWR VPWR sky130_fd_sc_hd__decap_6
X_08056_ _02801_ _02807_ _02850_ VGND VGND VPWR VPWR _02851_ sky130_fd_sc_hd__and3_2
XFILLER_0_98_83 VGND VGND VPWR VPWR sky130_fd_sc_hd__fill_1
X_05268_ mac_inst.i\[9\] _04937_ _04964_ _04966_ _04968_ VGND VGND VPWR VPWR _04969_
+ sky130_fd_sc_hd__a2111oi_2
X_07007_ _01844_ VGND VGND VPWR VPWR _01845_ sky130_fd_sc_hd__inv_2
XFILLER_0_3_393 VGND VGND VPWR VPWR sky130_fd_sc_hd__decap_8
X_05199_ _04783_ mac_inst.x\[2\] _04852_ VGND VGND VPWR VPWR _04903_ sky130_fd_sc_hd__and3_2
XFILLER_0_11_193 VPWR VGND VPWR VGND sky130_ef_sc_hd__decap_12
XTAP_TAPCELL_ROW_8_359 VGND VPWR sky130_fd_sc_hd__tapvpwrvgnd_1
X_08958_ _03650_ _03652_ tanh_inst.LOOKUP.index\[1\] VGND VGND VPWR VPWR _03702_ sky130_fd_sc_hd__mux2_1
X_07909_ _02544_ _02705_ _02706_ VGND VGND VPWR VPWR _02707_ sky130_fd_sc_hd__a21oi_2
X_08889_ tanh_inst.divider.x\[5\] tanh_inst.divider.x\[6\] tanh_inst.LOOKUP.index\[0\]
+ VGND VGND VPWR VPWR _03634_ sky130_fd_sc_hd__mux2_1
XTAP_TAPCELL_ROW_27_601 VGND VPWR sky130_fd_sc_hd__tapvpwrvgnd_1
XFILLER_0_79_650 VGND VGND VPWR VPWR sky130_fd_sc_hd__fill_1
XFILLER_0_78_171 VPWR VGND VPWR VGND sky130_ef_sc_hd__decap_12
XTAP_TAPCELL_ROW_55_954 VGND VPWR sky130_fd_sc_hd__tapvpwrvgnd_1
XFILLER_0_39_503 VGND VGND VPWR VPWR sky130_fd_sc_hd__fill_1
XFILLER_0_94_653 VGND VGND VPWR VPWR sky130_fd_sc_hd__fill_2
XFILLER_0_109_446 VGND VGND VPWR VPWR sky130_fd_sc_hd__fill_2
XFILLER_0_19_293 VPWR VGND VPWR VGND sky130_ef_sc_hd__decap_12
XFILLER_0_47_591 VGND VGND VPWR VPWR sky130_fd_sc_hd__decap_4
XFILLER_0_105_663 VGND VGND VPWR VPWR sky130_fd_sc_hd__fill_1
XFILLER_0_62_583 VGND VGND VPWR VPWR sky130_fd_sc_hd__decap_4
XFILLER_0_22_414 VGND VGND VPWR VPWR sky130_fd_sc_hd__fill_1
XFILLER_0_105_685 VGND VGND VPWR VPWR sky130_fd_sc_hd__fill_1
XFILLER_0_22_447 VGND VGND VPWR VPWR sky130_fd_sc_hd__fill_2
X_10216_ clknet_leaf_30_clk mac_inst.y\[10\] _00000_ VGND VGND VPWR VPWR mac_y_out[10]
+ sky130_fd_sc_hd__dfrtp_2
XFILLER_0_118_15 VPWR VGND VPWR VGND sky130_ef_sc_hd__decap_12
X_10078_ clknet_leaf_12_clk _00095_ VGND VGND VPWR VPWR tanh_inst.divider.y_\[-15\]
+ sky130_fd_sc_hd__dfxtp_2
XFILLER_0_27_57 VPWR VGND VPWR VGND sky130_ef_sc_hd__decap_12
XTAP_TAPCELL_ROW_85_1326 VGND VPWR sky130_fd_sc_hd__tapvpwrvgnd_1
XFILLER_0_57_311 VGND VGND VPWR VPWR sky130_fd_sc_hd__decap_4
XFILLER_0_97_491 VPWR VGND VPWR VGND sky130_ef_sc_hd__decap_12
XFILLER_0_85_697 VGND VGND VPWR VPWR sky130_fd_sc_hd__decap_3
XFILLER_0_84_141 VGND VGND VPWR VPWR sky130_fd_sc_hd__decap_8
Xclkbuf_0_clk clk VGND VGND VPWR VPWR clknet_0_clk sky130_fd_sc_hd__clkbuf_16
XFILLER_0_45_517 VGND VGND VPWR VPWR sky130_fd_sc_hd__decap_4
X_06240_ _01179_ _01180_ VGND VGND VPWR VPWR _01181_ sky130_fd_sc_hd__xor2_2
XFILLER_0_115_438 VGND VGND VPWR VPWR sky130_fd_sc_hd__decap_3
XFILLER_0_53_561 VPWR VGND VPWR VGND sky130_ef_sc_hd__decap_12
X_06171_ tanh_inst.divider.x\[-5\] tanh_inst.divider.x\[-4\] tanh_inst.divider.x\[-3\]
+ tanh_inst.divider.x\[-2\] tanh_inst.divider.i\[0\] tanh_inst.divider.i\[1\] VGND
+ VGND VPWR VPWR _01115_ sky130_fd_sc_hd__mux4_2
XFILLER_0_53_594 VGND VGND VPWR VPWR sky130_fd_sc_hd__fill_1
XFILLER_0_41_723 VGND VGND VPWR VPWR sky130_fd_sc_hd__fill_1
XTAP_TAPCELL_ROW_96_1466 VGND VPWR sky130_fd_sc_hd__tapvpwrvgnd_1
X_05122_ _04825_ _04830_ VGND VGND VPWR VPWR _00122_ sky130_fd_sc_hd__nor2_2
XFILLER_0_111_633 VGND VGND VPWR VPWR sky130_fd_sc_hd__fill_2
XFILLER_0_110_121 VPWR VGND VPWR VGND sky130_ef_sc_hd__decap_12
X_05053_ tanh_inst.divider.i\[2\] VGND VGND VPWR VPWR _04777_ sky130_fd_sc_hd__inv_2
XFILLER_0_68_53 VGND VGND VPWR VPWR sky130_fd_sc_hd__decap_3
X_09930_ _04643_ _04647_ VGND VGND VPWR VPWR _04648_ sky130_fd_sc_hd__xnor2_2
XPHY_EDGE_ROW_15_Right_15 VGND VGND VPWR VPWR sky130_fd_sc_hd__decap_3
X_09861_ tanh_inst.divider.y\[1\] _04568_ _04579_ VGND VGND VPWR VPWR _04581_ sky130_fd_sc_hd__o21ai_2
X_08812_ tanh_inst.divider.x\[-8\] _02028_ _03508_ VGND VGND VPWR VPWR _03558_ sky130_fd_sc_hd__o21a_2
XTAP_TAPCELL_ROW_5_329 VGND VPWR sky130_fd_sc_hd__tapvpwrvgnd_1
X_09792_ _04506_ _04512_ VGND VGND VPWR VPWR _04514_ sky130_fd_sc_hd__xnor2_2
X_05955_ _00890_ _00898_ _00911_ VGND VGND VPWR VPWR _00913_ sky130_fd_sc_hd__and3_2
X_08743_ _04953_ _03497_ mac_inst.i\[20\] VGND VGND VPWR VPWR _03501_ sky130_fd_sc_hd__a21oi_2
XFILLER_0_84_85 VGND VGND VPWR VPWR sky130_fd_sc_hd__decap_6
XFILLER_0_23_3 VPWR VGND VPWR VGND sky130_ef_sc_hd__decap_12
X_08674_ _03385_ _03388_ _03412_ _03452_ _03411_ VGND VGND VPWR VPWR _03454_ sky130_fd_sc_hd__o311a_2
X_05886_ _04981_ _00847_ VGND VGND VPWR VPWR _00849_ sky130_fd_sc_hd__or2_2
X_07625_ _02427_ _02428_ VGND VGND VPWR VPWR _02430_ sky130_fd_sc_hd__nor2_2
XPHY_EDGE_ROW_24_Right_24 VGND VGND VPWR VPWR sky130_fd_sc_hd__decap_3
XTAP_TAPCELL_ROW_105_1573 VGND VPWR sky130_fd_sc_hd__tapvpwrvgnd_1
X_07556_ _02360_ _02361_ VGND VGND VPWR VPWR _02362_ sky130_fd_sc_hd__and2_2
XFILLER_0_75_130 VGND VGND VPWR VPWR sky130_fd_sc_hd__fill_1
XTAP_TAPCELL_ROW_52_913 VGND VPWR sky130_fd_sc_hd__tapvpwrvgnd_1
XFILLER_0_118_210 VGND VGND VPWR VPWR sky130_fd_sc_hd__fill_1
X_06507_ _01413_ _01419_ _01425_ _01426_ VGND VGND VPWR VPWR _01427_ sky130_fd_sc_hd__a211o_2
XFILLER_0_75_152 VGND VGND VPWR VPWR sky130_fd_sc_hd__fill_2
XFILLER_0_48_377 VGND VGND VPWR VPWR sky130_fd_sc_hd__decap_6
X_09226_ _03962_ _03963_ VGND VGND VPWR VPWR _03964_ sky130_fd_sc_hd__and2_2
X_07487_ _02293_ _02292_ VGND VGND VPWR VPWR _02294_ sky130_fd_sc_hd__and2b_2
XFILLER_0_8_463 VGND VGND VPWR VPWR sky130_fd_sc_hd__fill_1
X_06438_ _01347_ _01354_ _01346_ VGND VGND VPWR VPWR _01364_ sky130_fd_sc_hd__o21ai_2
XFILLER_0_106_438 VGND VGND VPWR VPWR sky130_fd_sc_hd__decap_3
XFILLER_0_63_369 VGND VGND VPWR VPWR sky130_fd_sc_hd__decap_8
XFILLER_0_32_701 VGND VGND VPWR VPWR sky130_fd_sc_hd__fill_2
X_06369_ _01266_ _01267_ _01279_ _01290_ VGND VGND VPWR VPWR _01300_ sky130_fd_sc_hd__nor4_2
X_09157_ _03699_ _03710_ _04759_ VGND VGND VPWR VPWR _03897_ sky130_fd_sc_hd__mux2_1
X_09088_ _02025_ _03587_ _02023_ VGND VGND VPWR VPWR _03829_ sky130_fd_sc_hd__o21a_2
X_08108_ _02894_ _02901_ VGND VGND VPWR VPWR _02902_ sky130_fd_sc_hd__nand2_2
X_08039_ _04762_ _02053_ VGND VGND VPWR VPWR _02834_ sky130_fd_sc_hd__nand2_2
XPHY_EDGE_ROW_33_Right_33 VGND VGND VPWR VPWR sky130_fd_sc_hd__decap_3
X_10001_ _04715_ _04716_ VGND VGND VPWR VPWR _04717_ sky130_fd_sc_hd__nand2_2
XPHY_EDGE_ROW_42_Right_42 VGND VGND VPWR VPWR sky130_fd_sc_hd__decap_3
XPHY_EDGE_ROW_103_Left_225 VGND VGND VPWR VPWR sky130_fd_sc_hd__decap_3
XFILLER_0_13_15 VPWR VGND VPWR VGND sky130_ef_sc_hd__decap_12
XFILLER_0_109_221 VGND VGND VPWR VPWR sky130_fd_sc_hd__decap_3
XFILLER_0_94_472 VGND VGND VPWR VPWR sky130_fd_sc_hd__decap_4
XFILLER_0_54_303 VGND VGND VPWR VPWR sky130_fd_sc_hd__decap_4
XFILLER_0_82_645 VGND VGND VPWR VPWR sky130_fd_sc_hd__fill_1
XFILLER_0_81_122 VPWR VGND VPWR VGND sky130_ef_sc_hd__decap_12
XTAP_TAPCELL_ROW_80_1267 VGND VPWR sky130_fd_sc_hd__tapvpwrvgnd_1
XTAP_TAPCELL_ROW_80_1256 VGND VPWR sky130_fd_sc_hd__tapvpwrvgnd_1
XFILLER_0_120_27 VGND VGND VPWR VPWR sky130_fd_sc_hd__fill_1
XFILLER_0_35_572 VGND VGND VPWR VPWR sky130_fd_sc_hd__decap_4
XPHY_EDGE_ROW_51_Right_51 VGND VGND VPWR VPWR sky130_fd_sc_hd__decap_3
XFILLER_0_112_419 VGND VGND VPWR VPWR sky130_fd_sc_hd__fill_1
XPHY_EDGE_ROW_112_Left_234 VGND VGND VPWR VPWR sky130_fd_sc_hd__decap_3
XTAP_TAPCELL_ROW_10_386 VGND VPWR sky130_fd_sc_hd__tapvpwrvgnd_1
XFILLER_0_1_105 VGND VGND VPWR VPWR sky130_fd_sc_hd__decap_6
XFILLER_0_22_233 VPWR VGND VPWR VGND sky130_ef_sc_hd__decap_12
XFILLER_0_1_149 VPWR VGND VPWR VGND sky130_ef_sc_hd__decap_12
XFILLER_0_22_277 VPWR VGND VPWR VGND sky130_ef_sc_hd__decap_12
XTAP_TAPCELL_ROW_91_1396 VGND VPWR sky130_fd_sc_hd__tapvpwrvgnd_1
XPHY_EDGE_ROW_60_Right_60 VGND VGND VPWR VPWR sky130_fd_sc_hd__decap_3
XPHY_EDGE_ROW_121_Left_243 VGND VGND VPWR VPWR sky130_fd_sc_hd__decap_3
X_05740_ _00698_ _00702_ _00712_ VGND VGND VPWR VPWR _00715_ sky130_fd_sc_hd__a21oi_2
XFILLER_0_54_99 VGND VGND VPWR VPWR sky130_fd_sc_hd__decap_4
X_05671_ _04911_ _00496_ _00509_ VGND VGND VPWR VPWR _00652_ sky130_fd_sc_hd__a21oi_2
X_07410_ _02074_ _02080_ _02082_ _02076_ _04760_ _04761_ VGND VGND VPWR VPWR _02218_
+ sky130_fd_sc_hd__mux4_2
XFILLER_0_9_205 VPWR VGND VPWR VGND sky130_ef_sc_hd__decap_12
XTAP_TAPCELL_ROW_18_486 VGND VPWR sky130_fd_sc_hd__tapvpwrvgnd_1
X_08390_ tanh_inst.divider.x\[-1\] _03163_ VGND VGND VPWR VPWR _03177_ sky130_fd_sc_hd__and2_2
XFILLER_0_85_461 VGND VGND VPWR VPWR sky130_fd_sc_hd__decap_4
X_07341_ tanh_inst.divider.y\[-21\] tanh_inst.divider.y\[-20\] tanh_inst.LOOKUP.index\[0\]
+ VGND VGND VPWR VPWR _02150_ sky130_fd_sc_hd__mux2_1
XFILLER_0_57_130 VPWR VGND VPWR VGND sky130_ef_sc_hd__decap_12
XFILLER_0_9_249 VPWR VGND VPWR VGND sky130_ef_sc_hd__decap_12
XFILLER_0_72_111 VGND VGND VPWR VPWR sky130_fd_sc_hd__fill_1
XFILLER_0_70_98 VGND VGND VPWR VPWR sky130_fd_sc_hd__decap_8
X_07272_ tanh_inst.divider.y\[-2\] _02028_ _02029_ VGND VGND VPWR VPWR _02082_ sky130_fd_sc_hd__o21ai_2
XFILLER_0_5_411 VGND VGND VPWR VPWR sky130_fd_sc_hd__fill_1
X_06223_ _01163_ _01164_ VGND VGND VPWR VPWR _01165_ sky130_fd_sc_hd__xor2_2
X_09011_ _03751_ _03752_ VGND VGND VPWR VPWR _03754_ sky130_fd_sc_hd__nand2_2
XFILLER_0_72_166 VPWR VGND VPWR VGND sky130_ef_sc_hd__decap_12
X_06154_ _01093_ _01094_ _01096_ _01097_ tanh_inst.divider.i\[2\] tanh_inst.divider.i\[3\]
+ VGND VGND VPWR VPWR _01099_ sky130_fd_sc_hd__mux4_2
XPHY_EDGE_ROW_103_Right_103 VGND VGND VPWR VPWR sky130_fd_sc_hd__decap_3
X_05105_ mac_complete _04818_ _04817_ VGND VGND VPWR VPWR _00127_ sky130_fd_sc_hd__a21o_2
X_06085_ tanh_inst.divider.x\[-22\] tanh_inst.divider.x\[-21\] tanh_inst.divider.i\[0\]
+ VGND VGND VPWR VPWR _01032_ sky130_fd_sc_hd__mux2_1
X_09913_ _04629_ _04630_ VGND VGND VPWR VPWR _04632_ sky130_fd_sc_hd__xnor2_2
X_05036_ tanh_inst.LOOKUP.index\[1\] VGND VGND VPWR VPWR _04760_ sky130_fd_sc_hd__inv_2
XFILLER_0_95_51 VGND VGND VPWR VPWR sky130_fd_sc_hd__decap_4
XFILLER_0_0_193 VGND VGND VPWR VPWR sky130_fd_sc_hd__decap_3
X_09844_ _04757_ _04006_ _04212_ VGND VGND VPWR VPWR _04565_ sky130_fd_sc_hd__a21o_2
X_06987_ _01824_ _01826_ VGND VGND VPWR VPWR _01827_ sky130_fd_sc_hd__nor2_2
X_09775_ _04496_ _04497_ VGND VGND VPWR VPWR _04498_ sky130_fd_sc_hd__and2b_2
XTAP_TAPCELL_ROW_107_1602 VGND VPWR sky130_fd_sc_hd__tapvpwrvgnd_1
X_05938_ _00896_ _00897_ VGND VGND VPWR VPWR _05938_/X sky130_fd_sc_hd__xor2_2
X_08726_ mac_inst.i\[11\] _00960_ VGND VGND VPWR VPWR _00276_ sky130_fd_sc_hd__xor2_2
X_08657_ tanh_inst.LOOKUP.index\[4\] _02818_ _02859_ VGND VGND VPWR VPWR _03437_ sky130_fd_sc_hd__o21a_2
X_05869_ mac_inst.z\[13\] _00816_ _00833_ VGND VGND VPWR VPWR _00834_ sky130_fd_sc_hd__a21oi_2
X_07608_ _02360_ _02363_ _02410_ _02411_ VGND VGND VPWR VPWR _02413_ sky130_fd_sc_hd__o2bb2a_2
XFILLER_0_95_269 VGND VGND VPWR VPWR sky130_fd_sc_hd__decap_8
XFILLER_0_64_612 VGND VGND VPWR VPWR sky130_fd_sc_hd__decap_4
XFILLER_0_64_601 VGND VGND VPWR VPWR sky130_fd_sc_hd__fill_1
X_08588_ _03367_ _03368_ _03369_ _03318_ VGND VGND VPWR VPWR _03370_ sky130_fd_sc_hd__o22a_2
XFILLER_0_48_141 VGND VGND VPWR VPWR sky130_fd_sc_hd__fill_1
X_07539_ _02052_ _02344_ _02341_ VGND VGND VPWR VPWR _02345_ sky130_fd_sc_hd__o21a_2
XFILLER_0_106_213 VGND VGND VPWR VPWR sky130_fd_sc_hd__decap_3
XFILLER_0_91_442 VGND VGND VPWR VPWR sky130_fd_sc_hd__fill_1
XFILLER_0_17_550 VGND VGND VPWR VPWR sky130_fd_sc_hd__decap_3
XFILLER_0_106_246 VGND VGND VPWR VPWR sky130_fd_sc_hd__decap_6
X_09209_ tanh_inst.divider.y\[-17\] _03947_ VGND VGND VPWR VPWR _03948_ sky130_fd_sc_hd__and2_2
X_10481_ clknet_leaf_34_clk _00338_ _00082_ VGND VGND VPWR VPWR tanh_counter\[4\]
+ sky130_fd_sc_hd__dfrtp_2
XFILLER_0_17_561 VGND VGND VPWR VPWR sky130_fd_sc_hd__fill_1
XTAP_TAPCELL_ROW_118_1742 VGND VPWR sky130_fd_sc_hd__tapvpwrvgnd_1
XTAP_TAPCELL_ROW_118_1731 VGND VPWR sky130_fd_sc_hd__tapvpwrvgnd_1
XFILLER_0_121_249 VGND VGND VPWR VPWR sky130_fd_sc_hd__decap_3
XFILLER_0_99_553 VGND VGND VPWR VPWR sky130_fd_sc_hd__fill_2
XTAP_TAPCELL_ROW_69_1129 VGND VPWR sky130_fd_sc_hd__tapvpwrvgnd_1
XFILLER_0_115_27 VPWR VGND VPWR VGND sky130_ef_sc_hd__decap_12
XFILLER_0_99_597 VGND VGND VPWR VPWR sky130_fd_sc_hd__fill_2
XFILLER_0_67_483 VPWR VGND VPWR VGND sky130_ef_sc_hd__decap_12
XTAP_TAPCELL_ROW_15_445 VGND VPWR sky130_fd_sc_hd__tapvpwrvgnd_1
XFILLER_0_55_678 VGND VGND VPWR VPWR sky130_fd_sc_hd__decap_8
XTAP_TAPCELL_ROW_43_798 VGND VPWR sky130_fd_sc_hd__tapvpwrvgnd_1
XFILLER_0_54_166 VGND VGND VPWR VPWR sky130_fd_sc_hd__decap_8
XFILLER_0_40_46 VGND VGND VPWR VPWR sky130_fd_sc_hd__decap_3
XFILLER_0_42_339 VGND VGND VPWR VPWR sky130_fd_sc_hd__decap_8
XTAP_TAPCELL_ROW_93_1425 VGND VPWR sky130_fd_sc_hd__tapvpwrvgnd_1
X_06910_ tanh_inst.div_en tanh_inst.divider.z_\[-8\] VGND VGND VPWR VPWR _00181_ sky130_fd_sc_hd__and2b_2
XFILLER_0_49_99 VGND VGND VPWR VPWR sky130_fd_sc_hd__decap_6
X_07890_ _02018_ _02687_ _02688_ _02015_ VGND VGND VPWR VPWR _02689_ sky130_fd_sc_hd__a31o_2
X_06841_ _01729_ _01730_ VGND VGND VPWR VPWR _01731_ sky130_fd_sc_hd__xnor2_2
X_06772_ _01658_ _01663_ VGND VGND VPWR VPWR _01670_ sky130_fd_sc_hd__nand2_2
X_09560_ _04163_ _04228_ _04229_ tanh_inst.z_\[7\] VGND VGND VPWR VPWR _04289_ sky130_fd_sc_hd__a31o_2
X_09491_ tanh_inst.divider.y\[-10\] _04165_ _04216_ tanh_inst.divider.y\[-9\] VGND
+ VGND VPWR VPWR _04221_ sky130_fd_sc_hd__a22o_2
X_05723_ mac_inst.z\[3\] _00694_ VGND VGND VPWR VPWR _00699_ sky130_fd_sc_hd__xnor2_2
X_08511_ _03289_ _03293_ VGND VGND VPWR VPWR _03295_ sky130_fd_sc_hd__and2_2
XFILLER_0_81_42 VGND VGND VPWR VPWR sky130_fd_sc_hd__fill_1
XFILLER_0_77_225 VPWR VGND VPWR VGND sky130_ef_sc_hd__decap_12
X_08442_ _03226_ _03227_ VGND VGND VPWR VPWR _03228_ sky130_fd_sc_hd__xnor2_2
X_05654_ mac_inst.y\[28\] _00636_ VGND VGND VPWR VPWR _00637_ sky130_fd_sc_hd__nand2_2
XFILLER_0_105_93 VPWR VGND VPWR VGND sky130_ef_sc_hd__decap_12
XTAP_TAPCELL_ROW_102_1543 VGND VPWR sky130_fd_sc_hd__tapvpwrvgnd_1
XTAP_TAPCELL_ROW_102_1532 VGND VPWR sky130_fd_sc_hd__tapvpwrvgnd_1
X_08373_ _02018_ _03127_ _03128_ VGND VGND VPWR VPWR _03161_ sky130_fd_sc_hd__and3_2
X_05585_ _00573_ _00574_ VGND VGND VPWR VPWR _05585_/Y sky130_fd_sc_hd__xnor2_2
XFILLER_0_45_100 VGND VGND VPWR VPWR sky130_fd_sc_hd__decap_4
X_07324_ _02025_ _02132_ _02131_ VGND VGND VPWR VPWR _02133_ sky130_fd_sc_hd__a21o_2
XFILLER_0_45_122 VGND VGND VPWR VPWR sky130_fd_sc_hd__decap_6
XFILLER_0_46_645 VGND VGND VPWR VPWR sky130_fd_sc_hd__decap_4
XFILLER_0_116_555 VGND VGND VPWR VPWR sky130_fd_sc_hd__decap_4
XFILLER_0_90_3 VPWR VGND VPWR VGND sky130_ef_sc_hd__decap_12
X_07255_ _02022_ _02050_ _02053_ _02064_ VGND VGND VPWR VPWR _02065_ sky130_fd_sc_hd__a211oi_2
XFILLER_0_73_486 VGND VGND VPWR VPWR sky130_fd_sc_hd__fill_1
XFILLER_0_45_166 VGND VGND VPWR VPWR sky130_fd_sc_hd__fill_2
XFILLER_0_121_81 VGND VGND VPWR VPWR sky130_fd_sc_hd__decap_3
XFILLER_0_116_566 VGND VGND VPWR VPWR sky130_fd_sc_hd__fill_1
X_06206_ _01146_ _01148_ VGND VGND VPWR VPWR _01149_ sky130_fd_sc_hd__xnor2_2
X_07186_ _01088_ _00194_ _02002_ _01059_ VGND VGND VPWR VPWR _00226_ sky130_fd_sc_hd__o22a_2
XFILLER_0_41_361 VPWR VGND VPWR VGND sky130_ef_sc_hd__decap_12
X_06137_ _04776_ _01073_ _01078_ _01082_ VGND VGND VPWR VPWR _01083_ sky130_fd_sc_hd__o211ai_2
X_06068_ _00837_ _00846_ VGND VGND VPWR VPWR _01016_ sky130_fd_sc_hd__nand2_2
XTAP_TAPCELL_ROW_113_1672 VGND VPWR sky130_fd_sc_hd__tapvpwrvgnd_1
X_09827_ _03256_ _04546_ VGND VGND VPWR VPWR _04548_ sky130_fd_sc_hd__nor2_2
X_09758_ _04764_ _04473_ VGND VGND VPWR VPWR _04481_ sky130_fd_sc_hd__and2_2
X_08709_ tanh_inst.divider.x\[7\] _02014_ _03480_ _03487_ _01470_ VGND VGND VPWR VPWR
+ _00264_ sky130_fd_sc_hd__o221a_2
X_09689_ _04388_ _04391_ _04413_ VGND VGND VPWR VPWR _04414_ sky130_fd_sc_hd__nor3_2
XFILLER_0_83_206 VGND VGND VPWR VPWR sky130_fd_sc_hd__decap_3
XFILLER_0_49_461 VGND VGND VPWR VPWR sky130_fd_sc_hd__decap_3
XFILLER_0_76_280 VPWR VGND VPWR VGND sky130_ef_sc_hd__decap_12
XTAP_TAPCELL_ROW_64_1059 VGND VPWR sky130_fd_sc_hd__tapvpwrvgnd_1
XTAP_TAPCELL_ROW_12_415 VGND VPWR sky130_fd_sc_hd__tapvpwrvgnd_1
XFILLER_0_91_250 VGND VGND VPWR VPWR sky130_fd_sc_hd__decap_4
XFILLER_0_64_464 VPWR VGND VPWR VGND sky130_ef_sc_hd__decap_12
XTAP_TAPCELL_ROW_40_757 VGND VPWR sky130_fd_sc_hd__tapvpwrvgnd_1
XTAP_TAPCELL_ROW_40_768 VGND VPWR sky130_fd_sc_hd__tapvpwrvgnd_1
XFILLER_0_10_27 VGND VGND VPWR VPWR sky130_fd_sc_hd__fill_1
XFILLER_0_20_501 VPWR VGND VPWR VGND sky130_ef_sc_hd__decap_12
X_10464_ clknet_leaf_41_clk _00321_ VGND VGND VPWR VPWR tanh_inst.divider.y\[0\] sky130_fd_sc_hd__dfxtp_2
XFILLER_0_32_350 VGND VGND VPWR VPWR sky130_fd_sc_hd__fill_1
XFILLER_0_51_169 VGND VGND VPWR VPWR sky130_fd_sc_hd__decap_3
XFILLER_0_60_692 VGND VGND VPWR VPWR sky130_fd_sc_hd__decap_3
XFILLER_0_32_361 VGND VGND VPWR VPWR sky130_fd_sc_hd__decap_3
X_10395_ clknet_2_0__leaf_clk _00252_ VGND VGND VPWR VPWR tanh_inst.divider.x\[-5\]
+ sky130_fd_sc_hd__dfxtp_2
XFILLER_0_102_260 VGND VGND VPWR VPWR sky130_fd_sc_hd__decap_6
XTAP_TAPCELL_ROW_75_1199 VGND VPWR sky130_fd_sc_hd__tapvpwrvgnd_1
XFILLER_0_20_589 VGND VGND VPWR VPWR sky130_fd_sc_hd__fill_2
XFILLER_0_19_69 VPWR VGND VPWR VGND sky130_ef_sc_hd__decap_12
XFILLER_0_99_361 VGND VGND VPWR VPWR sky130_fd_sc_hd__fill_1
XFILLER_0_35_35 VGND VGND VPWR VPWR sky130_fd_sc_hd__decap_8
XTAP_TAPCELL_ROW_48_857 VGND VPWR sky130_fd_sc_hd__tapvpwrvgnd_1
XTAP_TAPCELL_ROW_48_868 VGND VPWR sky130_fd_sc_hd__tapvpwrvgnd_1
XFILLER_0_7_517 VGND VGND VPWR VPWR sky130_fd_sc_hd__fill_2
X_05370_ _04927_ _05008_ _05030_ _00363_ VGND VGND VPWR VPWR _00377_ sky130_fd_sc_hd__and4_2
XFILLER_0_51_78 VGND VGND VPWR VPWR sky130_fd_sc_hd__decap_4
XFILLER_0_15_317 VPWR VGND VPWR VGND sky130_ef_sc_hd__decap_12
XFILLER_0_27_166 VGND VGND VPWR VPWR sky130_fd_sc_hd__fill_2
XFILLER_0_28_678 VGND VGND VPWR VPWR sky130_fd_sc_hd__decap_3
XFILLER_0_42_114 VGND VGND VPWR VPWR sky130_fd_sc_hd__decap_6
Xclkload10 clknet_leaf_27_clk VGND VGND VPWR VPWR clkload10/Y sky130_fd_sc_hd__inv_12
Xclkload32 clknet_leaf_15_clk VGND VGND VPWR VPWR clkload32/Y sky130_fd_sc_hd__clkinv_8
X_07040_ _01864_ _01873_ _01872_ VGND VGND VPWR VPWR _01874_ sky130_fd_sc_hd__a21oi_2
Xclkload21 clknet_leaf_2_clk VGND VGND VPWR VPWR clkload21/Y sky130_fd_sc_hd__clkinv_4
XFILLER_0_113_569 VGND VGND VPWR VPWR sky130_fd_sc_hd__fill_1
XFILLER_0_11_501 VGND VGND VPWR VPWR sky130_fd_sc_hd__decap_3
XFILLER_0_2_233 VPWR VGND VPWR VGND sky130_ef_sc_hd__decap_12
XFILLER_0_2_277 VPWR VGND VPWR VGND sky130_ef_sc_hd__decap_12
X_08991_ _03544_ _03545_ _03546_ _03556_ _04761_ tanh_inst.LOOKUP.index\[1\] VGND
+ VGND VPWR VPWR _03734_ sky130_fd_sc_hd__mux4_2
XFILLER_0_76_53 VPWR VGND VPWR VGND sky130_ef_sc_hd__decap_12
X_07942_ tanh_inst.divider.x\[-12\] _02738_ VGND VGND VPWR VPWR _02740_ sky130_fd_sc_hd__nand2_2
X_07873_ _02656_ _02671_ VGND VGND VPWR VPWR _02672_ sky130_fd_sc_hd__nor2_2
X_06824_ _01714_ _01715_ VGND VGND VPWR VPWR _01716_ sky130_fd_sc_hd__nor2_2
X_09612_ tanh_inst.divider.x\[-5\] _04337_ VGND VGND VPWR VPWR _04339_ sky130_fd_sc_hd__and2_2
XFILLER_0_92_41 VGND VGND VPWR VPWR sky130_fd_sc_hd__decap_6
X_09543_ _04270_ _04271_ VGND VGND VPWR VPWR _04272_ sky130_fd_sc_hd__or2_2
XFILLER_0_92_85 VGND VGND VPWR VPWR sky130_fd_sc_hd__decap_4
X_06755_ tanh_inst.LOOKUP.index\[0\] _01478_ _01525_ _01653_ VGND VGND VPWR VPWR _01654_
+ sky130_fd_sc_hd__o31a_2
X_09474_ _04178_ _04182_ _04203_ tanh_inst.z_\[7\] VGND VGND VPWR VPWR _04205_ sky130_fd_sc_hd__o31a_2
X_06686_ _01591_ _01592_ VGND VGND VPWR VPWR _01593_ sky130_fd_sc_hd__or2_2
XFILLER_0_78_556 VGND VGND VPWR VPWR sky130_fd_sc_hd__fill_2
X_05706_ _04795_ _00669_ _00681_ VGND VGND VPWR VPWR _00683_ sky130_fd_sc_hd__a21o_2
X_05637_ _00620_ _00621_ VGND VGND VPWR VPWR _00622_ sky130_fd_sc_hd__nor2_2
X_08425_ _03154_ _03210_ VGND VGND VPWR VPWR _03211_ sky130_fd_sc_hd__nor2_2
XFILLER_0_93_559 VGND VGND VPWR VPWR sky130_fd_sc_hd__fill_1
XFILLER_0_58_280 VGND VGND VPWR VPWR sky130_fd_sc_hd__fill_1
XFILLER_0_18_133 VGND VGND VPWR VPWR sky130_fd_sc_hd__decap_6
X_08356_ _03141_ _03143_ VGND VGND VPWR VPWR _03144_ sky130_fd_sc_hd__nand2_2
XFILLER_0_46_453 VGND VGND VPWR VPWR sky130_fd_sc_hd__decap_8
XFILLER_0_61_401 VGND VGND VPWR VPWR sky130_fd_sc_hd__decap_4
XFILLER_0_18_177 VPWR VGND VPWR VGND sky130_ef_sc_hd__decap_12
Xclkload4 clknet_leaf_38_clk VGND VGND VPWR VPWR clkload4/Y sky130_fd_sc_hd__inv_6
X_07307_ _02115_ _02116_ _04759_ VGND VGND VPWR VPWR _02117_ sky130_fd_sc_hd__mux2_1
X_05568_ _00545_ _00550_ _00544_ VGND VGND VPWR VPWR _00560_ sky130_fd_sc_hd__o21ai_2
XFILLER_0_46_475 VGND VGND VPWR VPWR sky130_fd_sc_hd__fill_1
XFILLER_0_46_486 VGND VGND VPWR VPWR sky130_fd_sc_hd__decap_8
X_05499_ mac_inst.i\[3\] _00399_ _00412_ VGND VGND VPWR VPWR _00496_ sky130_fd_sc_hd__o21a_2
XFILLER_0_33_136 VPWR VGND VPWR VGND sky130_ef_sc_hd__decap_12
X_08287_ _02990_ _03022_ VGND VGND VPWR VPWR _03077_ sky130_fd_sc_hd__or2_2
XTAP_TAPCELL_ROW_115_1701 VGND VPWR sky130_fd_sc_hd__tapvpwrvgnd_1
X_07238_ tanh_inst.LOOKUP.index\[0\] _02044_ _02047_ VGND VGND VPWR VPWR _02048_ sky130_fd_sc_hd__a21o_2
XFILLER_0_61_467 VPWR VGND VPWR VGND sky130_ef_sc_hd__decap_12
X_07169_ _01979_ _01985_ _01987_ VGND VGND VPWR VPWR _01988_ sky130_fd_sc_hd__a21oi_2
XFILLER_0_104_558 VGND VGND VPWR VPWR sky130_fd_sc_hd__decap_8
XFILLER_0_100_720 VGND VGND VPWR VPWR sky130_fd_sc_hd__decap_4
X_10180_ x_in[6] _00000_ VGND VGND VPWR VPWR mac_inst.x\[6\] sky130_fd_sc_hd__dlxtn_1
XFILLER_0_88_309 VPWR VGND VPWR VGND sky130_ef_sc_hd__decap_12
XTAP_TAPCELL_ROW_45_827 VGND VPWR sky130_fd_sc_hd__tapvpwrvgnd_1
XTAP_TAPCELL_ROW_25_573 VGND VPWR sky130_fd_sc_hd__tapvpwrvgnd_1
XFILLER_0_21_15 VPWR VGND VPWR VGND sky130_ef_sc_hd__decap_12
XFILLER_0_25_615 VGND VGND VPWR VPWR sky130_fd_sc_hd__fill_1
XFILLER_0_24_125 VGND VGND VPWR VPWR sky130_fd_sc_hd__fill_2
XFILLER_0_37_497 VGND VGND VPWR VPWR sky130_fd_sc_hd__decap_6
XTAP_TAPCELL_ROW_77_1228 VGND VPWR sky130_fd_sc_hd__tapvpwrvgnd_1
XFILLER_0_12_309 VPWR VGND VPWR VGND sky130_ef_sc_hd__decap_12
X_10447_ clknet_leaf_9_clk _00304_ VGND VGND VPWR VPWR tanh_inst.divider.y\[-17\]
+ sky130_fd_sc_hd__dfxtp_2
X_10378_ clknet_leaf_25_clk _00235_ VGND VGND VPWR VPWR tanh_inst.divider.x\[-22\]
+ sky130_fd_sc_hd__dfxtp_2
XTAP_TAPCELL_ROW_88_1357 VGND VPWR sky130_fd_sc_hd__tapvpwrvgnd_1
XTAP_TAPCELL_ROW_88_1368 VGND VPWR sky130_fd_sc_hd__tapvpwrvgnd_1
X_06540_ tanh_inst.divider.y_\[6\] _01455_ VGND VGND VPWR VPWR _01457_ sky130_fd_sc_hd__xnor2_2
XFILLER_0_1_69 VPWR VGND VPWR VGND sky130_ef_sc_hd__decap_12
X_06471_ tanh_inst.divider.y_\[-1\] _01380_ _01370_ VGND VGND VPWR VPWR _01394_ sky130_fd_sc_hd__o21a_2
XFILLER_0_117_105 VGND VGND VPWR VPWR sky130_fd_sc_hd__decap_6
X_05422_ _00423_ _00425_ VGND VGND VPWR VPWR _00426_ sky130_fd_sc_hd__nand2_2
XFILLER_0_47_239 VGND VGND VPWR VPWR sky130_fd_sc_hd__fill_1
X_08210_ _02971_ _02975_ _03000_ VGND VGND VPWR VPWR _03001_ sky130_fd_sc_hd__nand3_2
XFILLER_0_117_149 VPWR VGND VPWR VGND sky130_ef_sc_hd__decap_12
X_09190_ _03927_ _03928_ VGND VGND VPWR VPWR _03929_ sky130_fd_sc_hd__xnor2_2
X_08141_ tanh_inst.divider.x\[-7\] _02924_ VGND VGND VPWR VPWR _02934_ sky130_fd_sc_hd__xnor2_2
XFILLER_0_15_125 VPWR VGND VPWR VGND sky130_ef_sc_hd__decap_12
XFILLER_0_16_659 VGND VGND VPWR VPWR sky130_fd_sc_hd__decap_8
X_05353_ _04922_ _00360_ VGND VGND VPWR VPWR _00361_ sky130_fd_sc_hd__nand2_2
X_08072_ _02018_ _02857_ _02866_ VGND VGND VPWR VPWR _02867_ sky130_fd_sc_hd__o21bai_2
XFILLER_0_15_169 VPWR VGND VPWR VGND sky130_ef_sc_hd__decap_12
X_05284_ _04855_ _04858_ _04860_ _04864_ mac_inst.i\[1\] mac_inst.i\[0\] VGND VGND
+ VPWR VPWR _04984_ sky130_fd_sc_hd__mux4_2
XFILLER_0_102_83 VGND VGND VPWR VPWR sky130_fd_sc_hd__fill_1
XTAP_TAPCELL_ROW_99_1497 VGND VPWR sky130_fd_sc_hd__tapvpwrvgnd_1
X_07023_ _01850_ _01856_ _01857_ _01089_ VGND VGND VPWR VPWR _01859_ sky130_fd_sc_hd__a31o_2
XFILLER_0_11_81 VPWR VGND VPWR VGND sky130_ef_sc_hd__decap_12
XFILLER_0_3_531 VGND VGND VPWR VPWR sky130_fd_sc_hd__fill_2
XFILLER_0_30_117 VPWR VGND VPWR VGND sky130_ef_sc_hd__decap_12
XTAP_TAPCELL_ROW_110_1631 VGND VPWR sky130_fd_sc_hd__tapvpwrvgnd_1
XFILLER_0_87_96 VGND VGND VPWR VPWR sky130_fd_sc_hd__decap_4
X_08974_ _03716_ _03717_ VGND VGND VPWR VPWR _03718_ sky130_fd_sc_hd__nand2b_2
XFILLER_0_53_3 VGND VGND VPWR VPWR sky130_fd_sc_hd__decap_4
XTAP_TAPCELL_ROW_110_1642 VGND VPWR sky130_fd_sc_hd__tapvpwrvgnd_1
X_07925_ _02691_ _02721_ VGND VGND VPWR VPWR _02723_ sky130_fd_sc_hd__and2_2
XPHY_EDGE_ROW_89_Right_89 VGND VGND VPWR VPWR sky130_fd_sc_hd__decap_3
XFILLER_0_98_629 VPWR VGND VPWR VGND sky130_ef_sc_hd__decap_12
XFILLER_0_97_117 VGND VGND VPWR VPWR sky130_fd_sc_hd__fill_1
X_07856_ _02022_ _02281_ _02488_ VGND VGND VPWR VPWR _02655_ sky130_fd_sc_hd__o21ai_2
X_07787_ _02552_ _02561_ _02587_ VGND VGND VPWR VPWR _02588_ sky130_fd_sc_hd__o21ai_2
X_06807_ _01699_ _01700_ VGND VGND VPWR VPWR _01701_ sky130_fd_sc_hd__xor2_2
XFILLER_0_78_331 VGND VGND VPWR VPWR sky130_fd_sc_hd__decap_8
X_09526_ tanh_inst.divider.y\[-8\] _04243_ VGND VGND VPWR VPWR _04256_ sky130_fd_sc_hd__and2_2
X_06738_ tanh_inst.z_\[-10\] _01638_ VGND VGND VPWR VPWR _01639_ sky130_fd_sc_hd__and2_2
X_09457_ _04186_ _04188_ VGND VGND VPWR VPWR _04189_ sky130_fd_sc_hd__xnor2_2
XFILLER_0_38_206 VGND VGND VPWR VPWR sky130_fd_sc_hd__decap_6
XTAP_TAPCELL_ROW_121_1771 VGND VPWR sky130_fd_sc_hd__tapvpwrvgnd_1
XFILLER_0_109_617 VGND VGND VPWR VPWR sky130_fd_sc_hd__fill_1
XPHY_EDGE_ROW_98_Right_98 VGND VGND VPWR VPWR sky130_fd_sc_hd__decap_3
X_06669_ _01565_ _01576_ _01577_ VGND VGND VPWR VPWR _01578_ sky130_fd_sc_hd__and3_2
XFILLER_0_66_559 VGND VGND VPWR VPWR sky130_fd_sc_hd__decap_3
XFILLER_0_66_548 VGND VGND VPWR VPWR sky130_fd_sc_hd__decap_3
XTAP_TAPCELL_ROW_61_1029 VGND VPWR sky130_fd_sc_hd__tapvpwrvgnd_1
X_08408_ _03193_ _03194_ VGND VGND VPWR VPWR _03195_ sky130_fd_sc_hd__nand2b_2
XTAP_TAPCELL_ROW_121_1793 VGND VPWR sky130_fd_sc_hd__tapvpwrvgnd_1
XTAP_TAPCELL_ROW_121_1782 VGND VPWR sky130_fd_sc_hd__tapvpwrvgnd_1
X_09388_ tanh_inst.divider.y\[-13\] _04080_ _04050_ VGND VGND VPWR VPWR _04122_ sky130_fd_sc_hd__o21bai_2
XTAP_TAPCELL_ROW_22_532 VGND VPWR sky130_fd_sc_hd__tapvpwrvgnd_1
XTAP_TAPCELL_ROW_22_543 VGND VPWR sky130_fd_sc_hd__tapvpwrvgnd_1
XFILLER_0_46_250 VGND VGND VPWR VPWR sky130_fd_sc_hd__fill_2
XFILLER_0_117_650 VGND VGND VPWR VPWR sky130_fd_sc_hd__fill_2
XFILLER_0_61_220 VGND VGND VPWR VPWR sky130_fd_sc_hd__decap_4
X_08339_ _03124_ _03126_ VGND VGND VPWR VPWR _03127_ sky130_fd_sc_hd__or2_2
XTAP_TAPCELL_ROW_50_885 VGND VPWR sky130_fd_sc_hd__tapvpwrvgnd_1
XFILLER_0_104_333 VGND VGND VPWR VPWR sky130_fd_sc_hd__decap_6
X_10301_ clknet_leaf_23_clk _00158_ VGND VGND VPWR VPWR tanh_inst.z_\[6\] sky130_fd_sc_hd__dfxtp_2
XFILLER_0_30_651 VGND VGND VPWR VPWR sky130_fd_sc_hd__decap_3
X_10232_ clknet_leaf_29_clk mac_inst.y\[26\] _00000_ VGND VGND VPWR VPWR mac_y_out[26]
+ sky130_fd_sc_hd__dfrtp_2
XTAP_TAPCELL_ROW_72_1158 VGND VPWR sky130_fd_sc_hd__tapvpwrvgnd_1
XFILLER_0_100_572 VGND VGND VPWR VPWR sky130_fd_sc_hd__decap_6
X_10094_ clknet_leaf_6_clk _00111_ VGND VGND VPWR VPWR tanh_inst.divider.y_\[1\] sky130_fd_sc_hd__dfxtp_2
XFILLER_0_107_39 VPWR VGND VPWR VGND sky130_ef_sc_hd__decap_12
XFILLER_0_16_15 VPWR VGND VPWR VGND sky130_ef_sc_hd__decap_12
XFILLER_0_88_117 VGND VGND VPWR VPWR sky130_fd_sc_hd__fill_1
XTAP_TAPCELL_ROW_58_985 VGND VPWR sky130_fd_sc_hd__tapvpwrvgnd_1
XFILLER_0_69_331 VGND VGND VPWR VPWR sky130_fd_sc_hd__decap_4
XTAP_TAPCELL_ROW_2_290 VGND VPWR sky130_fd_sc_hd__tapvpwrvgnd_1
XFILLER_0_97_673 VGND VGND VPWR VPWR sky130_fd_sc_hd__fill_2
XFILLER_0_96_172 VGND VGND VPWR VPWR sky130_fd_sc_hd__decap_3
XTAP_TAPCELL_ROW_83_1298 VGND VPWR sky130_fd_sc_hd__tapvpwrvgnd_1
XFILLER_0_44_209 VGND VGND VPWR VPWR sky130_fd_sc_hd__fill_1
XFILLER_0_107_182 VGND VGND VPWR VPWR sky130_fd_sc_hd__fill_1
XFILLER_0_52_275 VGND VGND VPWR VPWR sky130_fd_sc_hd__decap_8
XFILLER_0_12_139 VGND VGND VPWR VPWR sky130_fd_sc_hd__fill_1
XFILLER_0_0_501 VGND VGND VPWR VPWR sky130_fd_sc_hd__decap_3
XFILLER_0_110_325 VGND VGND VPWR VPWR sky130_fd_sc_hd__fill_1
XFILLER_0_0_589 VPWR VGND VPWR VGND sky130_ef_sc_hd__decap_12
X_07710_ _02310_ _02321_ _04759_ VGND VGND VPWR VPWR _02513_ sky130_fd_sc_hd__mux2_1
X_05971_ _00908_ _00926_ _00927_ VGND VGND VPWR VPWR _00928_ sky130_fd_sc_hd__a21o_2
X_08690_ _03451_ _03454_ VGND VGND VPWR VPWR _03469_ sky130_fd_sc_hd__nor2_2
X_07641_ tanh_inst.divider.y\[-18\] _02443_ VGND VGND VPWR VPWR _02445_ sky130_fd_sc_hd__and2_2
X_07572_ tanh_inst.divider.x\[-20\] _02377_ VGND VGND VPWR VPWR _02378_ sky130_fd_sc_hd__and2_2
XTAP_TAPCELL_ROW_0_249 VGND VPWR sky130_fd_sc_hd__tapvpwrvgnd_1
X_06523_ tanh_inst.divider.i\[4\] _01264_ _01289_ VGND VGND VPWR VPWR _01441_ sky130_fd_sc_hd__o21a_2
XFILLER_0_94_109 VGND VGND VPWR VPWR sky130_fd_sc_hd__fill_2
XFILLER_0_87_150 VPWR VGND VPWR VGND sky130_ef_sc_hd__decap_12
X_09311_ _03944_ _03945_ _03979_ _04008_ VGND VGND VPWR VPWR _04047_ sky130_fd_sc_hd__and4_2
X_06454_ tanh_inst.divider.i\[4\] _01189_ _01289_ VGND VGND VPWR VPWR _01378_ sky130_fd_sc_hd__o21a_2
XFILLER_0_63_529 VPWR VGND VPWR VGND sky130_ef_sc_hd__decap_12
X_09242_ _03944_ _03945_ tanh_inst.z_\[7\] VGND VGND VPWR VPWR _03980_ sky130_fd_sc_hd__a21o_2
XFILLER_0_8_645 VGND VGND VPWR VPWR sky130_fd_sc_hd__decap_3
XFILLER_0_8_623 VGND VGND VPWR VPWR sky130_fd_sc_hd__fill_1
XFILLER_0_7_111 VGND VGND VPWR VPWR sky130_fd_sc_hd__fill_1
XFILLER_0_35_209 VPWR VGND VPWR VGND sky130_ef_sc_hd__decap_12
X_06385_ tanh_inst.divider.y_\[-7\] _01312_ VGND VGND VPWR VPWR _01315_ sky130_fd_sc_hd__and2b_2
XFILLER_0_106_609 VGND VGND VPWR VPWR sky130_fd_sc_hd__fill_1
X_09173_ _03723_ _03735_ _02024_ VGND VGND VPWR VPWR _03912_ sky130_fd_sc_hd__mux2_1
XFILLER_0_8_678 VGND VGND VPWR VPWR sky130_fd_sc_hd__fill_1
X_05405_ _00395_ _00408_ _00409_ VGND VGND VPWR VPWR _00410_ sky130_fd_sc_hd__or3_2
XFILLER_0_113_93 VPWR VGND VPWR VGND sky130_ef_sc_hd__decap_12
X_05336_ _00343_ _00344_ VGND VGND VPWR VPWR _00345_ sky130_fd_sc_hd__nand2_2
X_08124_ _02916_ _02917_ VGND VGND VPWR VPWR _02918_ sky130_fd_sc_hd__nand2_2
X_08055_ _02848_ _02849_ VGND VGND VPWR VPWR _02850_ sky130_fd_sc_hd__nand2_2
XFILLER_0_3_361 VPWR VGND VPWR VGND sky130_ef_sc_hd__decap_12
X_05267_ mac_inst.i\[12\] _04838_ _04938_ _04967_ VGND VGND VPWR VPWR _04968_ sky130_fd_sc_hd__o31a_2
XFILLER_0_43_297 VGND VGND VPWR VPWR sky130_fd_sc_hd__fill_1
X_07006_ _01840_ _01841_ _01842_ VGND VGND VPWR VPWR _01844_ sky130_fd_sc_hd__and3_2
XFILLER_0_12_673 VGND VGND VPWR VPWR sky130_fd_sc_hd__fill_1
X_05198_ _04892_ _04901_ mac_inst.i\[2\] VGND VGND VPWR VPWR _04902_ sky130_fd_sc_hd__mux2_1
XFILLER_0_11_161 VGND VGND VPWR VPWR sky130_fd_sc_hd__decap_6
X_08957_ _03699_ _03700_ tanh_inst.LOOKUP.index\[2\] VGND VGND VPWR VPWR _03701_ sky130_fd_sc_hd__mux2_1
X_07908_ _02662_ _02663_ _02703_ _02622_ _02704_ VGND VGND VPWR VPWR _02706_ sky130_fd_sc_hd__a221o_2
X_08888_ tanh_inst.divider.x\[1\] tanh_inst.divider.x\[2\] tanh_inst.divider.x\[3\]
+ tanh_inst.divider.x\[4\] tanh_inst.LOOKUP.index\[0\] tanh_inst.LOOKUP.index\[1\]
+ VGND VGND VPWR VPWR _03633_ sky130_fd_sc_hd__mux4_2
X_07839_ _04791_ _02637_ _02638_ _02018_ VGND VGND VPWR VPWR _02639_ sky130_fd_sc_hd__a31oi_2
XTAP_TAPCELL_ROW_27_602 VGND VPWR sky130_fd_sc_hd__tapvpwrvgnd_1
XTAP_TAPCELL_ROW_55_944 VGND VPWR sky130_fd_sc_hd__tapvpwrvgnd_1
XFILLER_0_79_673 VGND VGND VPWR VPWR sky130_fd_sc_hd__fill_1
XFILLER_0_78_161 VGND VGND VPWR VPWR sky130_fd_sc_hd__fill_1
XTAP_TAPCELL_ROW_55_955 VGND VPWR sky130_fd_sc_hd__tapvpwrvgnd_1
X_09509_ _04142_ _04187_ _04238_ _04237_ _04207_ VGND VGND VPWR VPWR _04239_ sky130_fd_sc_hd__a32oi_2
XFILLER_0_78_183 VPWR VGND VPWR VGND sky130_ef_sc_hd__decap_12
XFILLER_0_81_304 VPWR VGND VPWR VGND sky130_ef_sc_hd__decap_12
XFILLER_0_66_378 VGND VGND VPWR VPWR sky130_fd_sc_hd__decap_6
XFILLER_0_26_209 VGND VGND VPWR VPWR sky130_fd_sc_hd__decap_4
XPHY_EDGE_ROW_117_Right_117 VGND VGND VPWR VPWR sky130_fd_sc_hd__decap_3
XFILLER_0_109_469 VPWR VGND VPWR VGND sky130_ef_sc_hd__decap_12
XFILLER_0_19_261 VPWR VGND VPWR VGND sky130_ef_sc_hd__decap_12
XFILLER_0_105_620 VGND VGND VPWR VPWR sky130_fd_sc_hd__decap_3
XFILLER_0_62_551 VGND VGND VPWR VPWR sky130_fd_sc_hd__decap_6
XFILLER_0_34_253 VGND VGND VPWR VPWR sky130_fd_sc_hd__decap_6
XFILLER_0_104_141 VGND VGND VPWR VPWR sky130_fd_sc_hd__fill_2
XFILLER_0_120_623 VGND VGND VPWR VPWR sky130_fd_sc_hd__fill_1
X_10215_ clknet_leaf_21_clk mac_inst.y\[9\] _00000_ VGND VGND VPWR VPWR mac_y_out[9]
+ sky130_fd_sc_hd__dfrtp_2
XFILLER_0_118_27 VGND VGND VPWR VPWR sky130_fd_sc_hd__fill_1
X_10077_ clknet_leaf_12_clk _00094_ VGND VGND VPWR VPWR tanh_inst.divider.y_\[-16\]
+ sky130_fd_sc_hd__dfxtp_2
XFILLER_0_27_69 VPWR VGND VPWR VGND sky130_ef_sc_hd__decap_12
XTAP_TAPCELL_ROW_85_1327 VGND VPWR sky130_fd_sc_hd__tapvpwrvgnd_1
XFILLER_0_57_301 VGND VGND VPWR VPWR sky130_fd_sc_hd__decap_3
XFILLER_0_57_334 VGND VGND VPWR VPWR sky130_fd_sc_hd__fill_2
XFILLER_0_43_57 VGND VGND VPWR VPWR sky130_fd_sc_hd__fill_1
XFILLER_0_84_197 VPWR VGND VPWR VGND sky130_ef_sc_hd__decap_12
XFILLER_0_26_721 VGND VGND VPWR VPWR sky130_fd_sc_hd__decap_3
XFILLER_0_111_3 VPWR VGND VPWR VGND sky130_ef_sc_hd__decap_12
XFILLER_0_53_540 VGND VGND VPWR VPWR sky130_fd_sc_hd__decap_6
X_06170_ _01088_ _01113_ _01114_ VGND VGND VPWR VPWR _00088_ sky130_fd_sc_hd__a21o_2
XFILLER_0_53_573 VGND VGND VPWR VPWR sky130_fd_sc_hd__decap_6
XTAP_TAPCELL_ROW_96_1467 VGND VPWR sky130_fd_sc_hd__tapvpwrvgnd_1
XTAP_TAPCELL_ROW_96_1456 VGND VPWR sky130_fd_sc_hd__tapvpwrvgnd_1
XFILLER_0_80_381 VPWR VGND VPWR VGND sky130_ef_sc_hd__decap_12
X_05121_ mac_counter\[4\] _04824_ _00000_ VGND VGND VPWR VPWR _04830_ sky130_fd_sc_hd__o21ai_2
X_05052_ tanh_inst.divider.i\[4\] VGND VGND VPWR VPWR _04776_ sky130_fd_sc_hd__inv_2
XFILLER_0_7_57 VPWR VGND VPWR VGND sky130_ef_sc_hd__decap_12
XFILLER_0_110_133 VGND VGND VPWR VPWR sky130_fd_sc_hd__fill_1
XFILLER_0_21_470 VGND VGND VPWR VPWR sky130_fd_sc_hd__decap_8
X_09860_ _04512_ _04569_ VGND VGND VPWR VPWR _04580_ sky130_fd_sc_hd__or2_2
XTAP_TAPCELL_ROW_5_319 VGND VPWR sky130_fd_sc_hd__tapvpwrvgnd_1
X_08811_ _03550_ _03554_ _03556_ _03552_ _04760_ tanh_inst.LOOKUP.index\[0\] VGND
+ VGND VPWR VPWR _03557_ sky130_fd_sc_hd__mux4_2
X_09791_ _04506_ _04512_ VGND VGND VPWR VPWR _04513_ sky130_fd_sc_hd__or2_2
X_05954_ _00704_ _00847_ _00911_ VGND VGND VPWR VPWR _00912_ sky130_fd_sc_hd__o21a_2
X_08742_ _04953_ _03497_ _03500_ VGND VGND VPWR VPWR _00284_ sky130_fd_sc_hd__a21oi_2
X_08673_ _03385_ _03388_ _03412_ _03411_ VGND VGND VPWR VPWR _03453_ sky130_fd_sc_hd__o31a_2
X_07624_ _02428_ VGND VGND VPWR VPWR _02429_ sky130_fd_sc_hd__inv_2
X_05885_ _04979_ _00847_ VGND VGND VPWR VPWR _00848_ sky130_fd_sc_hd__or2_2
XFILLER_0_16_3 VPWR VGND VPWR VGND sky130_ef_sc_hd__decap_12
XFILLER_0_67_109 VGND VGND VPWR VPWR sky130_fd_sc_hd__decap_3
XTAP_TAPCELL_ROW_105_1574 VGND VPWR sky130_fd_sc_hd__tapvpwrvgnd_1
X_07555_ _02345_ _02359_ VGND VGND VPWR VPWR _02361_ sky130_fd_sc_hd__nand2_2
XTAP_TAPCELL_ROW_52_914 VGND VPWR sky130_fd_sc_hd__tapvpwrvgnd_1
X_06506_ tanh_inst.divider.y_\[3\] _01424_ VGND VGND VPWR VPWR _01426_ sky130_fd_sc_hd__and2_2
X_07486_ tanh_inst.divider.y\[-22\] _02225_ _02224_ VGND VGND VPWR VPWR _02293_ sky130_fd_sc_hd__o21ba_2
XFILLER_0_118_233 VGND VGND VPWR VPWR sky130_fd_sc_hd__decap_6
X_06437_ _01361_ _01362_ VGND VGND VPWR VPWR _01363_ sky130_fd_sc_hd__and2b_2
X_09225_ _03920_ _03922_ _03961_ VGND VGND VPWR VPWR _03963_ sky130_fd_sc_hd__or3_2
XFILLER_0_63_337 VGND VGND VPWR VPWR sky130_fd_sc_hd__decap_4
XTAP_TAPCELL_ROW_32_660 VGND VPWR sky130_fd_sc_hd__tapvpwrvgnd_1
XFILLER_0_8_475 VGND VGND VPWR VPWR sky130_fd_sc_hd__fill_1
X_06368_ tanh_inst.divider.i\[4\] _01026_ _01289_ VGND VGND VPWR VPWR _01299_ sky130_fd_sc_hd__o21a_2
XFILLER_0_16_253 VPWR VGND VPWR VGND sky130_ef_sc_hd__decap_12
XFILLER_0_44_584 VGND VGND VPWR VPWR sky130_fd_sc_hd__decap_4
X_09156_ _03894_ _03895_ tanh_inst.LOOKUP.index\[3\] VGND VGND VPWR VPWR _03896_ sky130_fd_sc_hd__mux2_1
X_06299_ _01233_ _01235_ _01088_ VGND VGND VPWR VPWR _01236_ sky130_fd_sc_hd__o21ai_2
XFILLER_0_114_461 VGND VGND VPWR VPWR sky130_fd_sc_hd__fill_1
X_09087_ _02027_ _03589_ _03591_ _02024_ VGND VGND VPWR VPWR _03828_ sky130_fd_sc_hd__a211o_2
X_05319_ _05016_ _05017_ mac_inst.i\[2\] VGND VGND VPWR VPWR _05018_ sky130_fd_sc_hd__mux2_1
X_08107_ _02899_ _02900_ VGND VGND VPWR VPWR _02901_ sky130_fd_sc_hd__nand2_2
XFILLER_0_102_645 VPWR VGND VPWR VGND sky130_ef_sc_hd__decap_12
X_08038_ tanh_inst.divider.y\[7\] _02052_ VGND VGND VPWR VPWR _02833_ sky130_fd_sc_hd__nor2_2
X_10000_ _04679_ _04680_ _04682_ VGND VGND VPWR VPWR _04716_ sky130_fd_sc_hd__a21o_2
X_09989_ tanh_inst.LOOKUP.index\[4\] _04159_ _04213_ VGND VGND VPWR VPWR _04705_ sky130_fd_sc_hd__o21a_2
XFILLER_0_79_481 VPWR VGND VPWR VGND sky130_ef_sc_hd__decap_12
XFILLER_0_104_29 VPWR VGND VPWR VGND sky130_ef_sc_hd__decap_12
XFILLER_0_67_654 VGND VGND VPWR VPWR sky130_fd_sc_hd__fill_2
XFILLER_0_66_131 VGND VGND VPWR VPWR sky130_fd_sc_hd__fill_1
XFILLER_0_13_27 VPWR VGND VPWR VGND sky130_ef_sc_hd__decap_12
XTAP_TAPCELL_ROW_80_1268 VGND VPWR sky130_fd_sc_hd__tapvpwrvgnd_1
XTAP_TAPCELL_ROW_80_1257 VGND VPWR sky130_fd_sc_hd__tapvpwrvgnd_1
XFILLER_0_54_315 VGND VGND VPWR VPWR sky130_fd_sc_hd__decap_4
XFILLER_0_39_389 VGND VGND VPWR VPWR sky130_fd_sc_hd__decap_3
XFILLER_0_81_156 VGND VGND VPWR VPWR sky130_fd_sc_hd__fill_2
XFILLER_0_81_134 VGND VGND VPWR VPWR sky130_fd_sc_hd__decap_4
XTAP_TAPCELL_ROW_10_387 VGND VPWR sky130_fd_sc_hd__tapvpwrvgnd_1
XFILLER_0_22_245 VGND VGND VPWR VPWR sky130_fd_sc_hd__decap_6
XFILLER_0_22_289 VPWR VGND VPWR VGND sky130_ef_sc_hd__decap_12
XTAP_TAPCELL_ROW_91_1397 VGND VPWR sky130_fd_sc_hd__tapvpwrvgnd_1
X_05670_ _00650_ _00651_ VGND VGND VPWR VPWR _05670_/Y sky130_fd_sc_hd__xnor2_2
X_07340_ _02147_ _02148_ _02024_ VGND VGND VPWR VPWR _02149_ sky130_fd_sc_hd__o21a_2
XFILLER_0_57_142 VGND VGND VPWR VPWR sky130_fd_sc_hd__decap_8
XFILLER_0_9_217 VGND VGND VPWR VPWR sky130_fd_sc_hd__decap_6
XTAP_TAPCELL_ROW_18_487 VGND VPWR sky130_fd_sc_hd__tapvpwrvgnd_1
XFILLER_0_85_495 VGND VGND VPWR VPWR sky130_fd_sc_hd__fill_1
XFILLER_0_57_175 VGND VGND VPWR VPWR sky130_fd_sc_hd__fill_1
X_09010_ _03751_ _03752_ VGND VGND VPWR VPWR _03753_ sky130_fd_sc_hd__or2_2
X_07271_ tanh_inst.divider.y\[-2\] _02028_ _02029_ VGND VGND VPWR VPWR _02081_ sky130_fd_sc_hd__o21a_2
XFILLER_0_115_225 VGND VGND VPWR VPWR sky130_fd_sc_hd__decap_4
X_06222_ _01146_ _01147_ _04793_ VGND VGND VPWR VPWR _01164_ sky130_fd_sc_hd__o21a_2
XFILLER_0_72_178 VPWR VGND VPWR VGND sky130_ef_sc_hd__decap_12
XFILLER_0_60_307 VGND VGND VPWR VPWR sky130_fd_sc_hd__fill_1
XFILLER_0_14_713 VGND VGND VPWR VPWR sky130_fd_sc_hd__decap_8
XFILLER_0_26_551 VGND VGND VPWR VPWR sky130_fd_sc_hd__decap_4
X_06153_ _01096_ _01097_ tanh_inst.divider.i\[2\] VGND VGND VPWR VPWR _01098_ sky130_fd_sc_hd__mux2_1
XFILLER_0_79_31 VPWR VGND VPWR VGND sky130_ef_sc_hd__decap_12
XFILLER_0_13_223 VGND VGND VPWR VPWR sky130_fd_sc_hd__fill_1
XFILLER_0_5_478 VGND VGND VPWR VPWR sky130_fd_sc_hd__decap_3
X_05104_ current_state\[1\] _04779_ VGND VGND VPWR VPWR _04818_ sky130_fd_sc_hd__nor2_2
X_06084_ tanh_inst.divider.i\[4\] tanh_inst.divider.i\[3\] VGND VGND VPWR VPWR _01031_
+ sky130_fd_sc_hd__or2_2
XFILLER_0_110_83 VGND VGND VPWR VPWR sky130_fd_sc_hd__fill_1
X_09912_ _04629_ _04630_ VGND VGND VPWR VPWR _04631_ sky130_fd_sc_hd__nand2b_2
X_05035_ tanh_inst.LOOKUP.index\[2\] VGND VGND VPWR VPWR _04759_ sky130_fd_sc_hd__inv_2
X_09843_ _02019_ _04563_ VGND VGND VPWR VPWR _04564_ sky130_fd_sc_hd__and2_2
XFILLER_0_119_81 VPWR VGND VPWR VGND sky130_ef_sc_hd__decap_12
X_06986_ _01814_ _01825_ VGND VGND VPWR VPWR _01826_ sky130_fd_sc_hd__nand2_2
X_09774_ tanh_inst.divider.y\[-1\] _04495_ VGND VGND VPWR VPWR _04497_ sky130_fd_sc_hd__nand2_2
XTAP_TAPCELL_ROW_107_1603 VGND VPWR sky130_fd_sc_hd__tapvpwrvgnd_1
X_05937_ _00884_ _00887_ _00883_ VGND VGND VPWR VPWR _00897_ sky130_fd_sc_hd__a21bo_2
X_08725_ _00960_ _03492_ VGND VGND VPWR VPWR _00275_ sky130_fd_sc_hd__and2b_2
XFILLER_0_95_215 VGND VGND VPWR VPWR sky130_fd_sc_hd__decap_4
XFILLER_0_68_418 VGND VGND VPWR VPWR sky130_fd_sc_hd__fill_2
X_08656_ tanh_inst.divider.x\[5\] _02014_ _03436_ _01470_ VGND VGND VPWR VPWR _00262_
+ sky130_fd_sc_hd__o211a_2
X_05868_ mac_inst.z\[12\] _00800_ _00817_ VGND VGND VPWR VPWR _00833_ sky130_fd_sc_hd__and3_2
XTAP_TAPCELL_ROW_37_730 VGND VPWR sky130_fd_sc_hd__tapvpwrvgnd_1
X_07607_ _02411_ VGND VGND VPWR VPWR _02412_ sky130_fd_sc_hd__inv_2
X_08587_ _03320_ _03368_ VGND VGND VPWR VPWR _03369_ sky130_fd_sc_hd__or2_2
XFILLER_0_76_451 VPWR VGND VPWR VGND sky130_ef_sc_hd__decap_12
X_07538_ _02342_ _02343_ _02023_ VGND VGND VPWR VPWR _02344_ sky130_fd_sc_hd__mux2_1
XTAP_TAPCELL_ROW_66_1090 VGND VPWR sky130_fd_sc_hd__tapvpwrvgnd_1
X_05799_ _00766_ _00767_ VGND VGND VPWR VPWR _00769_ sky130_fd_sc_hd__nand2b_2
XFILLER_0_49_698 VGND VGND VPWR VPWR sky130_fd_sc_hd__fill_1
X_07469_ _02023_ _02273_ VGND VGND VPWR VPWR _02276_ sky130_fd_sc_hd__nor2_2
XFILLER_0_36_359 VGND VGND VPWR VPWR sky130_fd_sc_hd__decap_4
XFILLER_0_48_197 VGND VGND VPWR VPWR sky130_fd_sc_hd__fill_2
X_09208_ _03944_ _03946_ VGND VGND VPWR VPWR _03947_ sky130_fd_sc_hd__xnor2_2
X_10480_ clknet_leaf_34_clk _00337_ _00081_ VGND VGND VPWR VPWR tanh_counter\[3\]
+ sky130_fd_sc_hd__dfrtp_2
XTAP_TAPCELL_ROW_118_1743 VGND VPWR sky130_fd_sc_hd__tapvpwrvgnd_1
XTAP_TAPCELL_ROW_118_1732 VGND VPWR sky130_fd_sc_hd__tapvpwrvgnd_1
X_09139_ tanh_inst.divider.x\[-18\] _03878_ VGND VGND VPWR VPWR _03879_ sky130_fd_sc_hd__nor2_2
XFILLER_0_32_587 VGND VGND VPWR VPWR sky130_fd_sc_hd__fill_1
XFILLER_0_32_598 VGND VGND VPWR VPWR sky130_fd_sc_hd__fill_1
XFILLER_0_102_475 VGND VGND VPWR VPWR sky130_fd_sc_hd__fill_1
XFILLER_0_5_3 VPWR VGND VPWR VGND sky130_ef_sc_hd__decap_12
XTAP_TAPCELL_ROW_69_1119 VGND VPWR sky130_fd_sc_hd__tapvpwrvgnd_1
XFILLER_0_24_15 VPWR VGND VPWR VGND sky130_ef_sc_hd__decap_12
XFILLER_0_115_39 VPWR VGND VPWR VGND sky130_ef_sc_hd__decap_12
Xclkbuf_2_0__f_clk clknet_0_clk VGND VGND VPWR VPWR clknet_2_0__leaf_clk sky130_fd_sc_hd__clkbuf_16
XFILLER_0_86_259 VGND VGND VPWR VPWR sky130_fd_sc_hd__fill_1
XFILLER_0_82_421 VGND VGND VPWR VPWR sky130_fd_sc_hd__fill_2
XFILLER_0_67_495 VGND VGND VPWR VPWR sky130_fd_sc_hd__fill_1
XTAP_TAPCELL_ROW_15_446 VGND VPWR sky130_fd_sc_hd__tapvpwrvgnd_1
XFILLER_0_55_668 VGND VGND VPWR VPWR sky130_fd_sc_hd__decap_4
XFILLER_0_6_209 VPWR VGND VPWR VGND sky130_ef_sc_hd__decap_12
XFILLER_0_27_337 VGND VGND VPWR VPWR sky130_fd_sc_hd__fill_2
XTAP_TAPCELL_ROW_43_799 VGND VPWR sky130_fd_sc_hd__tapvpwrvgnd_1
XFILLER_0_82_465 VGND VGND VPWR VPWR sky130_fd_sc_hd__decap_8
XFILLER_0_42_307 VGND VGND VPWR VPWR sky130_fd_sc_hd__fill_1
XFILLER_0_35_381 VGND VGND VPWR VPWR sky130_fd_sc_hd__decap_8
XTAP_TAPCELL_ROW_93_1426 VGND VPWR sky130_fd_sc_hd__tapvpwrvgnd_1
XFILLER_0_50_362 VGND VGND VPWR VPWR sky130_fd_sc_hd__fill_2
XFILLER_0_50_373 VGND VGND VPWR VPWR sky130_fd_sc_hd__decap_8
X_06840_ tanh_inst.z_\[0\] _01719_ _01726_ VGND VGND VPWR VPWR _01730_ sky130_fd_sc_hd__a21bo_2
XFILLER_0_65_55 VGND VGND VPWR VPWR sky130_fd_sc_hd__fill_1
X_06771_ tanh_inst.z_\[-7\] _01668_ VGND VGND VPWR VPWR _01669_ sky130_fd_sc_hd__xor2_2
X_09490_ tanh_inst.divider.y\[-9\] _02014_ _04220_ _01470_ VGND VGND VPWR VPWR _00312_
+ sky130_fd_sc_hd__o211a_2
X_05722_ mac_inst.z\[3\] _00696_ VGND VGND VPWR VPWR _00698_ sky130_fd_sc_hd__nand2_2
X_08510_ _03289_ _03293_ VGND VGND VPWR VPWR _03294_ sky130_fd_sc_hd__nor2_2
XFILLER_0_77_237 VPWR VGND VPWR VGND sky130_ef_sc_hd__decap_12
X_05653_ _00634_ _00635_ VGND VGND VPWR VPWR _00636_ sky130_fd_sc_hd__xnor2_2
X_08441_ tanh_inst.divider.y\[0\] tanh_inst.divider.x\[0\] VGND VGND VPWR VPWR _03227_
+ sky130_fd_sc_hd__xor2_2
XFILLER_0_92_207 VGND VGND VPWR VPWR sky130_fd_sc_hd__decap_4
XTAP_TAPCELL_ROW_102_1533 VGND VPWR sky130_fd_sc_hd__tapvpwrvgnd_1
XFILLER_0_92_218 VGND VGND VPWR VPWR sky130_fd_sc_hd__decap_8
XFILLER_0_58_462 VPWR VGND VPWR VGND sky130_ef_sc_hd__decap_12
X_08372_ _03144_ _03145_ _03159_ tanh_inst.z_\[7\] VGND VGND VPWR VPWR _03160_ sky130_fd_sc_hd__a22o_2
X_05584_ _00564_ _00568_ _00563_ VGND VGND VPWR VPWR _00574_ sky130_fd_sc_hd__o21ai_2
XFILLER_0_85_281 VGND VGND VPWR VPWR sky130_fd_sc_hd__decap_4
X_07323_ _02067_ _02072_ _02073_ _02071_ _04760_ _04761_ VGND VGND VPWR VPWR _02132_
+ sky130_fd_sc_hd__mux4_2
X_07254_ _02025_ _02058_ _02063_ _02023_ VGND VGND VPWR VPWR _02064_ sky130_fd_sc_hd__o211a_2
XFILLER_0_116_589 VPWR VGND VPWR VGND sky130_ef_sc_hd__decap_12
X_06205_ _04793_ _01147_ VGND VGND VPWR VPWR _01148_ sky130_fd_sc_hd__nand2_2
XFILLER_0_83_3 VPWR VGND VPWR VGND sky130_ef_sc_hd__decap_12
XFILLER_0_45_189 VGND VGND VPWR VPWR sky130_fd_sc_hd__fill_1
X_07185_ _01997_ _02001_ VGND VGND VPWR VPWR _02002_ sky130_fd_sc_hd__xnor2_2
XFILLER_0_103_239 VGND VGND VPWR VPWR sky130_fd_sc_hd__fill_2
X_06136_ _01039_ _01081_ VGND VGND VPWR VPWR _01082_ sky130_fd_sc_hd__or2_2
XFILLER_0_41_373 VPWR VGND VPWR VGND sky130_ef_sc_hd__decap_12
X_06067_ _01013_ _01015_ VGND VGND VPWR VPWR _06067_/X sky130_fd_sc_hd__xor2_2
XTAP_TAPCELL_ROW_113_1673 VGND VPWR sky130_fd_sc_hd__tapvpwrvgnd_1
X_09826_ _03256_ _04546_ VGND VGND VPWR VPWR _04547_ sky130_fd_sc_hd__and2_2
X_06969_ _01799_ _01809_ _01776_ VGND VGND VPWR VPWR _01810_ sky130_fd_sc_hd__a21o_2
X_09757_ _04764_ _04473_ VGND VGND VPWR VPWR _04480_ sky130_fd_sc_hd__nor2_2
X_08708_ _02018_ _03485_ _03486_ _02015_ VGND VGND VPWR VPWR _03487_ sky130_fd_sc_hd__a31o_2
XFILLER_0_68_226 VGND VGND VPWR VPWR sky130_fd_sc_hd__decap_6
XFILLER_0_68_215 VGND VGND VPWR VPWR sky130_fd_sc_hd__decap_4
X_09688_ _04411_ _04412_ VGND VGND VPWR VPWR _04413_ sky130_fd_sc_hd__nor2_2
XFILLER_0_96_568 VPWR VGND VPWR VGND sky130_ef_sc_hd__decap_12
X_08639_ _03418_ _03419_ VGND VGND VPWR VPWR _03420_ sky130_fd_sc_hd__nor2_2
XFILLER_0_84_719 VGND VGND VPWR VPWR sky130_fd_sc_hd__decap_4
XFILLER_0_49_473 VGND VGND VPWR VPWR sky130_fd_sc_hd__decap_8
XFILLER_0_76_292 VPWR VGND VPWR VGND sky130_ef_sc_hd__decap_12
XFILLER_0_64_421 VPWR VGND VPWR VGND sky130_ef_sc_hd__decap_12
XTAP_TAPCELL_ROW_12_416 VGND VPWR sky130_fd_sc_hd__tapvpwrvgnd_1
XFILLER_0_107_523 VPWR VGND VPWR VGND sky130_ef_sc_hd__decap_12
XFILLER_0_91_262 VGND VGND VPWR VPWR sky130_fd_sc_hd__fill_1
XFILLER_0_24_307 VGND VGND VPWR VPWR sky130_fd_sc_hd__fill_1
XTAP_TAPCELL_ROW_40_758 VGND VPWR sky130_fd_sc_hd__tapvpwrvgnd_1
X_10463_ clknet_leaf_39_clk _00320_ VGND VGND VPWR VPWR tanh_inst.divider.y\[-1\]
+ sky130_fd_sc_hd__dfxtp_2
XFILLER_0_20_513 VPWR VGND VPWR VGND sky130_ef_sc_hd__decap_12
X_10394_ clknet_leaf_45_clk _00251_ VGND VGND VPWR VPWR tanh_inst.divider.x\[-6\]
+ sky130_fd_sc_hd__dfxtp_2
XPHY_EDGE_ROW_8_Left_130 VGND VGND VPWR VPWR sky130_fd_sc_hd__decap_3
XFILLER_0_19_15 VPWR VGND VPWR VGND sky130_ef_sc_hd__decap_12
XTAP_TAPCELL_ROW_48_858 VGND VPWR sky130_fd_sc_hd__tapvpwrvgnd_1
XFILLER_0_87_568 VGND VGND VPWR VPWR sky130_fd_sc_hd__decap_8
XFILLER_0_75_719 VGND VGND VPWR VPWR sky130_fd_sc_hd__decap_4
XFILLER_0_67_270 VGND VGND VPWR VPWR sky130_fd_sc_hd__decap_3
XFILLER_0_51_57 VGND VGND VPWR VPWR sky130_fd_sc_hd__decap_3
XFILLER_0_43_605 VGND VGND VPWR VPWR sky130_fd_sc_hd__decap_3
XFILLER_0_82_284 VPWR VGND VPWR VGND sky130_ef_sc_hd__decap_12
XFILLER_0_82_273 VGND VGND VPWR VPWR sky130_fd_sc_hd__fill_1
XFILLER_0_3_713 VGND VGND VPWR VPWR sky130_fd_sc_hd__decap_8
XFILLER_0_15_329 VGND VGND VPWR VPWR sky130_fd_sc_hd__decap_6
Xclkload33 clknet_leaf_16_clk VGND VGND VPWR VPWR clkload33/X sky130_fd_sc_hd__clkbuf_4
Xclkload22 clknet_leaf_3_clk VGND VGND VPWR VPWR clkload22/Y sky130_fd_sc_hd__inv_6
Xclkload11 clknet_leaf_28_clk VGND VGND VPWR VPWR clkload11/Y sky130_fd_sc_hd__inv_8
XFILLER_0_113_559 VGND VGND VPWR VPWR sky130_fd_sc_hd__fill_1
XFILLER_0_2_245 VGND VGND VPWR VPWR sky130_fd_sc_hd__decap_6
XFILLER_0_2_289 VPWR VGND VPWR VGND sky130_ef_sc_hd__decap_12
X_08990_ tanh_inst.divider.x\[7\] _03732_ _02025_ VGND VGND VPWR VPWR _03733_ sky130_fd_sc_hd__mux2_1
XFILLER_0_76_65 VPWR VGND VPWR VGND sky130_ef_sc_hd__decap_12
X_07941_ tanh_inst.divider.x\[-12\] _02738_ VGND VGND VPWR VPWR _02739_ sky130_fd_sc_hd__or2_2
X_07872_ _02669_ _02670_ VGND VGND VPWR VPWR _02671_ sky130_fd_sc_hd__xor2_2
X_06823_ tanh_inst.z_\[-1\] _01713_ VGND VGND VPWR VPWR _01715_ sky130_fd_sc_hd__and2_2
X_09611_ tanh_inst.divider.x\[-5\] _04337_ VGND VGND VPWR VPWR _04338_ sky130_fd_sc_hd__nor2_2
XFILLER_0_78_502 VGND VGND VPWR VPWR sky130_fd_sc_hd__decap_6
X_06754_ _01473_ _01479_ _04761_ VGND VGND VPWR VPWR _01653_ sky130_fd_sc_hd__o21ai_2
X_09542_ _02929_ _04269_ VGND VGND VPWR VPWR _04271_ sky130_fd_sc_hd__nor2_2
X_05705_ _00669_ _00681_ VGND VGND VPWR VPWR _00682_ sky130_fd_sc_hd__or2_2
X_09473_ _04178_ _04182_ _04203_ VGND VGND VPWR VPWR _04204_ sky130_fd_sc_hd__o21ai_2
XFILLER_0_93_505 VGND VGND VPWR VPWR sky130_fd_sc_hd__fill_2
X_06685_ tanh_inst.z_\[-16\] _01590_ VGND VGND VPWR VPWR _01592_ sky130_fd_sc_hd__nor2_2
XFILLER_0_25_91 VGND VGND VPWR VPWR sky130_fd_sc_hd__fill_2
X_08424_ _03153_ _03184_ VGND VGND VPWR VPWR _03210_ sky130_fd_sc_hd__nand2_2
X_05636_ mac_inst.y\[26\] _00619_ VGND VGND VPWR VPWR _00621_ sky130_fd_sc_hd__nor2_2
X_08355_ _03065_ _03142_ _03102_ VGND VGND VPWR VPWR _03143_ sky130_fd_sc_hd__a21oi_2
X_05567_ mac_inst.y\[19\] _00557_ VGND VGND VPWR VPWR _00559_ sky130_fd_sc_hd__xor2_2
XFILLER_0_116_331 VGND VGND VPWR VPWR sky130_fd_sc_hd__decap_8
Xclkload5 clknet_leaf_39_clk VGND VGND VPWR VPWR clkload5/Y sky130_fd_sc_hd__inv_4
X_07306_ tanh_inst.divider.y\[0\] tanh_inst.divider.y\[1\] tanh_inst.divider.y\[2\]
+ tanh_inst.divider.y\[3\] tanh_inst.LOOKUP.index\[0\] tanh_inst.LOOKUP.index\[1\]
+ VGND VGND VPWR VPWR _02116_ sky130_fd_sc_hd__mux4_2
XFILLER_0_18_189 VGND VGND VPWR VPWR sky130_fd_sc_hd__decap_6
X_05498_ _04912_ _00494_ VGND VGND VPWR VPWR _00495_ sky130_fd_sc_hd__or2_2
XFILLER_0_41_90 VGND VGND VPWR VPWR sky130_fd_sc_hd__fill_1
X_08286_ _02992_ _03024_ VGND VGND VPWR VPWR _03076_ sky130_fd_sc_hd__or2_2
XTAP_TAPCELL_ROW_115_1702 VGND VPWR sky130_fd_sc_hd__tapvpwrvgnd_1
X_07237_ tanh_inst.divider.y\[-16\] _02028_ _02029_ _04761_ VGND VGND VPWR VPWR _02047_
+ sky130_fd_sc_hd__o211a_2
XFILLER_0_61_479 VPWR VGND VPWR VGND sky130_ef_sc_hd__decap_12
XFILLER_0_33_148 VGND VGND VPWR VPWR sky130_fd_sc_hd__fill_2
X_07168_ tanh_inst.divider.z_\[3\] _01975_ VGND VGND VPWR VPWR _01987_ sky130_fd_sc_hd__xor2_2
XFILLER_0_14_351 VGND VGND VPWR VPWR sky130_fd_sc_hd__fill_1
X_06119_ tanh_inst.divider.x\[-3\] tanh_inst.divider.x\[-2\] tanh_inst.divider.x\[-1\]
+ tanh_inst.divider.x\[0\] tanh_inst.divider.i\[0\] tanh_inst.divider.i\[1\] VGND
+ VGND VPWR VPWR _01065_ sky130_fd_sc_hd__mux4_2
X_07099_ _01924_ _01925_ tanh_inst.divider.z_\[-5\] VGND VGND VPWR VPWR _01926_ sky130_fd_sc_hd__a21o_2
X_09809_ _04791_ _04530_ VGND VGND VPWR VPWR _04531_ sky130_fd_sc_hd__nor2_2
XFILLER_0_69_535 VGND VGND VPWR VPWR sky130_fd_sc_hd__fill_1
XTAP_TAPCELL_ROW_45_828 VGND VPWR sky130_fd_sc_hd__tapvpwrvgnd_1
XFILLER_0_96_365 VGND VGND VPWR VPWR sky130_fd_sc_hd__decap_8
XFILLER_0_57_719 VGND VGND VPWR VPWR sky130_fd_sc_hd__decap_4
XTAP_TAPCELL_ROW_25_574 VGND VPWR sky130_fd_sc_hd__tapvpwrvgnd_1
XFILLER_0_49_281 VGND VGND VPWR VPWR sky130_fd_sc_hd__decap_4
XFILLER_0_112_29 VPWR VGND VPWR VGND sky130_ef_sc_hd__decap_12
XFILLER_0_64_262 VGND VGND VPWR VPWR sky130_fd_sc_hd__decap_4
XFILLER_0_64_251 VGND VGND VPWR VPWR sky130_fd_sc_hd__fill_1
XFILLER_0_21_27 VPWR VGND VPWR VGND sky130_ef_sc_hd__decap_12
XTAP_TAPCELL_ROW_77_1229 VGND VPWR sky130_fd_sc_hd__tapvpwrvgnd_1
XFILLER_0_24_159 VPWR VGND VPWR VGND sky130_ef_sc_hd__decap_12
X_10446_ clknet_leaf_9_clk _00303_ VGND VGND VPWR VPWR tanh_inst.divider.y\[-18\]
+ sky130_fd_sc_hd__dfxtp_2
XFILLER_0_20_321 VPWR VGND VPWR VGND sky130_ef_sc_hd__decap_12
X_10377_ clknet_leaf_26_clk _00234_ VGND VGND VPWR VPWR tanh_inst.divider.x\[-23\]
+ sky130_fd_sc_hd__dfxtp_2
XFILLER_0_20_365 VGND VGND VPWR VPWR sky130_fd_sc_hd__decap_4
XTAP_TAPCELL_ROW_88_1358 VGND VPWR sky130_fd_sc_hd__tapvpwrvgnd_1
XFILLER_0_99_181 VPWR VGND VPWR VGND sky130_ef_sc_hd__decap_12
XFILLER_0_1_15 VPWR VGND VPWR VGND sky130_ef_sc_hd__decap_12
XFILLER_0_75_505 VGND VGND VPWR VPWR sky130_fd_sc_hd__decap_8
X_06470_ _01348_ _01363_ _01372_ _01381_ VGND VGND VPWR VPWR _01393_ sky130_fd_sc_hd__and4_2
XFILLER_0_62_67 VGND VGND VPWR VPWR sky130_fd_sc_hd__decap_4
XFILLER_0_28_410 VGND VGND VPWR VPWR sky130_fd_sc_hd__decap_3
X_05421_ _00424_ VGND VGND VPWR VPWR _00425_ sky130_fd_sc_hd__inv_2
XFILLER_0_7_337 VPWR VGND VPWR VGND sky130_ef_sc_hd__decap_12
X_08140_ tanh_inst.divider.x\[-7\] _02924_ VGND VGND VPWR VPWR _02933_ sky130_fd_sc_hd__and2_2
XFILLER_0_70_221 VGND VGND VPWR VPWR sky130_fd_sc_hd__decap_4
X_05352_ _04885_ _04891_ _04920_ _04887_ mac_inst.i\[0\] _04789_ VGND VGND VPWR VPWR
+ _00360_ sky130_fd_sc_hd__mux4_2
XFILLER_0_113_312 VGND VGND VPWR VPWR sky130_fd_sc_hd__decap_8
X_08071_ _02018_ _02865_ _02015_ VGND VGND VPWR VPWR _02866_ sky130_fd_sc_hd__a21o_2
XFILLER_0_15_137 VPWR VGND VPWR VGND sky130_ef_sc_hd__decap_12
X_05283_ _04983_ VGND VGND VPWR VPWR _00001_ sky130_fd_sc_hd__inv_2
XFILLER_0_113_345 VGND VGND VPWR VPWR sky130_fd_sc_hd__fill_1
XFILLER_0_113_334 VGND VGND VPWR VPWR sky130_fd_sc_hd__fill_2
XTAP_TAPCELL_ROW_99_1498 VGND VPWR sky130_fd_sc_hd__tapvpwrvgnd_1
X_07022_ _01850_ _01857_ _01856_ VGND VGND VPWR VPWR _01858_ sky130_fd_sc_hd__a21oi_2
XFILLER_0_11_93 VPWR VGND VPWR VGND sky130_ef_sc_hd__decap_12
XFILLER_0_23_181 VGND VGND VPWR VPWR sky130_fd_sc_hd__fill_2
XFILLER_0_30_129 VGND VGND VPWR VPWR sky130_fd_sc_hd__decap_3
XTAP_TAPCELL_ROW_110_1632 VGND VPWR sky130_fd_sc_hd__tapvpwrvgnd_1
X_08973_ tanh_inst.divider.y\[-22\] _03715_ VGND VGND VPWR VPWR _03717_ sky130_fd_sc_hd__or2_2
XTAP_TAPCELL_ROW_110_1643 VGND VPWR sky130_fd_sc_hd__tapvpwrvgnd_1
X_07924_ _02691_ _02721_ VGND VGND VPWR VPWR _02722_ sky130_fd_sc_hd__nor2_2
XFILLER_0_46_3 VPWR VGND VPWR VGND sky130_ef_sc_hd__decap_12
X_07855_ tanh_inst.divider.x\[-14\] _02014_ _02654_ _01470_ VGND VGND VPWR VPWR _00243_
+ sky130_fd_sc_hd__o211a_2
X_07786_ _02585_ _02586_ VGND VGND VPWR VPWR _02587_ sky130_fd_sc_hd__nor2_2
X_06806_ tanh_inst.z_\[-4\] _01688_ _01695_ VGND VGND VPWR VPWR _01700_ sky130_fd_sc_hd__a21bo_2
X_09525_ _04252_ _04254_ VGND VGND VPWR VPWR _04255_ sky130_fd_sc_hd__nand2_2
X_06737_ _01519_ _01637_ VGND VGND VPWR VPWR _01638_ sky130_fd_sc_hd__xnor2_2
X_09456_ _04096_ _04187_ _04142_ VGND VGND VPWR VPWR _04188_ sky130_fd_sc_hd__o21a_2
XFILLER_0_78_365 VGND VGND VPWR VPWR sky130_fd_sc_hd__decap_4
X_06668_ _01560_ _01561_ _01566_ _01558_ VGND VGND VPWR VPWR _01577_ sky130_fd_sc_hd__a211o_2
XTAP_TAPCELL_ROW_61_1019 VGND VPWR sky130_fd_sc_hd__tapvpwrvgnd_1
XFILLER_0_19_410 VPWR VGND VPWR VGND sky130_ef_sc_hd__decap_12
X_08407_ tanh_inst.divider.x\[-1\] _03192_ VGND VGND VPWR VPWR _03194_ sky130_fd_sc_hd__nand2_2
X_05619_ _00598_ _00605_ VGND VGND VPWR VPWR _00606_ sky130_fd_sc_hd__and2b_2
XTAP_TAPCELL_ROW_121_1783 VGND VPWR sky130_fd_sc_hd__tapvpwrvgnd_1
XTAP_TAPCELL_ROW_121_1772 VGND VPWR sky130_fd_sc_hd__tapvpwrvgnd_1
X_09387_ tanh_inst.divider.y\[-12\] _04119_ VGND VGND VPWR VPWR _04121_ sky130_fd_sc_hd__xnor2_2
X_06599_ tanh_inst.LOOKUP.index\[1\] tanh_inst.LOOKUP.index\[0\] VGND VGND VPWR VPWR
+ _01512_ sky130_fd_sc_hd__and2_2
XTAP_TAPCELL_ROW_22_533 VGND VPWR sky130_fd_sc_hd__tapvpwrvgnd_1
XFILLER_0_19_487 VGND VGND VPWR VPWR sky130_fd_sc_hd__fill_1
X_08338_ _03081_ _03125_ _03112_ VGND VGND VPWR VPWR _03126_ sky130_fd_sc_hd__o21a_2
XTAP_TAPCELL_ROW_50_886 VGND VPWR sky130_fd_sc_hd__tapvpwrvgnd_1
XPHY_EDGE_ROW_89_Left_211 VGND VGND VPWR VPWR sky130_fd_sc_hd__decap_3
X_08269_ _03028_ _03057_ VGND VGND VPWR VPWR _03059_ sky130_fd_sc_hd__nand2_2
X_10300_ clknet_leaf_22_clk _00157_ VGND VGND VPWR VPWR tanh_inst.z_\[5\] sky130_fd_sc_hd__dfxtp_2
XFILLER_0_15_671 VGND VGND VPWR VPWR sky130_fd_sc_hd__fill_1
X_10231_ clknet_leaf_28_clk mac_inst.y\[25\] _00000_ VGND VGND VPWR VPWR mac_y_out[25]
+ sky130_fd_sc_hd__dfrtp_2
XFILLER_0_30_674 VGND VGND VPWR VPWR sky130_fd_sc_hd__decap_6
XTAP_TAPCELL_ROW_72_1159 VGND VPWR sky130_fd_sc_hd__tapvpwrvgnd_1
X_10093_ clknet_leaf_6_clk _00110_ VGND VGND VPWR VPWR tanh_inst.divider.y_\[0\] sky130_fd_sc_hd__dfxtp_2
XPHY_EDGE_ROW_98_Left_220 VGND VGND VPWR VPWR sky130_fd_sc_hd__decap_3
XFILLER_0_89_608 VGND VGND VPWR VPWR sky130_fd_sc_hd__fill_1
XTAP_TAPCELL_ROW_58_986 VGND VPWR sky130_fd_sc_hd__tapvpwrvgnd_1
XFILLER_0_16_27 VGND VGND VPWR VPWR sky130_fd_sc_hd__fill_1
XFILLER_0_97_652 VGND VGND VPWR VPWR sky130_fd_sc_hd__fill_2
XTAP_TAPCELL_ROW_2_291 VGND VPWR sky130_fd_sc_hd__tapvpwrvgnd_1
XFILLER_0_32_15 VPWR VGND VPWR VGND sky130_ef_sc_hd__decap_12
XTAP_TAPCELL_ROW_83_1299 VGND VPWR sky130_fd_sc_hd__tapvpwrvgnd_1
XFILLER_0_4_307 VGND VGND VPWR VPWR sky130_fd_sc_hd__fill_1
XFILLER_0_114_109 VPWR VGND VPWR VGND sky130_ef_sc_hd__decap_12
XFILLER_0_52_232 VGND VGND VPWR VPWR sky130_fd_sc_hd__fill_2
XFILLER_0_80_585 VGND VGND VPWR VPWR sky130_fd_sc_hd__decap_3
XFILLER_0_0_513 VGND VGND VPWR VPWR sky130_fd_sc_hd__fill_2
XFILLER_0_21_641 VGND VGND VPWR VPWR sky130_fd_sc_hd__decap_8
XFILLER_0_110_348 VGND VGND VPWR VPWR sky130_fd_sc_hd__fill_2
X_10429_ clknet_leaf_40_clk _00286_ _00000_ VGND VGND VPWR VPWR mac_inst.i\[21\] sky130_fd_sc_hd__dfrtp_2
XFILLER_0_110_359 VGND VGND VPWR VPWR sky130_fd_sc_hd__decap_4
XFILLER_0_57_45 VGND VGND VPWR VPWR sky130_fd_sc_hd__fill_1
X_05970_ mac_inst.z\[20\] _00899_ _00916_ _00917_ VGND VGND VPWR VPWR _00927_ sky130_fd_sc_hd__a31o_2
XFILLER_0_20_195 VGND VGND VPWR VPWR sky130_fd_sc_hd__fill_1
XFILLER_0_73_11 VGND VGND VPWR VPWR sky130_fd_sc_hd__decap_3
X_07640_ tanh_inst.divider.y\[-18\] _02443_ VGND VGND VPWR VPWR _02444_ sky130_fd_sc_hd__nor2_2
X_07571_ _02373_ _02376_ VGND VGND VPWR VPWR _02377_ sky130_fd_sc_hd__xnor2_2
X_06522_ tanh_inst.divider.y\[4\] tanh_inst.div_en tanh_inst.divider.y_\[4\] _01092_
+ _01440_ VGND VGND VPWR VPWR _00114_ sky130_fd_sc_hd__a221o_2
XFILLER_0_87_162 VGND VGND VPWR VPWR sky130_fd_sc_hd__decap_6
XFILLER_0_87_140 VGND VGND VPWR VPWR sky130_fd_sc_hd__fill_1
Xclkbuf_leaf_45_clk clknet_2_0__leaf_clk VGND VGND VPWR VPWR clknet_leaf_45_clk sky130_fd_sc_hd__clkbuf_8
X_09310_ tanh_inst.LOOKUP.index\[4\] _04044_ _04045_ VGND VGND VPWR VPWR _04046_ sky130_fd_sc_hd__a21bo_2
XFILLER_0_87_195 VGND VGND VPWR VPWR sky130_fd_sc_hd__decap_6
XFILLER_0_8_613 VGND VGND VPWR VPWR sky130_fd_sc_hd__fill_1
X_06453_ tanh_inst.divider.y\[-2\] tanh_inst.div_en tanh_inst.divider.y_\[-2\] _01092_
+ _01377_ VGND VGND VPWR VPWR _00108_ sky130_fd_sc_hd__a221o_2
XFILLER_0_75_368 VGND VGND VPWR VPWR sky130_fd_sc_hd__decap_6
X_09241_ tanh_inst.LOOKUP.index\[4\] _03977_ _03978_ VGND VGND VPWR VPWR _03979_ sky130_fd_sc_hd__a21bo_2
XFILLER_0_28_251 VGND VGND VPWR VPWR sky130_fd_sc_hd__fill_1
X_06384_ _01313_ VGND VGND VPWR VPWR _01314_ sky130_fd_sc_hd__inv_2
X_09172_ tanh_inst.divider.y\[-17\] _02015_ VGND VGND VPWR VPWR _03911_ sky130_fd_sc_hd__nand2_2
XFILLER_0_16_413 VGND VGND VPWR VPWR sky130_fd_sc_hd__decap_6
X_05404_ _00382_ _00383_ _00396_ _00380_ VGND VGND VPWR VPWR _00409_ sky130_fd_sc_hd__o211a_2
XFILLER_0_7_167 VGND VGND VPWR VPWR sky130_fd_sc_hd__fill_1
X_05335_ mac_inst.y\[2\] _00342_ VGND VGND VPWR VPWR _00344_ sky130_fd_sc_hd__or2_2
X_08123_ _04771_ _02915_ VGND VGND VPWR VPWR _02917_ sky130_fd_sc_hd__or2_2
XFILLER_0_114_643 VGND VGND VPWR VPWR sky130_fd_sc_hd__fill_1
X_08054_ tanh_inst.divider.y\[-9\] tanh_inst.divider.x\[-9\] VGND VGND VPWR VPWR _02849_
+ sky130_fd_sc_hd__nand2_2
XFILLER_0_98_41 VPWR VGND VPWR VGND sky130_ef_sc_hd__decap_12
X_07005_ _01840_ _01841_ _01842_ VGND VGND VPWR VPWR _01843_ sky130_fd_sc_hd__a21o_2
XFILLER_0_98_85 VPWR VGND VPWR VGND sky130_ef_sc_hd__decap_12
X_05266_ mac_inst.i\[13\] mac_inst.i\[12\] VGND VGND VPWR VPWR _04967_ sky130_fd_sc_hd__nand2_2
XFILLER_0_114_698 VGND VGND VPWR VPWR sky130_fd_sc_hd__fill_2
XFILLER_0_12_641 VGND VGND VPWR VPWR sky130_fd_sc_hd__decap_3
XFILLER_0_3_373 VPWR VGND VPWR VGND sky130_ef_sc_hd__decap_12
X_05197_ _04893_ _04895_ _04897_ _04899_ _04783_ mac_inst.i\[1\] VGND VGND VPWR VPWR
+ _04901_ sky130_fd_sc_hd__mux4_2
X_08956_ tanh_inst.divider.x\[-2\] tanh_inst.divider.x\[-1\] tanh_inst.divider.x\[0\]
+ tanh_inst.divider.x\[1\] tanh_inst.LOOKUP.index\[0\] tanh_inst.LOOKUP.index\[1\]
+ VGND VGND VPWR VPWR _03700_ sky130_fd_sc_hd__mux4_2
X_07907_ _02542_ _02596_ _02703_ VGND VGND VPWR VPWR _02705_ sky130_fd_sc_hd__and3_2
X_08887_ _03630_ _03631_ tanh_inst.LOOKUP.index\[2\] VGND VGND VPWR VPWR _03632_ sky130_fd_sc_hd__mux2_1
X_07838_ _02634_ _02636_ VGND VGND VPWR VPWR _02638_ sky130_fd_sc_hd__nand2_2
XTAP_TAPCELL_ROW_27_603 VGND VPWR sky130_fd_sc_hd__tapvpwrvgnd_1
X_09508_ _04186_ _04206_ _04207_ VGND VGND VPWR VPWR _04238_ sky130_fd_sc_hd__and3_2
X_07769_ tanh_inst.divider.x\[-16\] _02569_ VGND VGND VPWR VPWR _02571_ sky130_fd_sc_hd__nand2_2
XTAP_TAPCELL_ROW_55_945 VGND VPWR sky130_fd_sc_hd__tapvpwrvgnd_1
Xclkbuf_leaf_36_clk clknet_2_1__leaf_clk VGND VGND VPWR VPWR clknet_leaf_36_clk sky130_fd_sc_hd__clkbuf_8
XFILLER_0_39_505 VGND VGND VPWR VPWR sky130_fd_sc_hd__decap_8
XFILLER_0_39_527 VPWR VGND VPWR VGND sky130_ef_sc_hd__decap_12
XFILLER_0_78_195 VGND VGND VPWR VPWR sky130_fd_sc_hd__fill_1
XFILLER_0_66_324 VPWR VGND VPWR VGND sky130_ef_sc_hd__decap_12
X_09439_ _04167_ _04169_ VGND VGND VPWR VPWR _04171_ sky130_fd_sc_hd__xor2_2
XFILLER_0_109_459 VGND VGND VPWR VPWR sky130_fd_sc_hd__fill_1
XFILLER_0_19_273 VGND VGND VPWR VPWR sky130_fd_sc_hd__decap_6
XFILLER_0_74_390 VPWR VGND VPWR VGND sky130_ef_sc_hd__decap_12
XFILLER_0_105_643 VGND VGND VPWR VPWR sky130_fd_sc_hd__decap_6
X_10214_ clknet_leaf_21_clk mac_inst.y\[8\] _00000_ VGND VGND VPWR VPWR mac_y_out[8]
+ sky130_fd_sc_hd__dfrtp_2
XTAP_TAPCELL_ROW_7_350 VGND VPWR sky130_fd_sc_hd__tapvpwrvgnd_1
XFILLER_0_27_15 VPWR VGND VPWR VGND sky130_ef_sc_hd__decap_12
X_10076_ clknet_leaf_12_clk _00093_ VGND VGND VPWR VPWR tanh_inst.divider.y_\[-17\]
+ sky130_fd_sc_hd__dfxtp_2
XTAP_TAPCELL_ROW_85_1328 VGND VPWR sky130_fd_sc_hd__tapvpwrvgnd_1
XFILLER_0_69_162 VGND VGND VPWR VPWR sky130_fd_sc_hd__decap_6
XFILLER_0_43_36 VGND VGND VPWR VPWR sky130_fd_sc_hd__fill_1
Xclkbuf_leaf_27_clk clknet_2_1__leaf_clk VGND VGND VPWR VPWR clknet_leaf_27_clk sky130_fd_sc_hd__clkbuf_8
XFILLER_0_84_176 VGND VGND VPWR VPWR sky130_fd_sc_hd__decap_8
XFILLER_0_72_316 VGND VGND VPWR VPWR sky130_fd_sc_hd__decap_4
XFILLER_0_5_605 VGND VGND VPWR VPWR sky130_fd_sc_hd__decap_3
XFILLER_0_104_3 VPWR VGND VPWR VGND sky130_ef_sc_hd__decap_12
X_05120_ mac_counter\[5\] _04825_ _04829_ VGND VGND VPWR VPWR _00123_ sky130_fd_sc_hd__a21oi_2
XTAP_TAPCELL_ROW_96_1468 VGND VPWR sky130_fd_sc_hd__tapvpwrvgnd_1
XTAP_TAPCELL_ROW_96_1457 VGND VPWR sky130_fd_sc_hd__tapvpwrvgnd_1
XFILLER_0_80_393 VPWR VGND VPWR VGND sky130_ef_sc_hd__decap_12
X_05051_ tanh_inst.divider.x\[-24\] VGND VGND VPWR VPWR _04775_ sky130_fd_sc_hd__inv_2
XFILLER_0_7_69 VPWR VGND VPWR VGND sky130_ef_sc_hd__decap_12
XFILLER_0_0_321 VPWR VGND VPWR VGND sky130_ef_sc_hd__decap_12
X_08810_ tanh_inst.divider.x\[-1\] _02028_ _03508_ VGND VGND VPWR VPWR _03556_ sky130_fd_sc_hd__o21a_2
XFILLER_0_0_365 VPWR VGND VPWR VGND sky130_ef_sc_hd__decap_12
XFILLER_0_21_493 VGND VGND VPWR VPWR sky130_fd_sc_hd__decap_8
X_09790_ _04510_ _04511_ VGND VGND VPWR VPWR _04512_ sky130_fd_sc_hd__nand2_2
X_05953_ mac_inst.i\[2\] _00665_ _00717_ _00847_ VGND VGND VPWR VPWR _00911_ sky130_fd_sc_hd__or4_2
X_08741_ mac_inst.i\[19\] _03499_ VGND VGND VPWR VPWR _03500_ sky130_fd_sc_hd__nor2_2
X_08672_ _03445_ _03450_ VGND VGND VPWR VPWR _03452_ sky130_fd_sc_hd__xor2_2
X_05884_ mac_inst.i\[5\] _04936_ _04935_ _04912_ VGND VGND VPWR VPWR _00847_ sky130_fd_sc_hd__o2bb2a_2
XFILLER_0_108_83 VGND VGND VPWR VPWR sky130_fd_sc_hd__fill_1
X_07623_ tanh_inst.divider.x\[-19\] _02426_ VGND VGND VPWR VPWR _02428_ sky130_fd_sc_hd__nor2_2
XFILLER_0_17_81 VPWR VGND VPWR VGND sky130_ef_sc_hd__decap_12
Xclkbuf_leaf_18_clk clknet_2_3__leaf_clk VGND VGND VPWR VPWR clknet_leaf_18_clk sky130_fd_sc_hd__clkbuf_8
XPHY_EDGE_ROW_5_Right_5 VGND VGND VPWR VPWR sky130_fd_sc_hd__decap_3
X_07554_ _02345_ _02359_ VGND VGND VPWR VPWR _02360_ sky130_fd_sc_hd__or2_2
XTAP_TAPCELL_ROW_52_915 VGND VPWR sky130_fd_sc_hd__tapvpwrvgnd_1
XTAP_TAPCELL_ROW_105_1575 VGND VPWR sky130_fd_sc_hd__tapvpwrvgnd_1
X_06505_ tanh_inst.divider.y_\[3\] _01424_ VGND VGND VPWR VPWR _01425_ sky130_fd_sc_hd__nor2_2
X_07485_ tanh_inst.divider.y\[-21\] _02290_ VGND VGND VPWR VPWR _02292_ sky130_fd_sc_hd__xnor2_2
X_06436_ _01359_ _01360_ tanh_inst.divider.y_\[-3\] VGND VGND VPWR VPWR _01362_ sky130_fd_sc_hd__or3b_2
X_09224_ _03920_ _03922_ _03961_ VGND VGND VPWR VPWR _03962_ sky130_fd_sc_hd__o21ai_2
XFILLER_0_90_113 VGND VGND VPWR VPWR sky130_fd_sc_hd__decap_8
XFILLER_0_76_699 VGND VGND VPWR VPWR sky130_fd_sc_hd__fill_1
XFILLER_0_8_443 VGND VGND VPWR VPWR sky130_fd_sc_hd__fill_2
XFILLER_0_33_80 VGND VGND VPWR VPWR sky130_fd_sc_hd__decap_3
XFILLER_0_90_146 VGND VGND VPWR VPWR sky130_fd_sc_hd__decap_6
XFILLER_0_8_487 VPWR VGND VPWR VGND sky130_ef_sc_hd__decap_12
XFILLER_0_16_221 VPWR VGND VPWR VGND sky130_ef_sc_hd__decap_12
XTAP_TAPCELL_ROW_32_661 VGND VPWR sky130_fd_sc_hd__tapvpwrvgnd_1
X_06367_ tanh_inst.divider.y\[-9\] tanh_inst.div_en tanh_inst.divider.y_\[-9\] _01092_
+ _01298_ VGND VGND VPWR VPWR _00101_ sky130_fd_sc_hd__a221o_2
XFILLER_0_16_265 VPWR VGND VPWR VGND sky130_ef_sc_hd__decap_12
X_09155_ tanh_inst.LOOKUP.index\[2\] _03703_ _03760_ VGND VGND VPWR VPWR _03895_ sky130_fd_sc_hd__o21a_2
X_06298_ _01211_ _01212_ _01222_ _01234_ VGND VGND VPWR VPWR _01235_ sky130_fd_sc_hd__a31o_2
X_09086_ _03586_ _03608_ _02024_ VGND VGND VPWR VPWR _03827_ sky130_fd_sc_hd__mux2_1
X_08106_ _02727_ _02728_ _02769_ _02898_ _02724_ VGND VGND VPWR VPWR _02900_ sky130_fd_sc_hd__o2111ai_2
XFILLER_0_71_393 VPWR VGND VPWR VGND sky130_ef_sc_hd__decap_12
XFILLER_0_71_382 VGND VGND VPWR VPWR sky130_fd_sc_hd__decap_8
X_05318_ _04865_ _04866_ _04869_ _04870_ _04783_ mac_inst.i\[1\] VGND VGND VPWR VPWR
+ _05017_ sky130_fd_sc_hd__mux4_2
XFILLER_0_114_484 VPWR VGND VPWR VGND sky130_ef_sc_hd__decap_12
XFILLER_0_102_635 VGND VGND VPWR VPWR sky130_fd_sc_hd__fill_1
X_08037_ tanh_inst.divider.x\[-10\] _02014_ _02831_ _02832_ _01470_ VGND VGND VPWR
+ VPWR _00247_ sky130_fd_sc_hd__o221a_2
XFILLER_0_3_181 VPWR VGND VPWR VGND sky130_ef_sc_hd__decap_12
X_05249_ _04842_ _04939_ mac_inst.i\[23\] mac_inst.i\[22\] mac_inst.i\[24\] VGND VGND
+ VPWR VPWR _04950_ sky130_fd_sc_hd__o2111a_2
XFILLER_0_102_657 VPWR VGND VPWR VGND sky130_ef_sc_hd__decap_12
XFILLER_0_101_167 VGND VGND VPWR VPWR sky130_fd_sc_hd__fill_1
X_09988_ tanh_inst.divider.y\[5\] _02014_ _04704_ _01470_ VGND VGND VPWR VPWR _00326_
+ sky130_fd_sc_hd__o211a_2
X_08939_ _02023_ _03676_ _03678_ VGND VGND VPWR VPWR _03683_ sky130_fd_sc_hd__or3_2
XFILLER_0_79_471 VGND VGND VPWR VPWR sky130_fd_sc_hd__decap_6
XFILLER_0_79_493 VGND VGND VPWR VPWR sky130_fd_sc_hd__decap_8
XFILLER_0_13_39 VPWR VGND VPWR VGND sky130_ef_sc_hd__decap_12
XPHY_EDGE_ROW_17_Left_139 VGND VGND VPWR VPWR sky130_fd_sc_hd__decap_3
XFILLER_0_39_357 VPWR VGND VPWR VGND sky130_ef_sc_hd__decap_12
XTAP_TAPCELL_ROW_80_1258 VGND VPWR sky130_fd_sc_hd__tapvpwrvgnd_1
XFILLER_0_66_176 VGND VGND VPWR VPWR sky130_fd_sc_hd__fill_1
XFILLER_0_120_29 VPWR VGND VPWR VGND sky130_ef_sc_hd__decap_12
XFILLER_0_90_691 VGND VGND VPWR VPWR sky130_fd_sc_hd__decap_8
XFILLER_0_120_410 VGND VGND VPWR VPWR sky130_fd_sc_hd__decap_3
XTAP_TAPCELL_ROW_10_388 VGND VPWR sky130_fd_sc_hd__tapvpwrvgnd_1
XPHY_EDGE_ROW_26_Left_148 VGND VGND VPWR VPWR sky130_fd_sc_hd__decap_3
XTAP_TAPCELL_ROW_91_1398 VGND VPWR sky130_fd_sc_hd__tapvpwrvgnd_1
X_10059_ rst VGND VGND VPWR VPWR _00078_ sky130_fd_sc_hd__inv_2
XFILLER_0_89_279 VGND VGND VPWR VPWR sky130_fd_sc_hd__fill_1
XPHY_EDGE_ROW_35_Left_157 VGND VGND VPWR VPWR sky130_fd_sc_hd__decap_3
XFILLER_0_58_677 VGND VGND VPWR VPWR sky130_fd_sc_hd__decap_6
XTAP_TAPCELL_ROW_18_488 VGND VPWR sky130_fd_sc_hd__tapvpwrvgnd_1
XFILLER_0_70_45 VGND VGND VPWR VPWR sky130_fd_sc_hd__decap_3
X_07270_ tanh_inst.divider.y\[-1\] _02028_ _02029_ VGND VGND VPWR VPWR _02080_ sky130_fd_sc_hd__o21ai_2
XFILLER_0_57_165 VGND VGND VPWR VPWR sky130_fd_sc_hd__decap_3
XFILLER_0_45_316 VGND VGND VPWR VPWR sky130_fd_sc_hd__decap_8
X_06221_ _04776_ _01159_ _01160_ _01162_ VGND VGND VPWR VPWR _01163_ sky130_fd_sc_hd__o211a_2
XFILLER_0_26_530 VGND VGND VPWR VPWR sky130_fd_sc_hd__fill_2
XFILLER_0_26_574 VGND VGND VPWR VPWR sky130_fd_sc_hd__decap_6
X_06152_ tanh_inst.divider.x\[7\] _01023_ _04778_ VGND VGND VPWR VPWR _01097_ sky130_fd_sc_hd__mux2_1
XFILLER_0_81_691 VPWR VGND VPWR VGND sky130_ef_sc_hd__decap_12
XFILLER_0_79_43 VPWR VGND VPWR VGND sky130_ef_sc_hd__decap_12
XFILLER_0_26_596 VGND VGND VPWR VPWR sky130_fd_sc_hd__fill_1
XFILLER_0_41_511 VGND VGND VPWR VPWR sky130_fd_sc_hd__fill_1
X_06083_ tanh_inst.divider.i\[4\] tanh_inst.divider.i\[3\] VGND VGND VPWR VPWR _01030_
+ sky130_fd_sc_hd__nor2_2
X_05103_ _04817_ current_state\[0\] tanh_counter\[0\] VGND VGND VPWR VPWR _00334_
+ sky130_fd_sc_hd__mux2_1
Xclkbuf_leaf_7_clk clknet_2_2__leaf_clk VGND VGND VPWR VPWR clknet_leaf_7_clk sky130_fd_sc_hd__clkbuf_8
XFILLER_0_79_98 VPWR VGND VPWR VGND sky130_ef_sc_hd__decap_12
XFILLER_0_13_279 VGND VGND VPWR VPWR sky130_fd_sc_hd__fill_1
X_09911_ tanh_inst.z_\[7\] _04573_ _04574_ VGND VGND VPWR VPWR _04630_ sky130_fd_sc_hd__o21a_2
X_05034_ tanh_inst.LOOKUP.index\[3\] VGND VGND VPWR VPWR _04758_ sky130_fd_sc_hd__inv_2
XPHY_EDGE_ROW_44_Left_166 VGND VGND VPWR VPWR sky130_fd_sc_hd__decap_3
XFILLER_0_111_498 VGND VGND VPWR VPWR sky130_fd_sc_hd__decap_6
X_09842_ _04550_ _04551_ _04562_ tanh_inst.z_\[7\] VGND VGND VPWR VPWR _04563_ sky130_fd_sc_hd__a2bb2o_2
X_09773_ tanh_inst.divider.y\[-1\] _04495_ VGND VGND VPWR VPWR _04496_ sky130_fd_sc_hd__nor2_2
XFILLER_0_119_93 VPWR VGND VPWR VGND sky130_ef_sc_hd__decap_12
X_06985_ _01803_ _01804_ _01815_ _01801_ VGND VGND VPWR VPWR _01825_ sky130_fd_sc_hd__a211o_2
X_08724_ mac_inst.i\[9\] mac_inst.i\[8\] _00958_ mac_inst.i\[10\] VGND VGND VPWR VPWR
+ _03492_ sky130_fd_sc_hd__a31o_2
XTAP_TAPCELL_ROW_107_1604 VGND VPWR sky130_fd_sc_hd__tapvpwrvgnd_1
X_05936_ _00893_ _00895_ VGND VGND VPWR VPWR _00896_ sky130_fd_sc_hd__and2b_2
X_08655_ _02019_ _03426_ _03435_ _02015_ VGND VGND VPWR VPWR _03436_ sky130_fd_sc_hd__a211o_2
X_05867_ _00812_ _00819_ _00831_ VGND VGND VPWR VPWR _00832_ sky130_fd_sc_hd__o21ai_2
XTAP_TAPCELL_ROW_37_720 VGND VPWR sky130_fd_sc_hd__tapvpwrvgnd_1
XPHY_EDGE_ROW_53_Left_175 VGND VGND VPWR VPWR sky130_fd_sc_hd__decap_3
XFILLER_0_95_238 VPWR VGND VPWR VGND sky130_ef_sc_hd__decap_12
X_07606_ _02392_ _02408_ VGND VGND VPWR VPWR _02411_ sky130_fd_sc_hd__nor2_2
X_08586_ _03316_ _03334_ _03333_ VGND VGND VPWR VPWR _03368_ sky130_fd_sc_hd__o21bai_2
X_07537_ _02077_ _02087_ _02025_ VGND VGND VPWR VPWR _02343_ sky130_fd_sc_hd__mux2_1
X_05798_ _00764_ _00765_ mac_inst.z\[9\] VGND VGND VPWR VPWR _00768_ sky130_fd_sc_hd__a21bo_2
XFILLER_0_76_496 VGND VGND VPWR VPWR sky130_fd_sc_hd__decap_3
XFILLER_0_76_463 VGND VGND VPWR VPWR sky130_fd_sc_hd__fill_1
XTAP_TAPCELL_ROW_66_1091 VGND VPWR sky130_fd_sc_hd__tapvpwrvgnd_1
XFILLER_0_64_625 VGND VGND VPWR VPWR sky130_fd_sc_hd__decap_8
XFILLER_0_63_113 VGND VGND VPWR VPWR sky130_fd_sc_hd__decap_3
XFILLER_0_48_176 VGND VGND VPWR VPWR sky130_fd_sc_hd__fill_1
X_07468_ _02027_ _02141_ _02274_ VGND VGND VPWR VPWR _02275_ sky130_fd_sc_hd__a21o_2
XFILLER_0_64_658 VGND VGND VPWR VPWR sky130_fd_sc_hd__decap_3
XFILLER_0_8_251 VGND VGND VPWR VPWR sky130_fd_sc_hd__fill_1
X_06419_ tanh_inst.divider.y_\[-4\] _01344_ VGND VGND VPWR VPWR _01346_ sky130_fd_sc_hd__nand2_2
X_07399_ _02027_ _02057_ VGND VGND VPWR VPWR _02207_ sky130_fd_sc_hd__nor2_2
XFILLER_0_63_179 VGND VGND VPWR VPWR sky130_fd_sc_hd__decap_6
X_09207_ tanh_inst.z_\[7\] _03945_ VGND VGND VPWR VPWR _03946_ sky130_fd_sc_hd__or2_2
XTAP_TAPCELL_ROW_118_1733 VGND VPWR sky130_fd_sc_hd__tapvpwrvgnd_1
X_09138_ tanh_inst.divider.y\[-18\] _03876_ VGND VGND VPWR VPWR _03878_ sky130_fd_sc_hd__xnor2_2
XPHY_EDGE_ROW_62_Left_184 VGND VGND VPWR VPWR sky130_fd_sc_hd__decap_3
XFILLER_0_32_511 VGND VGND VPWR VPWR sky130_fd_sc_hd__decap_8
XFILLER_0_32_533 VGND VGND VPWR VPWR sky130_fd_sc_hd__decap_6
XFILLER_0_114_270 VGND VGND VPWR VPWR sky130_fd_sc_hd__decap_3
XFILLER_0_102_421 VGND VGND VPWR VPWR sky130_fd_sc_hd__decap_3
X_09069_ _04758_ _03808_ _03810_ VGND VGND VPWR VPWR _03811_ sky130_fd_sc_hd__a21oi_2
XPHY_EDGE_ROW_71_Left_193 VGND VGND VPWR VPWR sky130_fd_sc_hd__decap_3
XFILLER_0_87_706 VPWR VGND VPWR VGND sky130_ef_sc_hd__decap_12
XFILLER_0_24_27 VGND VGND VPWR VPWR sky130_fd_sc_hd__fill_1
XFILLER_0_67_430 VGND VGND VPWR VPWR sky130_fd_sc_hd__fill_1
XFILLER_0_82_400 VGND VGND VPWR VPWR sky130_fd_sc_hd__decap_8
XTAP_TAPCELL_ROW_15_447 VGND VPWR sky130_fd_sc_hd__tapvpwrvgnd_1
XFILLER_0_27_316 VPWR VGND VPWR VGND sky130_ef_sc_hd__decap_12
XFILLER_0_62_190 VGND VGND VPWR VPWR sky130_fd_sc_hd__decap_6
XFILLER_0_50_341 VGND VGND VPWR VPWR sky130_fd_sc_hd__decap_3
XFILLER_0_105_281 VGND VGND VPWR VPWR sky130_fd_sc_hd__fill_1
XTAP_TAPCELL_ROW_93_1427 VGND VPWR sky130_fd_sc_hd__tapvpwrvgnd_1
XFILLER_0_23_588 VGND VGND VPWR VPWR sky130_fd_sc_hd__fill_1
XFILLER_0_120_251 VGND VGND VPWR VPWR sky130_fd_sc_hd__fill_1
XFILLER_0_49_57 VGND VGND VPWR VPWR sky130_fd_sc_hd__decap_6
XFILLER_0_4_15 VPWR VGND VPWR VGND sky130_ef_sc_hd__decap_12
X_06770_ tanh_inst.z_\[7\] _01667_ _01665_ VGND VGND VPWR VPWR _01668_ sky130_fd_sc_hd__mux2_1
X_05721_ mac_inst.z\[3\] _00694_ VGND VGND VPWR VPWR _00697_ sky130_fd_sc_hd__nand2_2
X_08440_ _03135_ _03224_ _03225_ VGND VGND VPWR VPWR _03226_ sky130_fd_sc_hd__a21oi_2
X_05652_ mac_inst.z\[31\] _00626_ _00628_ VGND VGND VPWR VPWR _00635_ sky130_fd_sc_hd__o21ba_2
XFILLER_0_105_51 VGND VGND VPWR VPWR sky130_fd_sc_hd__decap_4
XFILLER_0_58_441 VPWR VGND VPWR VGND sky130_ef_sc_hd__decap_12
XTAP_TAPCELL_ROW_102_1534 VGND VPWR sky130_fd_sc_hd__tapvpwrvgnd_1
XFILLER_0_81_88 VGND VGND VPWR VPWR sky130_fd_sc_hd__decap_6
XFILLER_0_58_474 VGND VGND VPWR VPWR sky130_fd_sc_hd__fill_2
X_08371_ _03153_ _03157_ VGND VGND VPWR VPWR _03159_ sky130_fd_sc_hd__xor2_2
X_05583_ mac_inst.y\[21\] _00572_ VGND VGND VPWR VPWR _00573_ sky130_fd_sc_hd__xnor2_2
XFILLER_0_46_625 VGND VGND VPWR VPWR sky130_fd_sc_hd__fill_1
X_07322_ _02027_ _02128_ _02129_ _02127_ _02024_ VGND VGND VPWR VPWR _02131_ sky130_fd_sc_hd__o311a_2
XFILLER_0_73_422 VGND VGND VPWR VPWR sky130_fd_sc_hd__decap_6
XFILLER_0_45_135 VGND VGND VPWR VPWR sky130_fd_sc_hd__decap_4
X_07253_ _02027_ _02060_ _02062_ _02024_ VGND VGND VPWR VPWR _02063_ sky130_fd_sc_hd__a211o_2
XFILLER_0_61_617 VPWR VGND VPWR VGND sky130_ef_sc_hd__decap_12
X_07184_ _01998_ _02000_ VGND VGND VPWR VPWR _02001_ sky130_fd_sc_hd__nand2_2
X_06204_ _01044_ _01083_ _01107_ _01129_ VGND VGND VPWR VPWR _01147_ sky130_fd_sc_hd__nand4_2
XFILLER_0_60_138 VGND VGND VPWR VPWR sky130_fd_sc_hd__fill_2
XFILLER_0_103_218 VGND VGND VPWR VPWR sky130_fd_sc_hd__fill_1
XFILLER_0_103_207 VGND VGND VPWR VPWR sky130_fd_sc_hd__decap_4
X_06135_ _01079_ _01080_ tanh_inst.divider.i\[2\] VGND VGND VPWR VPWR _01081_ sky130_fd_sc_hd__mux2_1
XFILLER_0_53_190 VPWR VGND VPWR VGND sky130_ef_sc_hd__decap_12
XFILLER_0_76_3 VPWR VGND VPWR VGND sky130_ef_sc_hd__decap_12
XFILLER_0_41_385 VGND VGND VPWR VPWR sky130_fd_sc_hd__decap_6
X_06066_ _00998_ _01001_ _01007_ _01014_ _01006_ VGND VGND VPWR VPWR _01015_ sky130_fd_sc_hd__o32a_2
XTAP_TAPCELL_ROW_113_1674 VGND VPWR sky130_fd_sc_hd__tapvpwrvgnd_1
X_09825_ _02053_ _03989_ _04193_ VGND VGND VPWR VPWR _04546_ sky130_fd_sc_hd__o21a_2
X_06968_ tanh_inst.divider.i\[2\] _01765_ VGND VGND VPWR VPWR _01809_ sky130_fd_sc_hd__or2_2
X_09756_ _04477_ _04478_ VGND VGND VPWR VPWR _04479_ sky130_fd_sc_hd__nor2_2
XFILLER_0_69_717 VGND VGND VPWR VPWR sky130_fd_sc_hd__decap_6
X_08707_ _03481_ _03484_ VGND VGND VPWR VPWR _03486_ sky130_fd_sc_hd__or2_2
X_05919_ mac_inst.z\[31\] _00879_ VGND VGND VPWR VPWR _00880_ sky130_fd_sc_hd__or2_2
X_09687_ tanh_inst.divider.x\[-3\] _04410_ VGND VGND VPWR VPWR _04412_ sky130_fd_sc_hd__and2_2
X_06899_ tanh_inst.div_en tanh_inst.divider.z_\[-19\] VGND VGND VPWR VPWR _00170_
+ sky130_fd_sc_hd__and2b_2
X_08638_ tanh_inst.divider.y\[5\] _03417_ VGND VGND VPWR VPWR _03419_ sky130_fd_sc_hd__and2_2
XFILLER_0_83_219 VGND VGND VPWR VPWR sky130_fd_sc_hd__decap_4
XFILLER_0_76_260 VGND VGND VPWR VPWR sky130_fd_sc_hd__fill_1
XFILLER_0_37_614 VGND VGND VPWR VPWR sky130_fd_sc_hd__fill_2
X_08569_ _03349_ tanh_inst.divider.x\[3\] VGND VGND VPWR VPWR _03352_ sky130_fd_sc_hd__nand2b_2
XFILLER_0_64_433 VGND VGND VPWR VPWR sky130_fd_sc_hd__decap_4
XTAP_TAPCELL_ROW_12_417 VGND VPWR sky130_fd_sc_hd__tapvpwrvgnd_1
XTAP_TAPCELL_ROW_12_406 VGND VPWR sky130_fd_sc_hd__tapvpwrvgnd_1
XFILLER_0_107_535 VGND VGND VPWR VPWR sky130_fd_sc_hd__decap_8
XFILLER_0_64_477 VGND VGND VPWR VPWR sky130_fd_sc_hd__decap_6
XFILLER_0_52_628 VPWR VGND VPWR VGND sky130_ef_sc_hd__decap_12
XTAP_TAPCELL_ROW_40_759 VGND VPWR sky130_fd_sc_hd__tapvpwrvgnd_1
XFILLER_0_10_29 VPWR VGND VPWR VGND sky130_ef_sc_hd__decap_12
X_10462_ clknet_leaf_40_clk _00319_ VGND VGND VPWR VPWR tanh_inst.divider.y\[-2\]
+ sky130_fd_sc_hd__dfxtp_2
XFILLER_0_20_525 VGND VGND VPWR VPWR sky130_fd_sc_hd__decap_6
X_10393_ clknet_leaf_0_clk _00250_ VGND VGND VPWR VPWR tanh_inst.divider.x\[-7\] sky130_fd_sc_hd__dfxtp_2
XFILLER_0_19_27 VPWR VGND VPWR VGND sky130_ef_sc_hd__decap_12
XFILLER_0_20_569 VGND VGND VPWR VPWR sky130_fd_sc_hd__fill_1
XFILLER_0_35_15 VPWR VGND VPWR VGND sky130_ef_sc_hd__decap_12
XFILLER_0_87_503 VGND VGND VPWR VPWR sky130_fd_sc_hd__fill_1
XTAP_TAPCELL_ROW_48_859 VGND VPWR sky130_fd_sc_hd__tapvpwrvgnd_1
XFILLER_0_99_374 VGND VGND VPWR VPWR sky130_fd_sc_hd__fill_2
XFILLER_0_59_238 VGND VGND VPWR VPWR sky130_fd_sc_hd__decap_4
XFILLER_0_28_614 VGND VGND VPWR VPWR sky130_fd_sc_hd__decap_6
XPHY_EDGE_ROW_109_Left_231 VGND VGND VPWR VPWR sky130_fd_sc_hd__decap_3
XFILLER_0_28_658 VGND VGND VPWR VPWR sky130_fd_sc_hd__decap_3
XFILLER_0_113_505 VPWR VGND VPWR VGND sky130_ef_sc_hd__decap_12
XFILLER_0_82_296 VGND VGND VPWR VPWR sky130_fd_sc_hd__decap_6
XFILLER_0_70_425 VGND VGND VPWR VPWR sky130_fd_sc_hd__fill_1
XFILLER_0_42_127 VGND VGND VPWR VPWR sky130_fd_sc_hd__decap_4
Xclkload23 clknet_leaf_4_clk VGND VGND VPWR VPWR clkload23/Y sky130_fd_sc_hd__clkinvlp_4
Xclkload34 clknet_leaf_17_clk VGND VGND VPWR VPWR clkload34/Y sky130_fd_sc_hd__inv_6
Xclkload12 clknet_leaf_29_clk VGND VGND VPWR VPWR clkload12/Y sky130_fd_sc_hd__clkinv_8
XFILLER_0_42_149 VGND VGND VPWR VPWR sky130_fd_sc_hd__decap_4
XFILLER_0_51_683 VGND VGND VPWR VPWR sky130_fd_sc_hd__decap_8
XFILLER_0_50_171 VGND VGND VPWR VPWR sky130_fd_sc_hd__fill_2
XPHY_EDGE_ROW_118_Left_240 VGND VGND VPWR VPWR sky130_fd_sc_hd__decap_3
X_07940_ _02735_ _02737_ VGND VGND VPWR VPWR _02738_ sky130_fd_sc_hd__xnor2_2
X_07871_ _02581_ _02627_ _02629_ _02626_ VGND VGND VPWR VPWR _02670_ sky130_fd_sc_hd__a31o_2
XFILLER_0_76_77 VGND VGND VPWR VPWR sky130_fd_sc_hd__decap_6
X_06822_ tanh_inst.z_\[-1\] _01713_ VGND VGND VPWR VPWR _01714_ sky130_fd_sc_hd__nor2_2
X_09610_ _04335_ _04336_ VGND VGND VPWR VPWR _04337_ sky130_fd_sc_hd__or2_2
X_09541_ _02929_ _04269_ VGND VGND VPWR VPWR _04270_ sky130_fd_sc_hd__and2_2
X_06753_ mac_y_out[15] _01469_ _01502_ _01652_ VGND VGND VPWR VPWR _00143_ sky130_fd_sc_hd__a22o_2
X_05704_ _04923_ _04944_ _00680_ VGND VGND VPWR VPWR _00681_ sky130_fd_sc_hd__nor3_2
XFILLER_0_116_83 VGND VGND VPWR VPWR sky130_fd_sc_hd__fill_1
X_09472_ _04200_ _04201_ VGND VGND VPWR VPWR _04203_ sky130_fd_sc_hd__xor2_2
X_06684_ tanh_inst.z_\[-16\] _01590_ VGND VGND VPWR VPWR _01591_ sky130_fd_sc_hd__and2_2
X_08423_ _03206_ _03208_ VGND VGND VPWR VPWR _03209_ sky130_fd_sc_hd__nor2_2
X_05635_ mac_inst.y\[26\] _00619_ VGND VGND VPWR VPWR _00620_ sky130_fd_sc_hd__and2_2
XTAP_TAPCELL_ROW_63_1050 VGND VPWR sky130_fd_sc_hd__tapvpwrvgnd_1
XFILLER_0_19_658 VPWR VGND VPWR VGND sky130_ef_sc_hd__decap_12
X_08354_ _03084_ _03101_ _03058_ VGND VGND VPWR VPWR _03142_ sky130_fd_sc_hd__o21a_2
X_05566_ mac_inst.y\[19\] _00557_ VGND VGND VPWR VPWR _00558_ sky130_fd_sc_hd__and2_2
XFILLER_0_73_252 VGND VGND VPWR VPWR sky130_fd_sc_hd__fill_1
X_07305_ tanh_inst.divider.y\[4\] tanh_inst.divider.y\[5\] tanh_inst.divider.y\[6\]
+ tanh_inst.divider.y\[7\] tanh_inst.LOOKUP.index\[0\] tanh_inst.LOOKUP.index\[1\]
+ VGND VGND VPWR VPWR _02115_ sky130_fd_sc_hd__mux4_2
XFILLER_0_6_552 VGND VGND VPWR VPWR sky130_fd_sc_hd__decap_4
X_05497_ _05013_ _05016_ _05017_ _05023_ _04781_ _04782_ VGND VGND VPWR VPWR _00494_
+ sky130_fd_sc_hd__mux4_2
Xclkload6 clknet_leaf_41_clk VGND VGND VPWR VPWR clkload6/Y sky130_fd_sc_hd__inv_6
X_08285_ _03073_ _03074_ VGND VGND VPWR VPWR _03075_ sky130_fd_sc_hd__or2_2
X_07236_ tanh_inst.divider.y\[-16\] _02028_ _02029_ VGND VGND VPWR VPWR _02046_ sky130_fd_sc_hd__o21ai_2
XTAP_TAPCELL_ROW_115_1703 VGND VPWR sky130_fd_sc_hd__tapvpwrvgnd_1
X_07167_ _01984_ _01986_ tanh_inst.divider.z_\[2\] _01092_ VGND VGND VPWR VPWR _00223_
+ sky130_fd_sc_hd__a2bb2o_2
X_06118_ tanh_inst.divider.x\[-7\] tanh_inst.divider.x\[-6\] tanh_inst.divider.x\[-5\]
+ tanh_inst.divider.x\[-4\] tanh_inst.divider.i\[0\] tanh_inst.divider.i\[1\] VGND
+ VGND VPWR VPWR _01064_ sky130_fd_sc_hd__mux4_2
XFILLER_0_14_385 VGND VGND VPWR VPWR sky130_fd_sc_hd__decap_3
X_07098_ _04777_ _01031_ _01035_ VGND VGND VPWR VPWR _01925_ sky130_fd_sc_hd__or3_2
XTAP_TAPCELL_ROW_74_1190 VGND VPWR sky130_fd_sc_hd__tapvpwrvgnd_1
X_06049_ _00951_ _00984_ _00991_ _00999_ _00982_ VGND VGND VPWR VPWR _01000_ sky130_fd_sc_hd__o2111ai_2
X_09808_ _04525_ _04529_ VGND VGND VPWR VPWR _04530_ sky130_fd_sc_hd__xnor2_2
X_09739_ _04461_ _04462_ VGND VGND VPWR VPWR _04463_ sky130_fd_sc_hd__and2_2
XFILLER_0_96_333 VGND VGND VPWR VPWR sky130_fd_sc_hd__decap_3
XFILLER_0_69_558 VGND VGND VPWR VPWR sky130_fd_sc_hd__fill_2
XTAP_TAPCELL_ROW_45_829 VGND VPWR sky130_fd_sc_hd__tapvpwrvgnd_1
XFILLER_0_84_517 VGND VGND VPWR VPWR sky130_fd_sc_hd__fill_1
XTAP_TAPCELL_ROW_25_575 VGND VPWR sky130_fd_sc_hd__tapvpwrvgnd_1
XFILLER_0_49_271 VGND VGND VPWR VPWR sky130_fd_sc_hd__decap_8
XFILLER_0_119_181 VPWR VGND VPWR VGND sky130_ef_sc_hd__decap_12
XFILLER_0_64_285 VGND VGND VPWR VPWR sky130_fd_sc_hd__decap_4
XFILLER_0_21_39 VPWR VGND VPWR VGND sky130_ef_sc_hd__decap_12
XFILLER_0_107_387 VGND VGND VPWR VPWR sky130_fd_sc_hd__decap_4
XTAP_TAPCELL_ROW_77_1219 VGND VPWR sky130_fd_sc_hd__tapvpwrvgnd_1
X_10445_ clknet_leaf_9_clk _00302_ VGND VGND VPWR VPWR tanh_inst.divider.y\[-19\]
+ sky130_fd_sc_hd__dfxtp_2
XFILLER_0_110_519 VPWR VGND VPWR VGND sky130_ef_sc_hd__decap_12
XFILLER_0_20_333 VGND VGND VPWR VPWR sky130_fd_sc_hd__decap_8
X_10376_ clknet_leaf_25_clk _00233_ VGND VGND VPWR VPWR tanh_inst.divider.x\[-24\]
+ sky130_fd_sc_hd__dfxtp_2
XFILLER_0_20_355 VGND VGND VPWR VPWR sky130_fd_sc_hd__decap_3
XTAP_TAPCELL_ROW_88_1359 VGND VPWR sky130_fd_sc_hd__tapvpwrvgnd_1
XFILLER_0_1_27 VPWR VGND VPWR VGND sky130_ef_sc_hd__decap_12
XFILLER_0_99_193 VPWR VGND VPWR VGND sky130_ef_sc_hd__decap_12
XFILLER_0_62_46 VGND VGND VPWR VPWR sky130_fd_sc_hd__decap_8
XFILLER_0_7_305 VPWR VGND VPWR VGND sky130_ef_sc_hd__decap_12
X_05420_ mac_inst.y\[7\] _00422_ VGND VGND VPWR VPWR _00424_ sky130_fd_sc_hd__nor2_2
XFILLER_0_55_252 VGND VGND VPWR VPWR sky130_fd_sc_hd__fill_1
X_05351_ mac_inst.i\[1\] _04998_ _00358_ _04909_ VGND VGND VPWR VPWR _00359_ sky130_fd_sc_hd__a211o_2
XFILLER_0_7_349 VPWR VGND VPWR VGND sky130_ef_sc_hd__decap_12
XFILLER_0_15_105 VGND VGND VPWR VPWR sky130_fd_sc_hd__decap_6
XFILLER_0_102_41 VPWR VGND VPWR VGND sky130_ef_sc_hd__decap_12
XFILLER_0_70_244 VGND VGND VPWR VPWR sky130_fd_sc_hd__decap_8
X_08070_ _02863_ _02864_ VGND VGND VPWR VPWR _02865_ sky130_fd_sc_hd__xnor2_2
XFILLER_0_15_149 VPWR VGND VPWR VGND sky130_ef_sc_hd__decap_12
X_05282_ _04942_ _04982_ VGND VGND VPWR VPWR _04983_ sky130_fd_sc_hd__nor2_2
XFILLER_0_43_447 VGND VGND VPWR VPWR sky130_fd_sc_hd__fill_1
X_07021_ _01841_ _01842_ _01848_ _01839_ VGND VGND VPWR VPWR _01857_ sky130_fd_sc_hd__a211o_2
XFILLER_0_102_85 VPWR VGND VPWR VGND sky130_ef_sc_hd__decap_12
XTAP_TAPCELL_ROW_99_1499 VGND VPWR sky130_fd_sc_hd__tapvpwrvgnd_1
XFILLER_0_113_357 VGND VGND VPWR VPWR sky130_fd_sc_hd__decap_6
X_08972_ tanh_inst.divider.y\[-22\] _03715_ VGND VGND VPWR VPWR _03716_ sky130_fd_sc_hd__and2_2
X_07923_ _02713_ _02720_ VGND VGND VPWR VPWR _02721_ sky130_fd_sc_hd__xor2_2
XTAP_TAPCELL_ROW_110_1633 VGND VPWR sky130_fd_sc_hd__tapvpwrvgnd_1
X_07854_ _02640_ _02653_ _02015_ VGND VGND VPWR VPWR _02654_ sky130_fd_sc_hd__a21o_2
XFILLER_0_39_3 VGND VGND VPWR VPWR sky130_fd_sc_hd__decap_8
X_06805_ tanh_inst.z_\[-3\] _01698_ VGND VGND VPWR VPWR _01699_ sky130_fd_sc_hd__xor2_2
X_07785_ _02579_ _02584_ VGND VGND VPWR VPWR _02586_ sky130_fd_sc_hd__and2_2
X_09524_ _04181_ _04249_ _04253_ _04202_ VGND VGND VPWR VPWR _04254_ sky130_fd_sc_hd__o211a_2
X_06736_ tanh_inst.z_\[7\] _01534_ VGND VGND VPWR VPWR _01637_ sky130_fd_sc_hd__nor2_2
X_09455_ _04088_ _04143_ VGND VGND VPWR VPWR _04187_ sky130_fd_sc_hd__nand2b_2
X_06667_ _01574_ _01575_ VGND VGND VPWR VPWR _01576_ sky130_fd_sc_hd__and2b_2
XFILLER_0_19_400 VGND VGND VPWR VPWR sky130_fd_sc_hd__decap_3
XFILLER_0_19_422 VGND VGND VPWR VPWR sky130_fd_sc_hd__decap_8
X_08406_ tanh_inst.divider.x\[-1\] _03192_ VGND VGND VPWR VPWR _03193_ sky130_fd_sc_hd__nor2_2
X_05618_ _00603_ _00604_ VGND VGND VPWR VPWR _00605_ sky130_fd_sc_hd__nor2_2
XTAP_TAPCELL_ROW_121_1784 VGND VPWR sky130_fd_sc_hd__tapvpwrvgnd_1
XTAP_TAPCELL_ROW_121_1773 VGND VPWR sky130_fd_sc_hd__tapvpwrvgnd_1
X_09386_ tanh_inst.divider.y\[-12\] _04119_ VGND VGND VPWR VPWR _04120_ sky130_fd_sc_hd__nand2_2
X_06598_ _01471_ _01486_ _01472_ VGND VGND VPWR VPWR _01511_ sky130_fd_sc_hd__a21oi_2
XFILLER_0_62_701 VGND VGND VPWR VPWR sky130_fd_sc_hd__fill_2
XTAP_TAPCELL_ROW_22_534 VGND VPWR sky130_fd_sc_hd__tapvpwrvgnd_1
XFILLER_0_74_583 VGND VGND VPWR VPWR sky130_fd_sc_hd__decap_4
X_08337_ tanh_inst.divider.x\[-3\] _03111_ _03074_ VGND VGND VPWR VPWR _03125_ sky130_fd_sc_hd__a21o_2
X_05549_ _00524_ _00541_ mac_inst.z\[31\] VGND VGND VPWR VPWR _00542_ sky130_fd_sc_hd__a21oi_2
XFILLER_0_46_285 VGND VGND VPWR VPWR sky130_fd_sc_hd__fill_2
XFILLER_0_104_302 VGND VGND VPWR VPWR sky130_fd_sc_hd__fill_1
XFILLER_0_22_609 VPWR VGND VPWR VGND sky130_ef_sc_hd__decap_12
X_08268_ _03028_ _03057_ VGND VGND VPWR VPWR _03058_ sky130_fd_sc_hd__or2_2
XTAP_TAPCELL_ROW_50_887 VGND VPWR sky130_fd_sc_hd__tapvpwrvgnd_1
X_07219_ tanh_inst.LOOKUP.index\[4\] tanh_inst.divider.y\[7\] _02020_ VGND VGND VPWR
+ VPWR _02029_ sky130_fd_sc_hd__or3b_2
X_10230_ clknet_leaf_28_clk mac_inst.y\[24\] _00000_ VGND VGND VPWR VPWR mac_y_out[24]
+ sky130_fd_sc_hd__dfrtp_2
X_08199_ _04770_ _02989_ VGND VGND VPWR VPWR _02991_ sky130_fd_sc_hd__xnor2_2
XFILLER_0_100_552 VGND VGND VPWR VPWR sky130_fd_sc_hd__fill_2
XFILLER_0_30_686 VGND VGND VPWR VPWR sky130_fd_sc_hd__fill_1
X_10092_ clknet_leaf_5_clk _00109_ VGND VGND VPWR VPWR tanh_inst.divider.y_\[-1\]
+ sky130_fd_sc_hd__dfxtp_2
XFILLER_0_100_596 VGND VGND VPWR VPWR sky130_fd_sc_hd__decap_8
XFILLER_0_100_585 VGND VGND VPWR VPWR sky130_fd_sc_hd__decap_3
XFILLER_0_100_563 VGND VGND VPWR VPWR sky130_fd_sc_hd__fill_1
XTAP_TAPCELL_ROW_58_987 VGND VPWR sky130_fd_sc_hd__tapvpwrvgnd_1
XTAP_TAPCELL_ROW_2_281 VGND VPWR sky130_fd_sc_hd__tapvpwrvgnd_1
XTAP_TAPCELL_ROW_2_292 VGND VPWR sky130_fd_sc_hd__tapvpwrvgnd_1
XFILLER_0_29_208 VGND VGND VPWR VPWR sky130_fd_sc_hd__fill_2
XFILLER_0_32_27 VGND VGND VPWR VPWR sky130_fd_sc_hd__fill_1
XFILLER_0_65_561 VGND VGND VPWR VPWR sky130_fd_sc_hd__decap_8
XFILLER_0_108_652 VGND VGND VPWR VPWR sky130_fd_sc_hd__decap_4
XFILLER_0_37_274 VGND VGND VPWR VPWR sky130_fd_sc_hd__fill_1
XFILLER_0_107_140 VGND VGND VPWR VPWR sky130_fd_sc_hd__decap_4
XFILLER_0_25_447 VGND VGND VPWR VPWR sky130_fd_sc_hd__fill_1
XFILLER_0_25_469 VPWR VGND VPWR VGND sky130_ef_sc_hd__decap_12
XFILLER_0_0_547 VPWR VGND VPWR VGND sky130_ef_sc_hd__decap_12
XFILLER_0_20_141 VPWR VGND VPWR VGND sky130_ef_sc_hd__decap_12
X_10428_ clknet_leaf_40_clk _00285_ _00000_ VGND VGND VPWR VPWR mac_inst.i\[20\] sky130_fd_sc_hd__dfrtp_2
X_10359_ clknet_leaf_18_clk _00216_ VGND VGND VPWR VPWR tanh_inst.divider.z_\[-5\]
+ sky130_fd_sc_hd__dfxtp_2
XFILLER_0_57_68 VPWR VGND VPWR VGND sky130_ef_sc_hd__decap_12
XFILLER_0_73_67 VGND VGND VPWR VPWR sky130_fd_sc_hd__fill_1
X_07570_ tanh_inst.z_\[7\] _02375_ VGND VGND VPWR VPWR _02376_ sky130_fd_sc_hd__nor2_2
X_06521_ _01433_ _01438_ _01439_ VGND VGND VPWR VPWR _01440_ sky130_fd_sc_hd__o21a_2
XFILLER_0_75_303 VGND VGND VPWR VPWR sky130_fd_sc_hd__decap_4
XFILLER_0_48_517 VGND VGND VPWR VPWR sky130_fd_sc_hd__fill_1
X_09240_ _01477_ _03575_ _03649_ _01525_ VGND VGND VPWR VPWR _03978_ sky130_fd_sc_hd__o22a_2
X_06452_ _01372_ _01373_ _01374_ _01376_ VGND VGND VPWR VPWR _01377_ sky130_fd_sc_hd__o31a_2
XFILLER_0_7_113 VPWR VGND VPWR VGND sky130_ef_sc_hd__decap_12
X_06383_ _01312_ tanh_inst.divider.y_\[-7\] VGND VGND VPWR VPWR _01313_ sky130_fd_sc_hd__nand2b_2
XFILLER_0_113_51 VGND VGND VPWR VPWR sky130_fd_sc_hd__decap_4
X_09171_ tanh_inst.divider.y\[-18\] _02014_ _03910_ _01470_ VGND VGND VPWR VPWR _00303_
+ sky130_fd_sc_hd__o211a_2
XFILLER_0_56_572 VPWR VGND VPWR VGND sky130_ef_sc_hd__decap_12
XFILLER_0_8_669 VGND VGND VPWR VPWR sky130_fd_sc_hd__fill_2
X_05403_ _00406_ _00407_ VGND VGND VPWR VPWR _00408_ sky130_fd_sc_hd__nand2_2
XFILLER_0_28_274 VGND VGND VPWR VPWR sky130_fd_sc_hd__fill_2
XFILLER_0_44_701 VGND VGND VPWR VPWR sky130_fd_sc_hd__fill_1
XFILLER_0_114_611 VGND VGND VPWR VPWR sky130_fd_sc_hd__fill_2
XFILLER_0_43_233 VGND VGND VPWR VPWR sky130_fd_sc_hd__fill_2
X_05334_ mac_inst.y\[2\] _00342_ VGND VGND VPWR VPWR _00343_ sky130_fd_sc_hd__nand2_2
X_08122_ _04771_ _02915_ VGND VGND VPWR VPWR _02916_ sky130_fd_sc_hd__nand2_2
X_08053_ tanh_inst.divider.y\[-9\] tanh_inst.divider.x\[-9\] VGND VGND VPWR VPWR _02848_
+ sky130_fd_sc_hd__or2_2
XFILLER_0_98_53 VPWR VGND VPWR VGND sky130_ef_sc_hd__decap_12
X_07004_ _01834_ _01836_ _01833_ VGND VGND VPWR VPWR _01842_ sky130_fd_sc_hd__a21o_2
X_05265_ mac_inst.i\[8\] _04965_ _04938_ VGND VGND VPWR VPWR _04966_ sky130_fd_sc_hd__mux2_1
XFILLER_0_98_97 VPWR VGND VPWR VGND sky130_ef_sc_hd__decap_12
X_05196_ mac_inst.x\[14\] _04852_ _04853_ VGND VGND VPWR VPWR _04900_ sky130_fd_sc_hd__a21o_2
XFILLER_0_3_385 VGND VGND VPWR VPWR sky130_fd_sc_hd__fill_1
XFILLER_0_12_697 VGND VGND VPWR VPWR sky130_fd_sc_hd__decap_3
X_08955_ tanh_inst.divider.x\[-6\] tanh_inst.divider.x\[-5\] tanh_inst.divider.x\[-4\]
+ tanh_inst.divider.x\[-3\] tanh_inst.LOOKUP.index\[0\] tanh_inst.LOOKUP.index\[1\]
+ VGND VGND VPWR VPWR _03699_ sky130_fd_sc_hd__mux4_2
X_07906_ _02662_ _02663_ _02619_ VGND VGND VPWR VPWR _02704_ sky130_fd_sc_hd__o21a_2
X_08886_ tanh_inst.divider.x\[-3\] tanh_inst.divider.x\[-2\] tanh_inst.divider.x\[-1\]
+ tanh_inst.divider.x\[0\] tanh_inst.LOOKUP.index\[0\] tanh_inst.LOOKUP.index\[1\]
+ VGND VGND VPWR VPWR _03631_ sky130_fd_sc_hd__mux4_2
X_07837_ _02634_ _02636_ VGND VGND VPWR VPWR _02637_ sky130_fd_sc_hd__or2_2
X_07768_ tanh_inst.divider.x\[-16\] _02569_ VGND VGND VPWR VPWR _02570_ sky130_fd_sc_hd__or2_2
XTAP_TAPCELL_ROW_27_604 VGND VPWR sky130_fd_sc_hd__tapvpwrvgnd_1
X_09507_ _04185_ _04206_ VGND VGND VPWR VPWR _04237_ sky130_fd_sc_hd__nand2_2
XFILLER_0_78_141 VGND VGND VPWR VPWR sky130_fd_sc_hd__decap_4
X_06719_ _01533_ _01621_ VGND VGND VPWR VPWR _01622_ sky130_fd_sc_hd__xnor2_2
XTAP_TAPCELL_ROW_55_946 VGND VPWR sky130_fd_sc_hd__tapvpwrvgnd_1
XFILLER_0_94_645 VGND VGND VPWR VPWR sky130_fd_sc_hd__decap_8
X_07699_ _02405_ _02455_ _02457_ _02454_ VGND VGND VPWR VPWR _02502_ sky130_fd_sc_hd__a31oi_2
XFILLER_0_66_336 VPWR VGND VPWR VGND sky130_ef_sc_hd__decap_12
X_09438_ _04167_ _04169_ VGND VGND VPWR VPWR _04170_ sky130_fd_sc_hd__nand2b_2
XFILLER_0_66_369 VGND VGND VPWR VPWR sky130_fd_sc_hd__fill_1
X_09369_ _04064_ _04067_ _04102_ VGND VGND VPWR VPWR _04103_ sky130_fd_sc_hd__o21ai_2
XFILLER_0_109_449 VGND VGND VPWR VPWR sky130_fd_sc_hd__decap_3
XFILLER_0_93_177 VGND VGND VPWR VPWR sky130_fd_sc_hd__decap_3
XFILLER_0_81_328 VGND VGND VPWR VPWR sky130_fd_sc_hd__fill_1
XFILLER_0_35_723 VGND VGND VPWR VPWR sky130_fd_sc_hd__fill_1
XFILLER_0_62_564 VGND VGND VPWR VPWR sky130_fd_sc_hd__decap_6
XFILLER_0_105_655 VGND VGND VPWR VPWR sky130_fd_sc_hd__decap_8
XFILLER_0_104_132 VGND VGND VPWR VPWR sky130_fd_sc_hd__decap_8
XFILLER_0_22_439 VGND VGND VPWR VPWR sky130_fd_sc_hd__decap_8
XFILLER_0_104_187 VGND VGND VPWR VPWR sky130_fd_sc_hd__decap_3
X_10213_ clknet_leaf_22_clk mac_inst.y\[7\] _00000_ VGND VGND VPWR VPWR mac_y_out[7]
+ sky130_fd_sc_hd__dfrtp_2
XFILLER_0_30_472 VGND VGND VPWR VPWR sky130_fd_sc_hd__decap_4
XFILLER_0_100_360 VGND VGND VPWR VPWR sky130_fd_sc_hd__decap_4
XFILLER_0_118_29 VPWR VGND VPWR VGND sky130_ef_sc_hd__decap_12
XTAP_TAPCELL_ROW_7_351 VGND VPWR sky130_fd_sc_hd__tapvpwrvgnd_1
XFILLER_0_27_27 VPWR VGND VPWR VGND sky130_ef_sc_hd__decap_12
X_10075_ clknet_leaf_12_clk _00092_ VGND VGND VPWR VPWR tanh_inst.divider.y_\[-18\]
+ sky130_fd_sc_hd__dfxtp_2
XTAP_TAPCELL_ROW_85_1329 VGND VPWR sky130_fd_sc_hd__tapvpwrvgnd_1
XFILLER_0_84_100 VPWR VGND VPWR VGND sky130_ef_sc_hd__decap_12
XFILLER_0_26_701 VGND VGND VPWR VPWR sky130_fd_sc_hd__fill_1
XFILLER_0_65_391 VGND VGND VPWR VPWR sky130_fd_sc_hd__fill_1
XFILLER_0_108_471 VGND VGND VPWR VPWR sky130_fd_sc_hd__decap_4
XTAP_TAPCELL_ROW_96_1458 VGND VPWR sky130_fd_sc_hd__tapvpwrvgnd_1
XFILLER_0_7_15 VPWR VGND VPWR VGND sky130_ef_sc_hd__decap_12
X_05050_ tanh_inst.divider.x\[-23\] VGND VGND VPWR VPWR _04774_ sky130_fd_sc_hd__inv_2
XFILLER_0_68_78 VGND VGND VPWR VPWR sky130_fd_sc_hd__decap_6
XFILLER_0_68_67 VGND VGND VPWR VPWR sky130_fd_sc_hd__decap_4
XFILLER_0_0_333 VGND VGND VPWR VPWR sky130_fd_sc_hd__decap_3
XFILLER_0_0_377 VPWR VGND VPWR VGND sky130_ef_sc_hd__decap_12
X_05952_ _00903_ _00908_ VGND VGND VPWR VPWR _05952_/X sky130_fd_sc_hd__xor2_2
X_08740_ _03498_ _03499_ VGND VGND VPWR VPWR _00283_ sky130_fd_sc_hd__nor2_2
X_08671_ _03445_ _03450_ VGND VGND VPWR VPWR _03451_ sky130_fd_sc_hd__nor2_2
X_05883_ _04912_ _04935_ _04936_ mac_inst.i\[5\] VGND VGND VPWR VPWR _00846_ sky130_fd_sc_hd__a2bb2o_2
X_07622_ tanh_inst.divider.x\[-19\] _02426_ VGND VGND VPWR VPWR _02427_ sky130_fd_sc_hd__and2_2
XFILLER_0_17_93 VPWR VGND VPWR VGND sky130_ef_sc_hd__decap_12
X_07553_ _02357_ _02358_ VGND VGND VPWR VPWR _02359_ sky130_fd_sc_hd__xnor2_2
XFILLER_0_88_472 VGND VGND VPWR VPWR sky130_fd_sc_hd__decap_4
XTAP_TAPCELL_ROW_52_916 VGND VPWR sky130_fd_sc_hd__tapvpwrvgnd_1
X_06504_ _01421_ _01423_ VGND VGND VPWR VPWR _01424_ sky130_fd_sc_hd__xnor2_2
XTAP_TAPCELL_ROW_105_1576 VGND VPWR sky130_fd_sc_hd__tapvpwrvgnd_1
X_07484_ tanh_inst.divider.y\[-21\] _02290_ VGND VGND VPWR VPWR _02291_ sky130_fd_sc_hd__nand2b_2
XFILLER_0_33_70 VGND VGND VPWR VPWR sky130_fd_sc_hd__fill_2
X_06435_ _01359_ _01360_ tanh_inst.divider.y_\[-3\] VGND VGND VPWR VPWR _01361_ sky130_fd_sc_hd__o21ba_2
X_09223_ _03959_ _03960_ VGND VGND VPWR VPWR _03961_ sky130_fd_sc_hd__nor2_2
XFILLER_0_75_188 VGND VGND VPWR VPWR sky130_fd_sc_hd__decap_3
XFILLER_0_75_177 VGND VGND VPWR VPWR sky130_fd_sc_hd__fill_2
XFILLER_0_118_268 VPWR VGND VPWR VGND sky130_ef_sc_hd__decap_12
XFILLER_0_106_419 VGND VGND VPWR VPWR sky130_fd_sc_hd__fill_1
XFILLER_0_16_233 VPWR VGND VPWR VGND sky130_ef_sc_hd__decap_12
XTAP_TAPCELL_ROW_32_662 VGND VPWR sky130_fd_sc_hd__tapvpwrvgnd_1
X_09154_ _03700_ _03702_ tanh_inst.LOOKUP.index\[2\] VGND VGND VPWR VPWR _03894_ sky130_fd_sc_hd__mux2_1
X_06366_ _01089_ _01297_ VGND VGND VPWR VPWR _01298_ sky130_fd_sc_hd__nor2_2
X_08105_ _02767_ _02812_ _02813_ _02854_ _02897_ VGND VGND VPWR VPWR _02899_ sky130_fd_sc_hd__o41a_2
XFILLER_0_8_499 VGND VGND VPWR VPWR sky130_fd_sc_hd__decap_8
XFILLER_0_44_564 VGND VGND VPWR VPWR sky130_fd_sc_hd__decap_6
X_06297_ _01209_ _01220_ _01221_ VGND VGND VPWR VPWR _01234_ sky130_fd_sc_hd__o21ai_2
X_09085_ tanh_inst.divider.y\[-20\] _02014_ _03826_ _01470_ VGND VGND VPWR VPWR _00301_
+ sky130_fd_sc_hd__o211a_2
XFILLER_0_16_277 VPWR VGND VPWR VGND sky130_ef_sc_hd__decap_12
X_05317_ _04858_ _04860_ _04863_ _04864_ _04783_ mac_inst.i\[1\] VGND VGND VPWR VPWR
+ _05016_ sky130_fd_sc_hd__mux4_2
XFILLER_0_101_113 VGND VGND VPWR VPWR sky130_fd_sc_hd__decap_6
X_08036_ _02018_ _02829_ _02830_ _02015_ VGND VGND VPWR VPWR _02832_ sky130_fd_sc_hd__a31o_2
X_05248_ _04948_ _04947_ _04946_ VGND VGND VPWR VPWR _04949_ sky130_fd_sc_hd__mux2_1
XFILLER_0_102_669 VGND VGND VPWR VPWR sky130_fd_sc_hd__fill_2
XFILLER_0_12_472 VGND VGND VPWR VPWR sky130_fd_sc_hd__decap_4
XFILLER_0_3_193 VPWR VGND VPWR VGND sky130_ef_sc_hd__decap_12
XFILLER_0_12_483 VGND VGND VPWR VPWR sky130_fd_sc_hd__fill_1
X_05179_ _04861_ _04867_ _04873_ _04881_ mac_inst.i\[2\] mac_inst.i\[3\] VGND VGND
+ VPWR VPWR _04883_ sky130_fd_sc_hd__mux4_2
X_09987_ _02019_ _04695_ _04703_ _02015_ VGND VGND VPWR VPWR _04704_ sky130_fd_sc_hd__a211o_2
X_08938_ _02022_ _03681_ VGND VGND VPWR VPWR _03682_ sky130_fd_sc_hd__or2_2
XTAP_TAPCELL_ROW_4_310 VGND VPWR sky130_fd_sc_hd__tapvpwrvgnd_1
X_08869_ _03612_ _03613_ _04768_ VGND VGND VPWR VPWR _03614_ sky130_fd_sc_hd__a21oi_2
XFILLER_0_39_303 VPWR VGND VPWR VGND sky130_ef_sc_hd__decap_12
XFILLER_0_94_442 VGND VGND VPWR VPWR sky130_fd_sc_hd__fill_2
XFILLER_0_67_678 VPWR VGND VPWR VGND sky130_ef_sc_hd__decap_12
XPHY_EDGE_ROW_11_Right_11 VGND VGND VPWR VPWR sky130_fd_sc_hd__decap_3
XFILLER_0_39_369 VGND VGND VPWR VPWR sky130_fd_sc_hd__decap_3
XTAP_TAPCELL_ROW_80_1259 VGND VPWR sky130_fd_sc_hd__tapvpwrvgnd_1
XFILLER_0_109_279 VGND VGND VPWR VPWR sky130_fd_sc_hd__fill_1
XFILLER_0_47_380 VPWR VGND VPWR VGND sky130_ef_sc_hd__decap_12
XFILLER_0_81_169 VPWR VGND VPWR VGND sky130_ef_sc_hd__decap_12
XFILLER_0_2_609 VGND VGND VPWR VPWR sky130_fd_sc_hd__fill_2
XTAP_TAPCELL_ROW_10_389 VGND VPWR sky130_fd_sc_hd__tapvpwrvgnd_1
XPHY_EDGE_ROW_20_Right_20 VGND VGND VPWR VPWR sky130_fd_sc_hd__decap_3
XTAP_TAPCELL_ROW_91_1399 VGND VPWR sky130_fd_sc_hd__tapvpwrvgnd_1
X_10058_ rst VGND VGND VPWR VPWR _00077_ sky130_fd_sc_hd__inv_2
XFILLER_0_89_225 VGND VGND VPWR VPWR sky130_fd_sc_hd__decap_4
XFILLER_0_57_111 VGND VGND VPWR VPWR sky130_fd_sc_hd__fill_1
XFILLER_0_85_442 VGND VGND VPWR VPWR sky130_fd_sc_hd__fill_1
XTAP_TAPCELL_ROW_18_489 VGND VPWR sky130_fd_sc_hd__tapvpwrvgnd_1
XFILLER_0_73_615 VGND VGND VPWR VPWR sky130_fd_sc_hd__fill_1
XFILLER_0_70_68 VGND VGND VPWR VPWR sky130_fd_sc_hd__fill_2
X_06220_ _01039_ _01161_ VGND VGND VPWR VPWR _01162_ sky130_fd_sc_hd__or2_2
XFILLER_0_73_659 VGND VGND VPWR VPWR sky130_fd_sc_hd__decap_6
XFILLER_0_79_11 VGND VGND VPWR VPWR sky130_fd_sc_hd__fill_2
XFILLER_0_41_501 VGND VGND VPWR VPWR sky130_fd_sc_hd__decap_3
XFILLER_0_53_350 VGND VGND VPWR VPWR sky130_fd_sc_hd__fill_1
XFILLER_0_108_290 VGND VGND VPWR VPWR sky130_fd_sc_hd__decap_4
X_06151_ tanh_inst.divider.x\[2\] tanh_inst.divider.x\[3\] tanh_inst.divider.x\[4\]
+ tanh_inst.divider.x\[5\] tanh_inst.divider.i\[0\] tanh_inst.divider.i\[1\] VGND
+ VGND VPWR VPWR _01096_ sky130_fd_sc_hd__mux4_2
XFILLER_0_13_225 VPWR VGND VPWR VGND sky130_ef_sc_hd__decap_12
XFILLER_0_26_586 VGND VGND VPWR VPWR sky130_fd_sc_hd__fill_2
XFILLER_0_110_41 VPWR VGND VPWR VGND sky130_ef_sc_hd__decap_12
X_06082_ _04777_ _01028_ VGND VGND VPWR VPWR _01029_ sky130_fd_sc_hd__nor2_2
XFILLER_0_79_55 VGND VGND VPWR VPWR sky130_fd_sc_hd__fill_1
X_05102_ current_state\[1\] _04779_ VGND VGND VPWR VPWR _04817_ sky130_fd_sc_hd__and2_2
XFILLER_0_111_444 VGND VGND VPWR VPWR sky130_fd_sc_hd__decap_4
XFILLER_0_111_433 VGND VGND VPWR VPWR sky130_fd_sc_hd__fill_2
XFILLER_0_110_85 VPWR VGND VPWR VGND sky130_ef_sc_hd__decap_12
X_09910_ _04757_ _04076_ _04212_ VGND VGND VPWR VPWR _04629_ sky130_fd_sc_hd__a21oi_2
X_05033_ tanh_inst.LOOKUP.index\[4\] VGND VGND VPWR VPWR _04757_ sky130_fd_sc_hd__inv_2
XFILLER_0_0_141 VPWR VGND VPWR VGND sky130_ef_sc_hd__decap_12
XFILLER_0_1_664 VGND VGND VPWR VPWR sky130_fd_sc_hd__fill_1
X_09841_ _04560_ _04561_ VGND VGND VPWR VPWR _04562_ sky130_fd_sc_hd__xor2_2
X_06984_ _01821_ _01823_ VGND VGND VPWR VPWR _01824_ sky130_fd_sc_hd__nand2_2
X_09772_ _04493_ _04494_ VGND VGND VPWR VPWR _04495_ sky130_fd_sc_hd__xnor2_2
X_05935_ mac_inst.z\[19\] _00892_ VGND VGND VPWR VPWR _00895_ sky130_fd_sc_hd__nand2_2
X_08723_ mac_inst.i\[9\] _00959_ VGND VGND VPWR VPWR _00274_ sky130_fd_sc_hd__xnor2_2
XTAP_TAPCELL_ROW_107_1605 VGND VPWR sky130_fd_sc_hd__tapvpwrvgnd_1
XFILLER_0_21_3 VPWR VGND VPWR VGND sky130_ef_sc_hd__decap_12
X_08654_ _03433_ _03434_ VGND VGND VPWR VPWR _03435_ sky130_fd_sc_hd__nor2_2
X_05866_ _00802_ _00818_ _00817_ VGND VGND VPWR VPWR _00831_ sky130_fd_sc_hd__a21bo_2
XTAP_TAPCELL_ROW_37_721 VGND VPWR sky130_fd_sc_hd__tapvpwrvgnd_1
X_07605_ _02409_ VGND VGND VPWR VPWR _02410_ sky130_fd_sc_hd__inv_2
X_05797_ mac_inst.z\[9\] _00763_ VGND VGND VPWR VPWR _00767_ sky130_fd_sc_hd__nand2_2
XFILLER_0_49_612 VGND VGND VPWR VPWR sky130_fd_sc_hd__decap_4
X_08585_ _03317_ _03335_ VGND VGND VPWR VPWR _03367_ sky130_fd_sc_hd__and2_2
X_07536_ tanh_inst.divider.y\[7\] _02070_ _02025_ VGND VGND VPWR VPWR _02342_ sky130_fd_sc_hd__mux2_1
XTAP_TAPCELL_ROW_66_1081 VGND VPWR sky130_fd_sc_hd__tapvpwrvgnd_1
XTAP_TAPCELL_ROW_66_1092 VGND VPWR sky130_fd_sc_hd__tapvpwrvgnd_1
XFILLER_0_107_706 VGND VGND VPWR VPWR sky130_fd_sc_hd__fill_1
X_07467_ _02028_ _02144_ _02029_ _02026_ VGND VGND VPWR VPWR _02274_ sky130_fd_sc_hd__o211a_2
X_09206_ _03815_ _03816_ _03858_ _03900_ VGND VGND VPWR VPWR _03945_ sky130_fd_sc_hd__and4b_2
X_06418_ tanh_inst.divider.y_\[-4\] _01344_ VGND VGND VPWR VPWR _01345_ sky130_fd_sc_hd__and2_2
X_07398_ _02204_ _02205_ _02025_ VGND VGND VPWR VPWR _02206_ sky130_fd_sc_hd__mux2_1
XFILLER_0_17_542 VGND VGND VPWR VPWR sky130_fd_sc_hd__decap_8
XFILLER_0_51_309 VPWR VGND VPWR VGND sky130_ef_sc_hd__decap_12
X_06349_ tanh_inst.divider.y_\[-10\] _01281_ VGND VGND VPWR VPWR _01282_ sky130_fd_sc_hd__and2_2
XTAP_TAPCELL_ROW_118_1734 VGND VPWR sky130_fd_sc_hd__tapvpwrvgnd_1
X_09137_ tanh_inst.divider.y\[-18\] _03876_ VGND VGND VPWR VPWR _03877_ sky130_fd_sc_hd__and2_2
XFILLER_0_102_411 VGND VGND VPWR VPWR sky130_fd_sc_hd__fill_1
X_09068_ tanh_inst.LOOKUP.index\[2\] _03654_ _03760_ tanh_inst.LOOKUP.index\[3\] VGND
+ VGND VPWR VPWR _03810_ sky130_fd_sc_hd__o211a_2
X_08019_ _02812_ _02814_ VGND VGND VPWR VPWR _02815_ sky130_fd_sc_hd__or2_2
XFILLER_0_32_589 VGND VGND VPWR VPWR sky130_fd_sc_hd__fill_1
XFILLER_0_87_718 VGND VGND VPWR VPWR sky130_fd_sc_hd__decap_6
XFILLER_0_39_144 VGND VGND VPWR VPWR sky130_fd_sc_hd__decap_3
XFILLER_0_94_250 VGND VGND VPWR VPWR sky130_fd_sc_hd__fill_2
XFILLER_0_55_615 VGND VGND VPWR VPWR sky130_fd_sc_hd__fill_1
XTAP_TAPCELL_ROW_15_448 VGND VPWR sky130_fd_sc_hd__tapvpwrvgnd_1
XFILLER_0_39_177 VGND VGND VPWR VPWR sky130_fd_sc_hd__decap_8
XFILLER_0_82_445 VGND VGND VPWR VPWR sky130_fd_sc_hd__decap_6
XFILLER_0_27_328 VGND VGND VPWR VPWR sky130_fd_sc_hd__decap_8
XFILLER_0_40_16 VGND VGND VPWR VPWR sky130_fd_sc_hd__fill_2
XFILLER_0_70_629 VGND VGND VPWR VPWR sky130_fd_sc_hd__decap_4
XFILLER_0_121_720 VGND VGND VPWR VPWR sky130_fd_sc_hd__decap_4
XFILLER_0_112_208 VGND VGND VPWR VPWR sky130_fd_sc_hd__fill_2
XTAP_TAPCELL_ROW_93_1428 VGND VPWR sky130_fd_sc_hd__tapvpwrvgnd_1
XFILLER_0_4_27 VGND VGND VPWR VPWR sky130_fd_sc_hd__fill_1
XFILLER_0_65_46 VGND VGND VPWR VPWR sky130_fd_sc_hd__decap_3
X_05720_ mac_inst.z\[31\] _00695_ _00693_ VGND VGND VPWR VPWR _00696_ sky130_fd_sc_hd__o21ai_2
X_05651_ _00633_ VGND VGND VPWR VPWR _00634_ sky130_fd_sc_hd__inv_2
X_08370_ _03153_ _03157_ VGND VGND VPWR VPWR _03158_ sky130_fd_sc_hd__and2_2
XTAP_TAPCELL_ROW_102_1535 VGND VPWR sky130_fd_sc_hd__tapvpwrvgnd_1
X_07321_ _02027_ _02128_ _02129_ _02127_ VGND VGND VPWR VPWR _02130_ sky130_fd_sc_hd__o31a_2
X_05582_ _00570_ _00571_ VGND VGND VPWR VPWR _00572_ sky130_fd_sc_hd__xor2_2
XFILLER_0_14_83 VGND VGND VPWR VPWR sky130_fd_sc_hd__fill_1
XFILLER_0_6_701 VGND VGND VPWR VPWR sky130_fd_sc_hd__fill_2
XFILLER_0_116_525 VGND VGND VPWR VPWR sky130_fd_sc_hd__fill_1
X_07252_ _02027_ _02061_ VGND VGND VPWR VPWR _02062_ sky130_fd_sc_hd__nor2_2
XTAP_TAPCELL_ROW_42_790 VGND VPWR sky130_fd_sc_hd__tapvpwrvgnd_1
XFILLER_0_45_169 VGND VGND VPWR VPWR sky130_fd_sc_hd__decap_3
X_07183_ tanh_inst.divider.z_\[5\] _01975_ VGND VGND VPWR VPWR _02000_ sky130_fd_sc_hd__nand2_2
X_06203_ _04776_ _01140_ _01145_ VGND VGND VPWR VPWR _01146_ sky130_fd_sc_hd__o21a_2
XFILLER_0_61_629 VGND VGND VPWR VPWR sky130_fd_sc_hd__decap_6
X_06134_ tanh_inst.divider.x\[-11\] tanh_inst.divider.x\[-10\] tanh_inst.divider.x\[-9\]
+ tanh_inst.divider.x\[-8\] tanh_inst.divider.i\[0\] tanh_inst.divider.i\[1\] VGND
+ VGND VPWR VPWR _01080_ sky130_fd_sc_hd__mux4_2
XFILLER_0_26_394 VGND VGND VPWR VPWR sky130_fd_sc_hd__fill_1
XFILLER_0_41_320 VGND VGND VPWR VPWR sky130_fd_sc_hd__fill_1
XFILLER_0_111_241 VGND VGND VPWR VPWR sky130_fd_sc_hd__fill_1
X_06065_ mac_inst.z\[28\] _00996_ _01005_ VGND VGND VPWR VPWR _01014_ sky130_fd_sc_hd__a21oi_2
XTAP_TAPCELL_ROW_113_1675 VGND VPWR sky130_fd_sc_hd__tapvpwrvgnd_1
X_09824_ _02015_ _04544_ _04545_ _01470_ VGND VGND VPWR VPWR _00321_ sky130_fd_sc_hd__o211a_2
X_06967_ _01801_ _01806_ VGND VGND VPWR VPWR _01808_ sky130_fd_sc_hd__nor2_2
X_09755_ _04448_ _04452_ _04476_ tanh_inst.z_\[7\] VGND VGND VPWR VPWR _04478_ sky130_fd_sc_hd__a31o_2
X_06898_ tanh_inst.div_en tanh_inst.divider.z_\[-20\] VGND VGND VPWR VPWR _00169_
+ sky130_fd_sc_hd__and2b_2
XFILLER_0_96_504 VGND VGND VPWR VPWR sky130_fd_sc_hd__decap_6
XTAP_TAPCELL_ROW_68_1110 VGND VPWR sky130_fd_sc_hd__tapvpwrvgnd_1
X_08706_ _03481_ _03484_ VGND VGND VPWR VPWR _03485_ sky130_fd_sc_hd__nand2_2
X_05918_ _00799_ _00838_ _00840_ _00866_ VGND VGND VPWR VPWR _00879_ sky130_fd_sc_hd__and4_2
X_09686_ tanh_inst.divider.x\[-3\] _04410_ VGND VGND VPWR VPWR _04411_ sky130_fd_sc_hd__nor2_2
X_08637_ tanh_inst.divider.y\[5\] _03417_ VGND VGND VPWR VPWR _03418_ sky130_fd_sc_hd__nor2_2
X_05849_ _00795_ _00799_ mac_inst.z\[31\] VGND VGND VPWR VPWR _00815_ sky130_fd_sc_hd__a21o_2
XFILLER_0_68_239 VPWR VGND VPWR VGND sky130_ef_sc_hd__decap_12
X_08568_ _03350_ VGND VGND VPWR VPWR _03351_ sky130_fd_sc_hd__inv_2
X_07519_ _02324_ _02325_ VGND VGND VPWR VPWR _02326_ sky130_fd_sc_hd__xnor2_2
XTAP_TAPCELL_ROW_12_418 VGND VPWR sky130_fd_sc_hd__tapvpwrvgnd_1
XTAP_TAPCELL_ROW_12_407 VGND VPWR sky130_fd_sc_hd__tapvpwrvgnd_1
X_08499_ _04757_ _02641_ _02858_ VGND VGND VPWR VPWR _03283_ sky130_fd_sc_hd__a21o_2
XFILLER_0_52_618 VGND VGND VPWR VPWR sky130_fd_sc_hd__fill_2
XFILLER_0_24_309 VPWR VGND VPWR VGND sky130_ef_sc_hd__decap_12
XFILLER_0_91_275 VGND VGND VPWR VPWR sky130_fd_sc_hd__decap_4
XFILLER_0_64_489 VPWR VGND VPWR VGND sky130_ef_sc_hd__decap_12
XFILLER_0_17_361 VGND VGND VPWR VPWR sky130_fd_sc_hd__decap_8
X_10461_ clknet_leaf_38_clk _00318_ VGND VGND VPWR VPWR tanh_inst.divider.y\[-3\]
+ sky130_fd_sc_hd__dfxtp_2
XTAP_TAPCELL_ROW_79_1250 VGND VPWR sky130_fd_sc_hd__tapvpwrvgnd_1
X_10392_ clknet_leaf_0_clk _00249_ VGND VGND VPWR VPWR tanh_inst.divider.x\[-8\] sky130_fd_sc_hd__dfxtp_2
XFILLER_0_19_39 VPWR VGND VPWR VGND sky130_ef_sc_hd__decap_12
XFILLER_0_99_342 VGND VGND VPWR VPWR sky130_fd_sc_hd__decap_3
XFILLER_0_35_27 VGND VGND VPWR VPWR sky130_fd_sc_hd__decap_3
XFILLER_0_67_261 VGND VGND VPWR VPWR sky130_fd_sc_hd__fill_2
XFILLER_0_82_253 VGND VGND VPWR VPWR sky130_fd_sc_hd__decap_3
XFILLER_0_55_445 VGND VGND VPWR VPWR sky130_fd_sc_hd__decap_3
XFILLER_0_70_415 VGND VGND VPWR VPWR sky130_fd_sc_hd__decap_4
Xclkload24 clknet_leaf_5_clk VGND VGND VPWR VPWR clkload24/Y sky130_fd_sc_hd__clkinvlp_4
XFILLER_0_113_517 VPWR VGND VPWR VGND sky130_ef_sc_hd__decap_12
Xclkload35 clknet_leaf_18_clk VGND VGND VPWR VPWR clkload35/Y sky130_fd_sc_hd__inv_8
XFILLER_0_42_139 VGND VGND VPWR VPWR sky130_fd_sc_hd__fill_1
Xclkload13 clknet_leaf_30_clk VGND VGND VPWR VPWR clkload13/Y sky130_fd_sc_hd__clkinv_8
XFILLER_0_121_561 VPWR VGND VPWR VGND sky130_ef_sc_hd__decap_12
XFILLER_0_23_386 VGND VGND VPWR VPWR sky130_fd_sc_hd__fill_1
XFILLER_0_121_583 VGND VGND VPWR VPWR sky130_fd_sc_hd__decap_4
XFILLER_0_55_9 VGND VGND VPWR VPWR sky130_fd_sc_hd__fill_1
XFILLER_0_11_559 VGND VGND VPWR VPWR sky130_fd_sc_hd__fill_1
X_07870_ _02667_ _02668_ VGND VGND VPWR VPWR _02669_ sky130_fd_sc_hd__nand2_2
X_06821_ tanh_inst.z_\[7\] _01667_ _01712_ VGND VGND VPWR VPWR _01713_ sky130_fd_sc_hd__mux2_1
X_09540_ _02053_ _03611_ _04193_ VGND VGND VPWR VPWR _04269_ sky130_fd_sc_hd__o21a_2
X_06752_ _01650_ _01651_ VGND VGND VPWR VPWR _01652_ sky130_fd_sc_hd__xnor2_2
X_09471_ _04200_ _04201_ VGND VGND VPWR VPWR _04202_ sky130_fd_sc_hd__nand2_2
X_05703_ mac_inst.i\[0\] _04789_ _04955_ _04975_ VGND VGND VPWR VPWR _00680_ sky130_fd_sc_hd__or4_2
X_06683_ _01547_ tanh_inst.z_\[7\] _01589_ VGND VGND VPWR VPWR _01590_ sky130_fd_sc_hd__mux2_1
X_08422_ _03177_ _03179_ _03205_ VGND VGND VPWR VPWR _03208_ sky130_fd_sc_hd__nor3_2
XFILLER_0_58_250 VGND VGND VPWR VPWR sky130_fd_sc_hd__fill_2
XFILLER_0_25_82 VGND VGND VPWR VPWR sky130_fd_sc_hd__fill_1
X_05634_ _00612_ _00618_ VGND VGND VPWR VPWR _00619_ sky130_fd_sc_hd__xnor2_2
XTAP_TAPCELL_ROW_63_1051 VGND VPWR sky130_fd_sc_hd__tapvpwrvgnd_1
XFILLER_0_58_294 VGND VGND VPWR VPWR sky130_fd_sc_hd__decap_8
X_08353_ _03139_ _03140_ VGND VGND VPWR VPWR _03141_ sky130_fd_sc_hd__and2_2
X_05565_ _00554_ _00556_ _04795_ _00553_ VGND VGND VPWR VPWR _00557_ sky130_fd_sc_hd__o2bb2a_2
X_08284_ tanh_inst.divider.x\[-4\] _03072_ VGND VGND VPWR VPWR _03074_ sky130_fd_sc_hd__and2_2
X_07304_ tanh_inst.divider.y\[6\] tanh_inst.divider.y\[7\] tanh_inst.LOOKUP.index\[0\]
+ VGND VGND VPWR VPWR _02114_ sky130_fd_sc_hd__mux2_1
X_07235_ tanh_inst.divider.y\[-15\] _02028_ _02029_ VGND VGND VPWR VPWR _02045_ sky130_fd_sc_hd__o21ai_2
Xclkload7 clknet_leaf_43_clk VGND VGND VPWR VPWR clkload7/Y sky130_fd_sc_hd__clkinv_4
X_05496_ _00492_ _00493_ VGND VGND VPWR VPWR _05496_/Y sky130_fd_sc_hd__xnor2_2
XFILLER_0_73_297 VGND VGND VPWR VPWR sky130_fd_sc_hd__decap_6
XFILLER_0_116_399 VPWR VGND VPWR VGND sky130_ef_sc_hd__decap_12
XTAP_TAPCELL_ROW_115_1704 VGND VPWR sky130_fd_sc_hd__tapvpwrvgnd_1
X_07166_ _01088_ _01985_ VGND VGND VPWR VPWR _01986_ sky130_fd_sc_hd__nand2_2
X_06117_ _01044_ tanh_inst.divider.y_\[-24\] VGND VGND VPWR VPWR _01063_ sky130_fd_sc_hd__and2b_2
X_07097_ tanh_inst.divider.y_\[7\] _01923_ VGND VGND VPWR VPWR _01924_ sky130_fd_sc_hd__or2_2
X_06048_ _00979_ _00989_ VGND VGND VPWR VPWR _00999_ sky130_fd_sc_hd__nand2_2
XTAP_TAPCELL_ROW_74_1191 VGND VPWR sky130_fd_sc_hd__tapvpwrvgnd_1
XFILLER_0_5_81 VPWR VGND VPWR VGND sky130_ef_sc_hd__decap_12
X_07999_ _02792_ _02793_ VGND VGND VPWR VPWR _02795_ sky130_fd_sc_hd__xnor2_2
X_09807_ _04527_ _04528_ VGND VGND VPWR VPWR _04529_ sky130_fd_sc_hd__nand2_2
X_09738_ _04408_ _04411_ _04459_ VGND VGND VPWR VPWR _04462_ sky130_fd_sc_hd__or3_2
XTAP_TAPCELL_ROW_45_819 VGND VPWR sky130_fd_sc_hd__tapvpwrvgnd_1
X_09669_ _04335_ _04338_ _04393_ VGND VGND VPWR VPWR _04395_ sky130_fd_sc_hd__or3_2
XTAP_TAPCELL_ROW_25_576 VGND VPWR sky130_fd_sc_hd__tapvpwrvgnd_1
XFILLER_0_107_311 VPWR VGND VPWR VGND sky130_ef_sc_hd__decap_12
XFILLER_0_64_253 VGND VGND VPWR VPWR sky130_fd_sc_hd__decap_4
XFILLER_0_119_193 VGND VGND VPWR VPWR sky130_fd_sc_hd__decap_3
XFILLER_0_107_344 VGND VGND VPWR VPWR sky130_fd_sc_hd__fill_2
XFILLER_0_52_404 VGND VGND VPWR VPWR sky130_fd_sc_hd__decap_3
XFILLER_0_33_640 VGND VGND VPWR VPWR sky130_fd_sc_hd__decap_3
X_10444_ clknet_leaf_9_clk _00301_ VGND VGND VPWR VPWR tanh_inst.divider.y\[-20\]
+ sky130_fd_sc_hd__dfxtp_2
XFILLER_0_33_673 VGND VGND VPWR VPWR sky130_fd_sc_hd__decap_6
XFILLER_0_103_561 VGND VGND VPWR VPWR sky130_fd_sc_hd__decap_6
X_10375_ clknet_leaf_20_clk _00232_ VGND VGND VPWR VPWR tanh_inst.div_en sky130_fd_sc_hd__dfxtp_2
XFILLER_0_20_301 VGND VGND VPWR VPWR sky130_fd_sc_hd__decap_6
XFILLER_0_32_194 VGND VGND VPWR VPWR sky130_fd_sc_hd__fill_2
XFILLER_0_46_15 VPWR VGND VPWR VGND sky130_ef_sc_hd__decap_12
XFILLER_0_1_39 VPWR VGND VPWR VGND sky130_ef_sc_hd__decap_12
XFILLER_0_87_389 VGND VGND VPWR VPWR sky130_fd_sc_hd__decap_3
XFILLER_0_7_317 VPWR VGND VPWR VGND sky130_ef_sc_hd__decap_12
X_05350_ _05001_ _05002_ mac_inst.i\[1\] VGND VGND VPWR VPWR _00358_ sky130_fd_sc_hd__a21oi_2
XPHY_EDGE_ROW_112_Right_112 VGND VGND VPWR VPWR sky130_fd_sc_hd__decap_3
XFILLER_0_83_584 VPWR VGND VPWR VGND sky130_ef_sc_hd__decap_12
XFILLER_0_102_53 VPWR VGND VPWR VGND sky130_ef_sc_hd__decap_12
XFILLER_0_11_51 VGND VGND VPWR VPWR sky130_fd_sc_hd__decap_4
X_05281_ _04944_ _04981_ VGND VGND VPWR VPWR _04982_ sky130_fd_sc_hd__nor2_2
XFILLER_0_102_97 VPWR VGND VPWR VGND sky130_ef_sc_hd__decap_12
X_07020_ _01854_ _01855_ VGND VGND VPWR VPWR _01856_ sky130_fd_sc_hd__nor2_2
XFILLER_0_70_267 VPWR VGND VPWR VGND sky130_ef_sc_hd__decap_12
XFILLER_0_30_109 VGND VGND VPWR VPWR sky130_fd_sc_hd__decap_3
XFILLER_0_87_11 VGND VGND VPWR VPWR sky130_fd_sc_hd__decap_3
XFILLER_0_3_556 VGND VGND VPWR VPWR sky130_fd_sc_hd__decap_4
XPHY_EDGE_ROW_49_Right_49 VGND VGND VPWR VPWR sky130_fd_sc_hd__decap_3
X_08971_ _03713_ _03714_ VGND VGND VPWR VPWR _03715_ sky130_fd_sc_hd__xnor2_2
X_07922_ _02547_ _02719_ _02716_ VGND VGND VPWR VPWR _02720_ sky130_fd_sc_hd__a21oi_2
XTAP_TAPCELL_ROW_110_1634 VGND VPWR sky130_fd_sc_hd__tapvpwrvgnd_1
X_07853_ _02018_ _02652_ VGND VGND VPWR VPWR _02653_ sky130_fd_sc_hd__nand2_2
X_06804_ tanh_inst.z_\[7\] _01667_ _01697_ VGND VGND VPWR VPWR _01698_ sky130_fd_sc_hd__mux2_1
X_07784_ _02579_ _02584_ VGND VGND VPWR VPWR _02585_ sky130_fd_sc_hd__nor2_2
XPHY_EDGE_ROW_58_Right_58 VGND VGND VPWR VPWR sky130_fd_sc_hd__decap_3
X_09523_ _04200_ _04201_ _04178_ VGND VGND VPWR VPWR _04253_ sky130_fd_sc_hd__o21ai_2
X_06735_ _01502_ _01635_ _01636_ _01469_ mac_y_out[13] VGND VGND VPWR VPWR _00141_
+ sky130_fd_sc_hd__a32o_2
X_09454_ _02809_ _04173_ VGND VGND VPWR VPWR _04186_ sky130_fd_sc_hd__xor2_2
X_06666_ tanh_inst.z_\[-18\] _01573_ VGND VGND VPWR VPWR _01575_ sky130_fd_sc_hd__or2_2
XFILLER_0_93_315 VGND VGND VPWR VPWR sky130_fd_sc_hd__decap_4
X_09385_ _04116_ _04118_ VGND VGND VPWR VPWR _04119_ sky130_fd_sc_hd__xnor2_2
X_08405_ _03190_ _03191_ VGND VGND VPWR VPWR _03192_ sky130_fd_sc_hd__xnor2_2
X_05617_ mac_inst.y\[24\] _00602_ VGND VGND VPWR VPWR _00604_ sky130_fd_sc_hd__nor2_2
XTAP_TAPCELL_ROW_121_1785 VGND VPWR sky130_fd_sc_hd__tapvpwrvgnd_1
XTAP_TAPCELL_ROW_121_1774 VGND VPWR sky130_fd_sc_hd__tapvpwrvgnd_1
XFILLER_0_93_359 VGND VGND VPWR VPWR sky130_fd_sc_hd__decap_4
X_06597_ _01502_ _01509_ _01510_ _01469_ mac_y_out[1] VGND VGND VPWR VPWR _00129_
+ sky130_fd_sc_hd__a32o_2
X_08336_ _03122_ _03123_ VGND VGND VPWR VPWR _03124_ sky130_fd_sc_hd__and2_2
XTAP_TAPCELL_ROW_22_535 VGND VPWR sky130_fd_sc_hd__tapvpwrvgnd_1
X_05548_ _00522_ _00531_ VGND VGND VPWR VPWR _00541_ sky130_fd_sc_hd__nor2_2
XFILLER_0_117_664 VGND VGND VPWR VPWR sky130_fd_sc_hd__fill_1
XFILLER_0_116_141 VGND VGND VPWR VPWR sky130_fd_sc_hd__decap_8
X_05479_ _04782_ _04901_ _00374_ mac_inst.i\[3\] VGND VGND VPWR VPWR _00478_ sky130_fd_sc_hd__a211o_2
X_08267_ _03048_ _03055_ VGND VGND VPWR VPWR _03057_ sky130_fd_sc_hd__xnor2_2
XTAP_TAPCELL_ROW_50_888 VGND VPWR sky130_fd_sc_hd__tapvpwrvgnd_1
X_07218_ _04757_ _02020_ VGND VGND VPWR VPWR _02028_ sky130_fd_sc_hd__and2_2
XPHY_EDGE_ROW_67_Right_67 VGND VGND VPWR VPWR sky130_fd_sc_hd__decap_3
XFILLER_0_61_278 VGND VGND VPWR VPWR sky130_fd_sc_hd__fill_2
X_08198_ tanh_inst.divider.x\[-6\] _02989_ VGND VGND VPWR VPWR _02990_ sky130_fd_sc_hd__nand2_2
X_07149_ _01955_ _01970_ _01969_ _01961_ VGND VGND VPWR VPWR _01971_ sky130_fd_sc_hd__o211a_2
X_10091_ clknet_leaf_5_clk _00108_ VGND VGND VPWR VPWR tanh_inst.divider.y_\[-2\]
+ sky130_fd_sc_hd__dfxtp_2
XPHY_EDGE_ROW_76_Right_76 VGND VGND VPWR VPWR sky130_fd_sc_hd__decap_3
XFILLER_0_69_312 VGND VGND VPWR VPWR sky130_fd_sc_hd__fill_1
XFILLER_0_16_29 VPWR VGND VPWR VGND sky130_ef_sc_hd__decap_12
XTAP_TAPCELL_ROW_58_988 VGND VPWR sky130_fd_sc_hd__tapvpwrvgnd_1
XTAP_TAPCELL_ROW_2_282 VGND VPWR sky130_fd_sc_hd__tapvpwrvgnd_1
XFILLER_0_84_304 VGND VGND VPWR VPWR sky130_fd_sc_hd__decap_4
XTAP_TAPCELL_ROW_2_293 VGND VPWR sky130_fd_sc_hd__tapvpwrvgnd_1
XFILLER_0_96_197 VGND VGND VPWR VPWR sky130_fd_sc_hd__fill_2
XFILLER_0_84_337 VGND VGND VPWR VPWR sky130_fd_sc_hd__fill_1
XFILLER_0_108_631 VGND VGND VPWR VPWR sky130_fd_sc_hd__decap_8
XPHY_EDGE_ROW_85_Right_85 VGND VGND VPWR VPWR sky130_fd_sc_hd__decap_3
XFILLER_0_4_309 VPWR VGND VPWR VGND sky130_ef_sc_hd__decap_12
XFILLER_0_108_697 VGND VGND VPWR VPWR sky130_fd_sc_hd__decap_3
XFILLER_0_80_576 VGND VGND VPWR VPWR sky130_fd_sc_hd__fill_2
XFILLER_0_12_109 VPWR VGND VPWR VGND sky130_ef_sc_hd__decap_12
XFILLER_0_21_610 VGND VGND VPWR VPWR sky130_fd_sc_hd__decap_6
XFILLER_0_21_621 VGND VGND VPWR VPWR sky130_fd_sc_hd__fill_1
X_10427_ clknet_leaf_40_clk _00284_ _00000_ VGND VGND VPWR VPWR mac_inst.i\[19\] sky130_fd_sc_hd__dfrtp_2
XFILLER_0_110_306 VGND VGND VPWR VPWR sky130_fd_sc_hd__fill_2
X_10358_ clknet_leaf_18_clk _00215_ VGND VGND VPWR VPWR tanh_inst.divider.z_\[-6\]
+ sky130_fd_sc_hd__dfxtp_2
XFILLER_0_0_559 VGND VGND VPWR VPWR sky130_fd_sc_hd__fill_1
XFILLER_0_20_153 VPWR VGND VPWR VGND sky130_ef_sc_hd__decap_12
XFILLER_0_21_698 VGND VGND VPWR VPWR sky130_fd_sc_hd__decap_4
XFILLER_0_20_197 VPWR VGND VPWR VGND sky130_ef_sc_hd__decap_12
X_10289_ clknet_leaf_27_clk _00146_ VGND VGND VPWR VPWR tanh_inst.z_\[-6\] sky130_fd_sc_hd__dfxtp_2
XPHY_EDGE_ROW_94_Right_94 VGND VGND VPWR VPWR sky130_fd_sc_hd__decap_3
XFILLER_0_88_643 VGND VGND VPWR VPWR sky130_fd_sc_hd__fill_1
XFILLER_0_87_120 VPWR VGND VPWR VGND sky130_ef_sc_hd__decap_12
X_06520_ _01433_ _01438_ _01089_ VGND VGND VPWR VPWR _01439_ sky130_fd_sc_hd__a21oi_2
X_06451_ _01089_ _01375_ VGND VGND VPWR VPWR _01376_ sky130_fd_sc_hd__nor2_2
XFILLER_0_75_337 VPWR VGND VPWR VGND sky130_ef_sc_hd__decap_12
XTAP_TAPCELL_ROW_60_1010 VGND VPWR sky130_fd_sc_hd__tapvpwrvgnd_1
X_05402_ mac_inst.y\[6\] _00405_ VGND VGND VPWR VPWR _00407_ sky130_fd_sc_hd__or2_2
X_06382_ _01310_ _01311_ VGND VGND VPWR VPWR _01312_ sky130_fd_sc_hd__xnor2_2
X_09170_ _03893_ _03909_ _02015_ VGND VGND VPWR VPWR _03910_ sky130_fd_sc_hd__a21o_2
XFILLER_0_56_584 VGND VGND VPWR VPWR sky130_fd_sc_hd__decap_4
XFILLER_0_7_125 VPWR VGND VPWR VGND sky130_ef_sc_hd__decap_12
XFILLER_0_16_404 VGND VGND VPWR VPWR sky130_fd_sc_hd__fill_1
XFILLER_0_28_253 VGND VGND VPWR VPWR sky130_fd_sc_hd__decap_4
XFILLER_0_7_169 VPWR VGND VPWR VGND sky130_ef_sc_hd__decap_12
XFILLER_0_16_459 VGND VGND VPWR VPWR sky130_fd_sc_hd__decap_3
XFILLER_0_22_83 VGND VGND VPWR VPWR sky130_fd_sc_hd__fill_1
X_05333_ _05030_ _05031_ VGND VGND VPWR VPWR _00342_ sky130_fd_sc_hd__xnor2_2
XFILLER_0_43_223 VGND VGND VPWR VPWR sky130_fd_sc_hd__fill_1
X_08121_ _02912_ _02914_ VGND VGND VPWR VPWR _02915_ sky130_fd_sc_hd__xnor2_2
XFILLER_0_114_645 VGND VGND VPWR VPWR sky130_fd_sc_hd__fill_1
XFILLER_0_113_111 VGND VGND VPWR VPWR sky130_fd_sc_hd__fill_1
X_08052_ _02845_ _02846_ VGND VGND VPWR VPWR _02847_ sky130_fd_sc_hd__xnor2_2
XFILLER_0_71_554 VGND VGND VPWR VPWR sky130_fd_sc_hd__decap_6
X_05264_ mac_inst.i\[7\] mac_inst.i\[6\] mac_inst.i\[9\] mac_inst.i\[8\] VGND VGND
+ VPWR VPWR _04965_ sky130_fd_sc_hd__nand4_2
X_07003_ _01832_ _01838_ tanh_inst.divider.z_\[-16\] VGND VGND VPWR VPWR _01841_ sky130_fd_sc_hd__a21o_2
XFILLER_0_113_155 VGND VGND VPWR VPWR sky130_fd_sc_hd__decap_3
XFILLER_0_98_65 VPWR VGND VPWR VGND sky130_ef_sc_hd__decap_12
XFILLER_0_12_610 VGND VGND VPWR VPWR sky130_fd_sc_hd__decap_3
XFILLER_0_114_689 VGND VGND VPWR VPWR sky130_fd_sc_hd__fill_1
XFILLER_0_12_632 VGND VGND VPWR VPWR sky130_fd_sc_hd__fill_2
X_05195_ mac_inst.x\[14\] _04852_ _04853_ VGND VGND VPWR VPWR _04899_ sky130_fd_sc_hd__a21oi_2
XFILLER_0_113_199 VGND VGND VPWR VPWR sky130_fd_sc_hd__fill_1
X_08954_ _04791_ _03691_ _03692_ _03697_ _02019_ VGND VGND VPWR VPWR _03698_ sky130_fd_sc_hd__o311a_2
XFILLER_0_51_3 VGND VGND VPWR VPWR sky130_fd_sc_hd__decap_4
X_07905_ _02620_ _02664_ VGND VGND VPWR VPWR _02703_ sky130_fd_sc_hd__and2_2
XTAP_TAPCELL_ROW_71_1150 VGND VPWR sky130_fd_sc_hd__tapvpwrvgnd_1
XFILLER_0_47_80 VGND VGND VPWR VPWR sky130_fd_sc_hd__decap_3
X_08885_ tanh_inst.divider.x\[-7\] tanh_inst.divider.x\[-6\] tanh_inst.divider.x\[-5\]
+ tanh_inst.divider.x\[-4\] tanh_inst.LOOKUP.index\[0\] tanh_inst.LOOKUP.index\[1\]
+ VGND VGND VPWR VPWR _03630_ sky130_fd_sc_hd__mux4_2
XFILLER_0_98_407 VPWR VGND VPWR VGND sky130_ef_sc_hd__decap_12
X_07836_ _02561_ _02587_ _02635_ VGND VGND VPWR VPWR _02636_ sky130_fd_sc_hd__a21oi_2
XFILLER_0_79_632 VGND VGND VPWR VPWR sky130_fd_sc_hd__fill_1
X_07767_ _02567_ _02568_ VGND VGND VPWR VPWR _02569_ sky130_fd_sc_hd__xnor2_2
XTAP_TAPCELL_ROW_27_605 VGND VPWR sky130_fd_sc_hd__tapvpwrvgnd_1
XFILLER_0_78_153 VGND VGND VPWR VPWR sky130_fd_sc_hd__decap_8
X_09506_ _04223_ _04227_ _04234_ VGND VGND VPWR VPWR _04236_ sky130_fd_sc_hd__a21oi_2
X_06718_ tanh_inst.z_\[7\] _01532_ VGND VGND VPWR VPWR _01621_ sky130_fd_sc_hd__nor2_2
XTAP_TAPCELL_ROW_55_947 VGND VPWR sky130_fd_sc_hd__tapvpwrvgnd_1
X_07698_ _02499_ _02500_ VGND VGND VPWR VPWR _02501_ sky130_fd_sc_hd__nand2_2
XFILLER_0_93_101 VGND VGND VPWR VPWR sky130_fd_sc_hd__fill_2
XFILLER_0_78_197 VGND VGND VPWR VPWR sky130_fd_sc_hd__decap_6
XFILLER_0_93_123 VGND VGND VPWR VPWR sky130_fd_sc_hd__fill_1
X_06649_ _01558_ _01559_ VGND VGND VPWR VPWR _01560_ sky130_fd_sc_hd__nor2_2
X_09437_ _04127_ _04168_ _04154_ VGND VGND VPWR VPWR _04169_ sky130_fd_sc_hd__a21oi_2
XFILLER_0_66_348 VGND VGND VPWR VPWR sky130_fd_sc_hd__fill_1
X_09368_ _04100_ _04101_ VGND VGND VPWR VPWR _04102_ sky130_fd_sc_hd__nor2_2
XFILLER_0_93_167 VGND VGND VPWR VPWR sky130_fd_sc_hd__fill_1
XTAP_TAPCELL_ROW_82_1290 VGND VPWR sky130_fd_sc_hd__tapvpwrvgnd_1
XFILLER_0_34_201 VGND VGND VPWR VPWR sky130_fd_sc_hd__fill_1
X_09299_ _02630_ _02631_ _04021_ VGND VGND VPWR VPWR _04035_ sky130_fd_sc_hd__nand3_2
XFILLER_0_34_223 VGND VGND VPWR VPWR sky130_fd_sc_hd__fill_2
X_08319_ tanh_inst.LOOKUP.index\[4\] _02419_ _02859_ VGND VGND VPWR VPWR _03108_ sky130_fd_sc_hd__o21a_2
XFILLER_0_62_587 VGND VGND VPWR VPWR sky130_fd_sc_hd__fill_1
X_10212_ clknet_leaf_22_clk mac_inst.y\[6\] _00000_ VGND VGND VPWR VPWR mac_y_out[6]
+ sky130_fd_sc_hd__dfrtp_2
XTAP_TAPCELL_ROW_7_352 VGND VPWR sky130_fd_sc_hd__tapvpwrvgnd_1
X_10074_ clknet_leaf_14_clk _00091_ VGND VGND VPWR VPWR tanh_inst.divider.y_\[-19\]
+ sky130_fd_sc_hd__dfxtp_2
XFILLER_0_27_39 VPWR VGND VPWR VGND sky130_ef_sc_hd__decap_12
XTAP_TAPCELL_ROW_85_1319 VGND VPWR sky130_fd_sc_hd__tapvpwrvgnd_1
XFILLER_0_43_16 VPWR VGND VPWR VGND sky130_ef_sc_hd__decap_12
XFILLER_0_84_112 VPWR VGND VPWR VGND sky130_ef_sc_hd__decap_12
XFILLER_0_57_337 VPWR VGND VPWR VGND sky130_ef_sc_hd__decap_12
XFILLER_0_26_713 VGND VGND VPWR VPWR sky130_fd_sc_hd__decap_8
XFILLER_0_25_223 VGND VGND VPWR VPWR sky130_fd_sc_hd__fill_1
XFILLER_0_53_521 VGND VGND VPWR VPWR sky130_fd_sc_hd__fill_1
XFILLER_0_4_139 VGND VGND VPWR VPWR sky130_fd_sc_hd__fill_1
XTAP_TAPCELL_ROW_96_1459 VGND VPWR sky130_fd_sc_hd__tapvpwrvgnd_1
XFILLER_0_80_373 VGND VGND VPWR VPWR sky130_fd_sc_hd__fill_1
XFILLER_0_7_27 VPWR VGND VPWR VGND sky130_ef_sc_hd__decap_12
XFILLER_0_111_615 VGND VGND VPWR VPWR sky130_fd_sc_hd__fill_1
XFILLER_0_0_389 VGND VGND VPWR VPWR sky130_fd_sc_hd__decap_3
X_05951_ _00888_ _00904_ _00909_ _00893_ VGND VGND VPWR VPWR _00910_ sky130_fd_sc_hd__o2bb2a_2
XFILLER_0_108_41 VPWR VGND VPWR VGND sky130_ef_sc_hd__decap_12
X_08670_ _03448_ _03449_ VGND VGND VPWR VPWR _03450_ sky130_fd_sc_hd__xor2_2
X_05882_ _00844_ _00845_ VGND VGND VPWR VPWR _05882_/Y sky130_fd_sc_hd__xnor2_2
XFILLER_0_108_85 VPWR VGND VPWR VGND sky130_ef_sc_hd__decap_12
X_07621_ _02423_ _02425_ VGND VGND VPWR VPWR _02426_ sky130_fd_sc_hd__xnor2_2
X_07552_ _02301_ _02302_ _02299_ VGND VGND VPWR VPWR _02358_ sky130_fd_sc_hd__o21a_2
X_06503_ _04793_ _01422_ VGND VGND VPWR VPWR _01423_ sky130_fd_sc_hd__nand2_2
XFILLER_0_76_635 VGND VGND VPWR VPWR sky130_fd_sc_hd__fill_2
XTAP_TAPCELL_ROW_52_917 VGND VPWR sky130_fd_sc_hd__tapvpwrvgnd_1
XTAP_TAPCELL_ROW_52_906 VGND VPWR sky130_fd_sc_hd__tapvpwrvgnd_1
XTAP_TAPCELL_ROW_105_1577 VGND VPWR sky130_fd_sc_hd__tapvpwrvgnd_1
X_07483_ tanh_inst.divider.x\[-21\] _02288_ VGND VGND VPWR VPWR _02290_ sky130_fd_sc_hd__xor2_2
X_06434_ _04793_ _01358_ _01357_ VGND VGND VPWR VPWR _01360_ sky130_fd_sc_hd__a21oi_2
X_09222_ tanh_inst.divider.x\[-16\] _03958_ VGND VGND VPWR VPWR _03960_ sky130_fd_sc_hd__and2_2
XFILLER_0_17_702 VGND VGND VPWR VPWR sky130_fd_sc_hd__fill_1
X_06365_ _01295_ _01296_ VGND VGND VPWR VPWR _01297_ sky130_fd_sc_hd__xnor2_2
XFILLER_0_99_3 VPWR VGND VPWR VGND sky130_ef_sc_hd__decap_12
X_09153_ tanh_inst.z_\[7\] _03885_ _03886_ _03892_ _02018_ VGND VGND VPWR VPWR _03893_
+ sky130_fd_sc_hd__a311o_2
XTAP_TAPCELL_ROW_32_663 VGND VPWR sky130_fd_sc_hd__tapvpwrvgnd_1
X_08104_ _02812_ _02854_ VGND VGND VPWR VPWR _02898_ sky130_fd_sc_hd__nor2_2
XFILLER_0_16_245 VGND VGND VPWR VPWR sky130_fd_sc_hd__decap_6
X_05316_ _05013_ _05014_ mac_inst.i\[2\] VGND VGND VPWR VPWR _05015_ sky130_fd_sc_hd__mux2_1
XFILLER_0_44_543 VGND VGND VPWR VPWR sky130_fd_sc_hd__decap_3
X_06296_ tanh_inst.divider.y_\[-14\] _01232_ VGND VGND VPWR VPWR _01233_ sky130_fd_sc_hd__xor2_2
X_09084_ _03807_ _03825_ _02014_ VGND VGND VPWR VPWR _03826_ sky130_fd_sc_hd__o21ai_2
XFILLER_0_71_362 VGND VGND VPWR VPWR sky130_fd_sc_hd__fill_2
XFILLER_0_16_289 VPWR VGND VPWR VGND sky130_ef_sc_hd__decap_12
XFILLER_0_114_475 VGND VGND VPWR VPWR sky130_fd_sc_hd__fill_1
X_08035_ _02018_ _02817_ VGND VGND VPWR VPWR _02831_ sky130_fd_sc_hd__nor2_2
XFILLER_0_3_161 VGND VGND VPWR VPWR sky130_fd_sc_hd__decap_6
X_05247_ _04787_ mac_inst.i\[30\] mac_inst.i\[28\] mac_inst.i\[27\] mac_inst.i\[26\]
+ VGND VGND VPWR VPWR _04948_ sky130_fd_sc_hd__a2111oi_2
XFILLER_0_31_259 VGND VGND VPWR VPWR sky130_fd_sc_hd__fill_2
X_05178_ _04873_ _04881_ mac_inst.i\[2\] VGND VGND VPWR VPWR _04882_ sky130_fd_sc_hd__mux2_1
XFILLER_0_101_169 VGND VGND VPWR VPWR sky130_fd_sc_hd__decap_4
XFILLER_0_110_670 VGND VGND VPWR VPWR sky130_fd_sc_hd__decap_4
X_09986_ _04699_ _04700_ _04701_ _04702_ _02019_ VGND VGND VPWR VPWR _04703_ sky130_fd_sc_hd__a311oi_2
X_08937_ _03679_ _03680_ _02025_ VGND VGND VPWR VPWR _03681_ sky130_fd_sc_hd__mux2_1
XTAP_TAPCELL_ROW_4_311 VGND VPWR sky130_fd_sc_hd__tapvpwrvgnd_1
X_08868_ _02022_ _03609_ _03610_ _02053_ VGND VGND VPWR VPWR _03613_ sky130_fd_sc_hd__o211ai_2
X_07819_ _02618_ _02617_ VGND VGND VPWR VPWR _02619_ sky130_fd_sc_hd__and2b_2
XFILLER_0_98_215 VGND VGND VPWR VPWR sky130_fd_sc_hd__fill_2
X_08799_ tanh_inst.divider.x\[1\] _02028_ _03508_ VGND VGND VPWR VPWR _03545_ sky130_fd_sc_hd__o21a_2
XFILLER_0_94_421 VGND VGND VPWR VPWR sky130_fd_sc_hd__decap_6
XFILLER_0_67_613 VGND VGND VPWR VPWR sky130_fd_sc_hd__decap_3
XFILLER_0_39_315 VGND VGND VPWR VPWR sky130_fd_sc_hd__decap_3
XFILLER_0_67_646 VGND VGND VPWR VPWR sky130_fd_sc_hd__decap_8
XFILLER_0_39_337 VGND VGND VPWR VPWR sky130_fd_sc_hd__fill_2
XFILLER_0_109_236 VGND VGND VPWR VPWR sky130_fd_sc_hd__decap_3
XFILLER_0_54_307 VGND VGND VPWR VPWR sky130_fd_sc_hd__fill_1
XFILLER_0_54_329 VGND VGND VPWR VPWR sky130_fd_sc_hd__decap_6
XFILLER_0_35_532 VGND VGND VPWR VPWR sky130_fd_sc_hd__decap_8
XFILLER_0_105_420 VGND VGND VPWR VPWR sky130_fd_sc_hd__fill_2
XFILLER_0_90_671 VPWR VGND VPWR VGND sky130_ef_sc_hd__decap_12
XFILLER_0_50_524 VGND VGND VPWR VPWR sky130_fd_sc_hd__decap_8
XFILLER_0_105_475 VPWR VGND VPWR VGND sky130_ef_sc_hd__decap_12
XFILLER_0_120_456 VGND VGND VPWR VPWR sky130_fd_sc_hd__decap_3
XFILLER_0_101_670 VGND VGND VPWR VPWR sky130_fd_sc_hd__fill_2
X_10057_ rst VGND VGND VPWR VPWR _00076_ sky130_fd_sc_hd__inv_2
XFILLER_0_89_248 VGND VGND VPWR VPWR sky130_fd_sc_hd__decap_6
XFILLER_0_85_465 VGND VGND VPWR VPWR sky130_fd_sc_hd__fill_1
XFILLER_0_108_280 VGND VGND VPWR VPWR sky130_fd_sc_hd__fill_1
X_06150_ _01093_ _01094_ tanh_inst.divider.i\[2\] VGND VGND VPWR VPWR _01095_ sky130_fd_sc_hd__mux2_1
XFILLER_0_81_671 VGND VGND VPWR VPWR sky130_fd_sc_hd__fill_1
XFILLER_0_110_53 VPWR VGND VPWR VGND sky130_ef_sc_hd__decap_12
X_06081_ tanh_inst.divider.x\[-20\] tanh_inst.divider.x\[-19\] tanh_inst.divider.x\[-18\]
+ tanh_inst.divider.x\[-17\] tanh_inst.divider.i\[0\] tanh_inst.divider.i\[1\] VGND
+ VGND VPWR VPWR _01028_ sky130_fd_sc_hd__mux4_2
XFILLER_0_13_237 VPWR VGND VPWR VGND sky130_ef_sc_hd__decap_12
X_05101_ _04804_ _00000_ _04816_ VGND VGND VPWR VPWR _00335_ sky130_fd_sc_hd__and3b_2
XFILLER_0_1_610 VGND VGND VPWR VPWR sky130_fd_sc_hd__decap_3
XFILLER_0_111_478 VGND VGND VPWR VPWR sky130_fd_sc_hd__fill_2
XFILLER_0_111_467 VGND VGND VPWR VPWR sky130_fd_sc_hd__fill_2
XFILLER_0_111_456 VGND VGND VPWR VPWR sky130_fd_sc_hd__decap_4
XFILLER_0_110_97 VPWR VGND VPWR VGND sky130_ef_sc_hd__decap_12
XFILLER_0_0_153 VPWR VGND VPWR VGND sky130_ef_sc_hd__decap_12
XFILLER_0_1_676 VGND VGND VPWR VPWR sky130_fd_sc_hd__decap_3
XFILLER_0_21_281 VPWR VGND VPWR VGND sky130_ef_sc_hd__decap_12
XFILLER_0_95_55 VGND VGND VPWR VPWR sky130_fd_sc_hd__fill_1
XFILLER_0_0_197 VPWR VGND VPWR VGND sky130_ef_sc_hd__decap_12
X_09840_ _04525_ _04529_ _04523_ VGND VGND VPWR VPWR _04561_ sky130_fd_sc_hd__a21bo_2
XFILLER_0_119_51 VGND VGND VPWR VPWR sky130_fd_sc_hd__decap_4
X_06983_ tanh_inst.divider.z_\[-18\] _01820_ VGND VGND VPWR VPWR _01823_ sky130_fd_sc_hd__or2_2
X_09771_ _04363_ _04364_ _04426_ _04436_ _04791_ VGND VGND VPWR VPWR _04494_ sky130_fd_sc_hd__o41a_2
X_05934_ _00889_ _00891_ mac_inst.z\[19\] VGND VGND VPWR VPWR _00894_ sky130_fd_sc_hd__a21bo_2
X_08722_ mac_inst.i\[8\] _00958_ VGND VGND VPWR VPWR _00273_ sky130_fd_sc_hd__xor2_2
XFILLER_0_96_719 VGND VGND VPWR VPWR sky130_fd_sc_hd__decap_4
X_08653_ _03430_ _03431_ _03432_ _02019_ VGND VGND VPWR VPWR _03434_ sky130_fd_sc_hd__a31o_2
XFILLER_0_14_3 VPWR VGND VPWR VGND sky130_ef_sc_hd__decap_12
X_05865_ _00828_ _00829_ VGND VGND VPWR VPWR _00830_ sky130_fd_sc_hd__and2_2
XTAP_TAPCELL_ROW_37_722 VGND VPWR sky130_fd_sc_hd__tapvpwrvgnd_1
X_07604_ _02392_ _02408_ VGND VGND VPWR VPWR _02409_ sky130_fd_sc_hd__nand2_2
XFILLER_0_88_270 VGND VGND VPWR VPWR sky130_fd_sc_hd__fill_1
X_08584_ _03364_ _03365_ VGND VGND VPWR VPWR _03366_ sky130_fd_sc_hd__nor2_2
X_05796_ mac_inst.z\[9\] _00763_ VGND VGND VPWR VPWR _00766_ sky130_fd_sc_hd__nor2_2
XFILLER_0_76_421 VGND VGND VPWR VPWR sky130_fd_sc_hd__decap_6
X_07535_ _02022_ _02338_ _02339_ _02340_ _02053_ VGND VGND VPWR VPWR _02341_ sky130_fd_sc_hd__a221o_2
X_07466_ _02271_ _02272_ _02025_ VGND VGND VPWR VPWR _02273_ sky130_fd_sc_hd__mux2_1
XTAP_TAPCELL_ROW_66_1093 VGND VPWR sky130_fd_sc_hd__tapvpwrvgnd_1
XTAP_TAPCELL_ROW_66_1082 VGND VPWR sky130_fd_sc_hd__tapvpwrvgnd_1
X_06417_ _01342_ _01343_ VGND VGND VPWR VPWR _01344_ sky130_fd_sc_hd__xor2_2
X_09205_ _03941_ _03943_ VGND VGND VPWR VPWR _03944_ sky130_fd_sc_hd__nand2_2
XFILLER_0_8_253 VPWR VGND VPWR VGND sky130_ef_sc_hd__decap_12
XFILLER_0_29_381 VGND VGND VPWR VPWR sky130_fd_sc_hd__decap_4
XFILLER_0_91_457 VGND VGND VPWR VPWR sky130_fd_sc_hd__fill_1
X_07397_ _02035_ _02041_ _02043_ _02037_ _04760_ _04761_ VGND VGND VPWR VPWR _02205_
+ sky130_fd_sc_hd__mux4_2
XFILLER_0_44_351 VPWR VGND VPWR VGND sky130_ef_sc_hd__decap_12
XTAP_TAPCELL_ROW_118_1735 VGND VPWR sky130_fd_sc_hd__tapvpwrvgnd_1
X_06348_ _01279_ _01280_ VGND VGND VPWR VPWR _01281_ sky130_fd_sc_hd__xor2_2
X_09136_ _02052_ _03875_ _03872_ VGND VGND VPWR VPWR _03876_ sky130_fd_sc_hd__o21a_2
XFILLER_0_17_598 VGND VGND VPWR VPWR sky130_fd_sc_hd__decap_8
XFILLER_0_121_209 VPWR VGND VPWR VGND sky130_ef_sc_hd__decap_12
X_06279_ _01039_ _01066_ _01216_ VGND VGND VPWR VPWR _01217_ sky130_fd_sc_hd__o21a_2
XFILLER_0_71_181 VGND VGND VPWR VPWR sky130_fd_sc_hd__decap_6
X_09067_ tanh_inst.LOOKUP.index\[2\] _03654_ _03760_ VGND VGND VPWR VPWR _03809_ sky130_fd_sc_hd__o21a_2
X_08018_ _02730_ _02813_ _02767_ VGND VGND VPWR VPWR _02814_ sky130_fd_sc_hd__a21o_2
XFILLER_0_32_579 VGND VGND VPWR VPWR sky130_fd_sc_hd__decap_3
X_09969_ tanh_inst.divider.y\[5\] _04678_ VGND VGND VPWR VPWR _04686_ sky130_fd_sc_hd__xnor2_2
XFILLER_0_24_29 VPWR VGND VPWR VGND sky130_ef_sc_hd__decap_12
XFILLER_0_79_281 VPWR VGND VPWR VGND sky130_ef_sc_hd__decap_12
XFILLER_0_94_262 VPWR VGND VPWR VGND sky130_ef_sc_hd__decap_12
XTAP_TAPCELL_ROW_15_449 VGND VPWR sky130_fd_sc_hd__tapvpwrvgnd_1
XFILLER_0_23_557 VGND VGND VPWR VPWR sky130_fd_sc_hd__decap_3
XTAP_TAPCELL_ROW_93_1429 VGND VPWR sky130_fd_sc_hd__tapvpwrvgnd_1
XFILLER_0_23_579 VGND VGND VPWR VPWR sky130_fd_sc_hd__decap_4
XFILLER_0_49_15 VGND VGND VPWR VPWR sky130_fd_sc_hd__fill_1
XFILLER_0_120_253 VPWR VGND VPWR VGND sky130_ef_sc_hd__decap_12
X_10109_ clknet_leaf_33_clk _00126_ _00076_ VGND VGND VPWR VPWR mac_complete sky130_fd_sc_hd__dfrtp_2
X_05650_ _04911_ _00479_ _00509_ VGND VGND VPWR VPWR _00633_ sky130_fd_sc_hd__a21o_2
X_05581_ _00524_ _00555_ _00561_ mac_inst.z\[31\] VGND VGND VPWR VPWR _00571_ sky130_fd_sc_hd__a31o_2
XTAP_TAPCELL_ROW_102_1536 VGND VPWR sky130_fd_sc_hd__tapvpwrvgnd_1
X_07320_ tanh_inst.divider.y\[6\] _02028_ _02029_ tanh_inst.LOOKUP.index\[0\] VGND
+ VGND VPWR VPWR _02129_ sky130_fd_sc_hd__o211a_2
XFILLER_0_18_307 VGND VGND VPWR VPWR sky130_fd_sc_hd__fill_1
XFILLER_0_85_273 VGND VGND VPWR VPWR sky130_fd_sc_hd__decap_6
X_07251_ tanh_inst.divider.y\[-24\] tanh_inst.divider.y\[-23\] tanh_inst.LOOKUP.index\[0\]
+ VGND VGND VPWR VPWR _02061_ sky130_fd_sc_hd__mux2_1
XTAP_TAPCELL_ROW_42_791 VGND VPWR sky130_fd_sc_hd__tapvpwrvgnd_1
XFILLER_0_121_41 VPWR VGND VPWR VGND sky130_ef_sc_hd__decap_12
X_07182_ tanh_inst.divider.z_\[5\] _01975_ VGND VGND VPWR VPWR _01999_ sky130_fd_sc_hd__and2_2
X_06202_ _01040_ _01141_ _01142_ _01028_ _01144_ VGND VGND VPWR VPWR _01145_ sky130_fd_sc_hd__o221a_2
XFILLER_0_5_223 VGND VGND VPWR VPWR sky130_fd_sc_hd__fill_1
XFILLER_0_121_85 VPWR VGND VPWR VGND sky130_ef_sc_hd__decap_12
X_06133_ tanh_inst.divider.x\[-15\] tanh_inst.divider.x\[-14\] tanh_inst.divider.x\[-13\]
+ tanh_inst.divider.x\[-12\] tanh_inst.divider.i\[0\] tanh_inst.divider.i\[1\] VGND
+ VGND VPWR VPWR _01079_ sky130_fd_sc_hd__mux4_2
XFILLER_0_14_557 VGND VGND VPWR VPWR sky130_fd_sc_hd__decap_3
XFILLER_0_30_83 VGND VGND VPWR VPWR sky130_fd_sc_hd__fill_1
X_06064_ _01011_ _01012_ VGND VGND VPWR VPWR _01013_ sky130_fd_sc_hd__nand2_2
XTAP_TAPCELL_ROW_113_1676 VGND VPWR sky130_fd_sc_hd__tapvpwrvgnd_1
XFILLER_0_111_297 VGND VGND VPWR VPWR sky130_fd_sc_hd__decap_4
X_09823_ tanh_inst.divider.y\[0\] _02014_ VGND VGND VPWR VPWR _04545_ sky130_fd_sc_hd__or2_2
X_06966_ tanh_inst.divider.z_\[-20\] _01092_ _01807_ _01088_ VGND VGND VPWR VPWR _00201_
+ sky130_fd_sc_hd__a22o_2
X_09754_ _04448_ _04452_ _04476_ VGND VGND VPWR VPWR _04477_ sky130_fd_sc_hd__a21oi_2
X_06897_ tanh_inst.div_en tanh_inst.divider.z_\[-21\] VGND VGND VPWR VPWR _00168_
+ sky130_fd_sc_hd__and2b_2
XTAP_TAPCELL_ROW_68_1111 VGND VPWR sky130_fd_sc_hd__tapvpwrvgnd_1
X_08705_ _03482_ _03483_ VGND VGND VPWR VPWR _03484_ sky130_fd_sc_hd__xnor2_2
X_05917_ _00877_ VGND VGND VPWR VPWR _00878_ sky130_fd_sc_hd__inv_2
X_09685_ _04408_ _04409_ VGND VGND VPWR VPWR _04410_ sky130_fd_sc_hd__or2_2
X_08636_ tanh_inst.divider.x\[5\] _03404_ VGND VGND VPWR VPWR _03417_ sky130_fd_sc_hd__xnor2_2
X_05848_ mac_inst.z\[31\] _00797_ _00813_ VGND VGND VPWR VPWR _00814_ sky130_fd_sc_hd__o21ai_2
X_05779_ _00729_ _00733_ _00740_ VGND VGND VPWR VPWR _00750_ sky130_fd_sc_hd__and3_2
X_08567_ tanh_inst.divider.x\[3\] _03349_ VGND VGND VPWR VPWR _03350_ sky130_fd_sc_hd__and2b_2
X_07518_ _02123_ _02193_ _02259_ tanh_inst.z_\[7\] VGND VGND VPWR VPWR _02325_ sky130_fd_sc_hd__a31o_2
XTAP_TAPCELL_ROW_12_408 VGND VPWR sky130_fd_sc_hd__tapvpwrvgnd_1
X_08498_ tanh_inst.divider.x\[1\] _02014_ _03282_ _01470_ VGND VGND VPWR VPWR _00258_
+ sky130_fd_sc_hd__o211a_2
XFILLER_0_91_254 VGND VGND VPWR VPWR sky130_fd_sc_hd__fill_1
X_07449_ _02255_ _02256_ tanh_inst.LOOKUP.index\[2\] VGND VGND VPWR VPWR _02257_ sky130_fd_sc_hd__mux2_1
XFILLER_0_9_584 VGND VGND VPWR VPWR sky130_fd_sc_hd__decap_4
XFILLER_0_36_137 VGND VGND VPWR VPWR sky130_fd_sc_hd__decap_3
X_10460_ clknet_leaf_38_clk _00317_ VGND VGND VPWR VPWR tanh_inst.divider.y\[-4\]
+ sky130_fd_sc_hd__dfxtp_2
XFILLER_0_45_682 VGND VGND VPWR VPWR sky130_fd_sc_hd__decap_3
XFILLER_0_51_107 VGND VGND VPWR VPWR sky130_fd_sc_hd__decap_4
XTAP_TAPCELL_ROW_79_1251 VGND VPWR sky130_fd_sc_hd__tapvpwrvgnd_1
XFILLER_0_72_490 VGND VGND VPWR VPWR sky130_fd_sc_hd__fill_1
X_09119_ tanh_inst.z_\[7\] _03859_ VGND VGND VPWR VPWR _03860_ sky130_fd_sc_hd__nor2_2
X_10391_ clknet_leaf_7_clk _00248_ VGND VGND VPWR VPWR tanh_inst.divider.x\[-9\] sky130_fd_sc_hd__dfxtp_2
XFILLER_0_60_663 VGND VGND VPWR VPWR sky130_fd_sc_hd__fill_1
XFILLER_0_32_365 VGND VGND VPWR VPWR sky130_fd_sc_hd__fill_2
XFILLER_0_3_3 VPWR VGND VPWR VGND sky130_ef_sc_hd__decap_12
XFILLER_0_102_297 VGND VGND VPWR VPWR sky130_fd_sc_hd__decap_3
XFILLER_0_87_505 VGND VGND VPWR VPWR sky130_fd_sc_hd__decap_4
XFILLER_0_59_207 VPWR VGND VPWR VGND sky130_ef_sc_hd__decap_12
XFILLER_0_36_671 VGND VGND VPWR VPWR sky130_fd_sc_hd__fill_2
XFILLER_0_113_529 VPWR VGND VPWR VGND sky130_ef_sc_hd__decap_12
Xclkload25 clknet_leaf_6_clk VGND VGND VPWR VPWR clkload25/Y sky130_fd_sc_hd__clkinv_4
Xclkload14 clknet_leaf_31_clk VGND VGND VPWR VPWR clkload14/Y sky130_fd_sc_hd__inv_6
Xclkload36 clknet_leaf_19_clk VGND VGND VPWR VPWR clkload36/Y sky130_fd_sc_hd__clkinv_8
XFILLER_0_121_573 VGND VGND VPWR VPWR sky130_fd_sc_hd__decap_4
XFILLER_0_50_195 VGND VGND VPWR VPWR sky130_fd_sc_hd__fill_1
X_06820_ _01475_ _01481_ VGND VGND VPWR VPWR _01712_ sky130_fd_sc_hd__nor2_2
X_06751_ _01640_ _01644_ VGND VGND VPWR VPWR _01651_ sky130_fd_sc_hd__nand2_2
XFILLER_0_116_41 VPWR VGND VPWR VGND sky130_ef_sc_hd__decap_12
X_09470_ tanh_inst.divider.x\[-10\] _04175_ _04174_ VGND VGND VPWR VPWR _04201_ sky130_fd_sc_hd__o21ai_2
X_06682_ _01479_ _01512_ _01516_ _01570_ VGND VGND VPWR VPWR _01589_ sky130_fd_sc_hd__a211o_2
X_05702_ _04980_ _00667_ mac_inst.z\[31\] VGND VGND VPWR VPWR _00679_ sky130_fd_sc_hd__a21o_2
XTAP_TAPCELL_ROW_47_850 VGND VPWR sky130_fd_sc_hd__tapvpwrvgnd_1
XFILLER_0_116_85 VPWR VGND VPWR VGND sky130_ef_sc_hd__decap_12
XFILLER_0_92_89 VGND VGND VPWR VPWR sky130_fd_sc_hd__fill_1
X_08421_ _03206_ VGND VGND VPWR VPWR _03207_ sky130_fd_sc_hd__inv_2
X_05633_ _04912_ _00451_ _00510_ VGND VGND VPWR VPWR _00618_ sky130_fd_sc_hd__o21a_2
XFILLER_0_86_593 VGND VGND VPWR VPWR sky130_fd_sc_hd__fill_1
XTAP_TAPCELL_ROW_63_1052 VGND VPWR sky130_fd_sc_hd__tapvpwrvgnd_1
X_08352_ _03129_ _03138_ VGND VGND VPWR VPWR _03140_ sky130_fd_sc_hd__nand2_2
X_05564_ _00524_ _00555_ mac_inst.z\[31\] VGND VGND VPWR VPWR _00556_ sky130_fd_sc_hd__a21oi_2
X_07303_ _01524_ _02106_ _02111_ _02112_ VGND VGND VPWR VPWR _02113_ sky130_fd_sc_hd__a211oi_2
X_08283_ tanh_inst.divider.x\[-4\] _03072_ VGND VGND VPWR VPWR _03073_ sky130_fd_sc_hd__nor2_2
X_05495_ mac_inst.y\[12\] _00484_ _00485_ _00476_ VGND VGND VPWR VPWR _00493_ sky130_fd_sc_hd__o2bb2ai_2
X_07234_ tanh_inst.divider.y\[-15\] _02028_ _02029_ VGND VGND VPWR VPWR _02044_ sky130_fd_sc_hd__o21a_2
Xclkload8 clknet_leaf_44_clk VGND VGND VPWR VPWR clkload8/Y sky130_fd_sc_hd__inv_6
XFILLER_0_6_543 VGND VGND VPWR VPWR sky130_fd_sc_hd__decap_4
XFILLER_0_27_671 VGND VGND VPWR VPWR sky130_fd_sc_hd__fill_1
XFILLER_0_41_82 VGND VGND VPWR VPWR sky130_fd_sc_hd__decap_3
XFILLER_0_104_507 VGND VGND VPWR VPWR sky130_fd_sc_hd__decap_6
XFILLER_0_81_3 VGND VGND VPWR VPWR sky130_fd_sc_hd__decap_4
XFILLER_0_14_321 VPWR VGND VPWR VGND sky130_ef_sc_hd__decap_12
XFILLER_0_6_587 VGND VGND VPWR VPWR sky130_fd_sc_hd__fill_1
XTAP_TAPCELL_ROW_115_1705 VGND VPWR sky130_fd_sc_hd__tapvpwrvgnd_1
X_07165_ _01981_ _01983_ VGND VGND VPWR VPWR _01985_ sky130_fd_sc_hd__nand2_2
XFILLER_0_14_365 VPWR VGND VPWR VGND sky130_ef_sc_hd__decap_12
XFILLER_0_42_652 VGND VGND VPWR VPWR sky130_fd_sc_hd__fill_2
XFILLER_0_42_674 VGND VGND VPWR VPWR sky130_fd_sc_hd__decap_4
X_07096_ _01031_ _01791_ _01894_ _01902_ _01908_ VGND VGND VPWR VPWR _01923_ sky130_fd_sc_hd__o2111a_2
X_06116_ _01062_ tanh_inst.divider.y\[-24\] tanh_inst.div_en VGND VGND VPWR VPWR _00086_
+ sky130_fd_sc_hd__mux2_1
XFILLER_0_42_696 VGND VGND VPWR VPWR sky130_fd_sc_hd__decap_4
X_06047_ mac_inst.z\[28\] _00996_ VGND VGND VPWR VPWR _00998_ sky130_fd_sc_hd__xnor2_2
XTAP_TAPCELL_ROW_74_1181 VGND VPWR sky130_fd_sc_hd__tapvpwrvgnd_1
XFILLER_0_1_281 VPWR VGND VPWR VGND sky130_ef_sc_hd__decap_12
XTAP_TAPCELL_ROW_74_1192 VGND VPWR sky130_fd_sc_hd__tapvpwrvgnd_1
XFILLER_0_10_593 VGND VGND VPWR VPWR sky130_fd_sc_hd__fill_1
X_07998_ _02793_ _02792_ VGND VGND VPWR VPWR _02794_ sky130_fd_sc_hd__nand2b_2
XFILLER_0_5_93 VPWR VGND VPWR VGND sky130_ef_sc_hd__decap_12
X_09806_ _04461_ _04488_ _04526_ _04466_ _04487_ VGND VGND VPWR VPWR _04528_ sky130_fd_sc_hd__o221a_2
X_06949_ _01776_ _01791_ _01778_ VGND VGND VPWR VPWR _01792_ sky130_fd_sc_hd__o21a_2
X_09737_ _04460_ VGND VGND VPWR VPWR _04461_ sky130_fd_sc_hd__inv_2
XFILLER_0_96_313 VGND VGND VPWR VPWR sky130_fd_sc_hd__fill_1
XFILLER_0_69_505 VPWR VGND VPWR VGND sky130_ef_sc_hd__decap_12
X_09668_ _04335_ _04338_ _04393_ VGND VGND VPWR VPWR _04394_ sky130_fd_sc_hd__o21ai_2
X_09599_ _04264_ _04283_ VGND VGND VPWR VPWR _04327_ sky130_fd_sc_hd__nand2_2
X_08619_ _03396_ _03400_ VGND VGND VPWR VPWR _03401_ sky130_fd_sc_hd__xor2_2
XPHY_EDGE_ROW_59_Left_181 VGND VGND VPWR VPWR sky130_fd_sc_hd__decap_3
XFILLER_0_119_161 VGND VGND VPWR VPWR sky130_fd_sc_hd__decap_6
XTAP_TAPCELL_ROW_25_577 VGND VPWR sky130_fd_sc_hd__tapvpwrvgnd_1
XFILLER_0_18_671 VGND VGND VPWR VPWR sky130_fd_sc_hd__decap_8
XFILLER_0_17_181 VPWR VGND VPWR VGND sky130_ef_sc_hd__decap_12
X_10443_ clknet_leaf_26_clk _00300_ VGND VGND VPWR VPWR tanh_inst.divider.y\[-21\]
+ sky130_fd_sc_hd__dfxtp_2
X_10374_ clknet_leaf_25_clk _00231_ VGND VGND VPWR VPWR tanh_inst.IS_FIRST4 sky130_fd_sc_hd__dfxtp_2
XFILLER_0_60_493 VGND VGND VPWR VPWR sky130_fd_sc_hd__fill_1
XPHY_EDGE_ROW_68_Left_190 VGND VGND VPWR VPWR sky130_fd_sc_hd__decap_3
XFILLER_0_46_27 VGND VGND VPWR VPWR sky130_fd_sc_hd__fill_1
XFILLER_0_99_162 VGND VGND VPWR VPWR sky130_fd_sc_hd__decap_6
XFILLER_0_99_151 VGND VGND VPWR VPWR sky130_fd_sc_hd__fill_2
XFILLER_0_87_335 VGND VGND VPWR VPWR sky130_fd_sc_hd__fill_1
XFILLER_0_62_26 VGND VGND VPWR VPWR sky130_fd_sc_hd__fill_2
XFILLER_0_56_722 VGND VGND VPWR VPWR sky130_fd_sc_hd__fill_2
XFILLER_0_28_402 VGND VGND VPWR VPWR sky130_fd_sc_hd__decap_8
XFILLER_0_7_329 VGND VGND VPWR VPWR sky130_fd_sc_hd__decap_6
XFILLER_0_43_427 VGND VGND VPWR VPWR sky130_fd_sc_hd__decap_3
X_05280_ _04781_ _04934_ _04955_ _04975_ VGND VGND VPWR VPWR _04981_ sky130_fd_sc_hd__or4_2
XFILLER_0_43_449 VGND VGND VPWR VPWR sky130_fd_sc_hd__decap_4
XFILLER_0_113_337 VGND VGND VPWR VPWR sky130_fd_sc_hd__decap_3
XFILLER_0_113_326 VGND VGND VPWR VPWR sky130_fd_sc_hd__fill_1
XFILLER_0_102_65 VPWR VGND VPWR VGND sky130_ef_sc_hd__decap_12
XFILLER_0_70_279 VGND VGND VPWR VPWR sky130_fd_sc_hd__decap_3
XFILLER_0_23_151 VPWR VGND VPWR VGND sky130_ef_sc_hd__decap_12
XFILLER_0_51_482 VPWR VGND VPWR VGND sky130_ef_sc_hd__decap_12
XFILLER_0_11_335 VGND VGND VPWR VPWR sky130_fd_sc_hd__fill_1
X_08970_ _03646_ _03658_ tanh_inst.z_\[7\] VGND VGND VPWR VPWR _03714_ sky130_fd_sc_hd__a21o_2
XFILLER_0_53_7 VGND VGND VPWR VPWR sky130_fd_sc_hd__fill_1
X_07921_ _02718_ VGND VGND VPWR VPWR _02719_ sky130_fd_sc_hd__inv_2
XTAP_TAPCELL_ROW_110_1635 VGND VPWR sky130_fd_sc_hd__tapvpwrvgnd_1
X_07852_ _02649_ _02651_ VGND VGND VPWR VPWR _02652_ sky130_fd_sc_hd__xnor2_2
X_06803_ _01480_ _01513_ _01483_ VGND VGND VPWR VPWR _01697_ sky130_fd_sc_hd__o21a_2
X_09522_ _04108_ _04250_ _04251_ _03966_ VGND VGND VPWR VPWR _04252_ sky130_fd_sc_hd__a22oi_2
X_07783_ _02582_ _02583_ VGND VGND VPWR VPWR _02584_ sky130_fd_sc_hd__xnor2_2
XFILLER_0_78_302 VGND VGND VPWR VPWR sky130_fd_sc_hd__decap_6
XFILLER_0_36_93 VGND VGND VPWR VPWR sky130_fd_sc_hd__decap_3
X_06734_ _01633_ _01634_ VGND VGND VPWR VPWR _01636_ sky130_fd_sc_hd__or2_2
X_09453_ _02809_ _04173_ VGND VGND VPWR VPWR _04185_ sky130_fd_sc_hd__or2_2
X_06665_ tanh_inst.z_\[-18\] _01573_ VGND VGND VPWR VPWR _01574_ sky130_fd_sc_hd__and2_2
XFILLER_0_66_508 VPWR VGND VPWR VGND sky130_ef_sc_hd__decap_12
X_09384_ _04047_ _04117_ tanh_inst.z_\[7\] VGND VGND VPWR VPWR _04118_ sky130_fd_sc_hd__a21o_2
X_08404_ _03068_ _03069_ _03108_ _03119_ _04791_ VGND VGND VPWR VPWR _03191_ sky130_fd_sc_hd__o41a_2
X_05616_ mac_inst.y\[24\] _00602_ VGND VGND VPWR VPWR _00603_ sky130_fd_sc_hd__and2_2
XTAP_TAPCELL_ROW_121_1786 VGND VPWR sky130_fd_sc_hd__tapvpwrvgnd_1
XTAP_TAPCELL_ROW_121_1775 VGND VPWR sky130_fd_sc_hd__tapvpwrvgnd_1
XFILLER_0_108_109 VPWR VGND VPWR VGND sky130_ef_sc_hd__decap_12
XFILLER_0_74_530 VGND VGND VPWR VPWR sky130_fd_sc_hd__fill_2
X_06596_ _01489_ _01508_ VGND VGND VPWR VPWR _01510_ sky130_fd_sc_hd__nand2_2
XFILLER_0_19_435 VPWR VGND VPWR VGND sky130_ef_sc_hd__decap_12
X_08335_ tanh_inst.divider.x\[-2\] _03121_ VGND VGND VPWR VPWR _03123_ sky130_fd_sc_hd__or2_2
XTAP_TAPCELL_ROW_22_536 VGND VPWR sky130_fd_sc_hd__tapvpwrvgnd_1
X_05547_ _00539_ VGND VGND VPWR VPWR _00540_ sky130_fd_sc_hd__inv_2
XFILLER_0_46_265 VPWR VGND VPWR VGND sky130_ef_sc_hd__decap_12
X_05478_ mac_inst.i\[3\] _00371_ VGND VGND VPWR VPWR _00477_ sky130_fd_sc_hd__nand2_2
X_08266_ _03050_ _03052_ _03054_ _03048_ VGND VGND VPWR VPWR _03056_ sky130_fd_sc_hd__a31o_2
XTAP_TAPCELL_ROW_50_889 VGND VPWR sky130_fd_sc_hd__tapvpwrvgnd_1
XFILLER_0_116_186 VGND VGND VPWR VPWR sky130_fd_sc_hd__fill_1
X_07217_ _01513_ _01523_ VGND VGND VPWR VPWR _02027_ sky130_fd_sc_hd__nand2_2
XFILLER_0_61_246 VGND VGND VPWR VPWR sky130_fd_sc_hd__fill_2
X_08197_ _02986_ _02988_ VGND VGND VPWR VPWR _02989_ sky130_fd_sc_hd__xor2_2
X_07148_ _01952_ _01962_ VGND VGND VPWR VPWR _01970_ sky130_fd_sc_hd__nand2b_2
XTAP_TAPCELL_ROW_76_1210 VGND VPWR sky130_fd_sc_hd__tapvpwrvgnd_1
XFILLER_0_14_195 VGND VGND VPWR VPWR sky130_fd_sc_hd__fill_1
X_07079_ _01030_ _01767_ VGND VGND VPWR VPWR _01908_ sky130_fd_sc_hd__nand2_2
XFILLER_0_100_521 VGND VGND VPWR VPWR sky130_fd_sc_hd__decap_8
XFILLER_0_30_699 VGND VGND VPWR VPWR sky130_fd_sc_hd__fill_1
X_10090_ clknet_leaf_4_clk _00107_ VGND VGND VPWR VPWR tanh_inst.divider.y_\[-3\]
+ sky130_fd_sc_hd__dfxtp_2
Xclkbuf_leaf_39_clk clknet_2_0__leaf_clk VGND VGND VPWR VPWR clknet_leaf_39_clk sky130_fd_sc_hd__clkbuf_8
XTAP_TAPCELL_ROW_87_1350 VGND VPWR sky130_fd_sc_hd__tapvpwrvgnd_1
XFILLER_0_69_335 VGND VGND VPWR VPWR sky130_fd_sc_hd__fill_1
XTAP_TAPCELL_ROW_58_989 VGND VPWR sky130_fd_sc_hd__tapvpwrvgnd_1
XTAP_TAPCELL_ROW_2_283 VGND VPWR sky130_fd_sc_hd__tapvpwrvgnd_1
XFILLER_0_84_316 VGND VGND VPWR VPWR sky130_fd_sc_hd__decap_4
XFILLER_0_32_29 VGND VGND VPWR VPWR sky130_fd_sc_hd__fill_2
XFILLER_0_65_541 VGND VGND VPWR VPWR sky130_fd_sc_hd__decap_3
XFILLER_0_37_232 VGND VGND VPWR VPWR sky130_fd_sc_hd__fill_2
XFILLER_0_37_254 VPWR VGND VPWR VGND sky130_ef_sc_hd__decap_12
XFILLER_0_80_533 VGND VGND VPWR VPWR sky130_fd_sc_hd__fill_2
XFILLER_0_52_224 VGND VGND VPWR VPWR sky130_fd_sc_hd__decap_8
XTAP_TAPCELL_ROW_98_1490 VGND VPWR sky130_fd_sc_hd__tapvpwrvgnd_1
X_10426_ clknet_leaf_38_clk _00283_ _00000_ VGND VGND VPWR VPWR mac_inst.i\[18\] sky130_fd_sc_hd__dfrtp_2
XFILLER_0_0_505 VGND VGND VPWR VPWR sky130_fd_sc_hd__decap_8
XFILLER_0_20_121 VPWR VGND VPWR VGND sky130_ef_sc_hd__decap_12
XFILLER_0_21_666 VGND VGND VPWR VPWR sky130_fd_sc_hd__decap_6
X_10357_ clknet_leaf_19_clk _00214_ VGND VGND VPWR VPWR tanh_inst.divider.z_\[-7\]
+ sky130_fd_sc_hd__dfxtp_2
XFILLER_0_57_15 VPWR VGND VPWR VGND sky130_ef_sc_hd__decap_12
XFILLER_0_20_165 VPWR VGND VPWR VGND sky130_ef_sc_hd__decap_12
X_10288_ clknet_leaf_27_clk _00145_ VGND VGND VPWR VPWR tanh_inst.z_\[-7\] sky130_fd_sc_hd__dfxtp_2
XFILLER_0_88_611 VGND VGND VPWR VPWR sky130_fd_sc_hd__fill_2
XFILLER_0_87_132 VGND VGND VPWR VPWR sky130_fd_sc_hd__fill_1
X_06450_ _01373_ _01374_ _01372_ VGND VGND VPWR VPWR _01375_ sky130_fd_sc_hd__o21a_2
XFILLER_0_29_722 VGND VGND VPWR VPWR sky130_fd_sc_hd__fill_2
XFILLER_0_75_349 VPWR VGND VPWR VGND sky130_ef_sc_hd__decap_12
XFILLER_0_56_541 VGND VGND VPWR VPWR sky130_fd_sc_hd__decap_3
XFILLER_0_56_530 VGND VGND VPWR VPWR sky130_fd_sc_hd__fill_2
XFILLER_0_28_232 VGND VGND VPWR VPWR sky130_fd_sc_hd__fill_1
X_05401_ mac_inst.y\[6\] _00405_ VGND VGND VPWR VPWR _00406_ sky130_fd_sc_hd__nand2_2
X_06381_ _04793_ _01299_ _01301_ VGND VGND VPWR VPWR _01311_ sky130_fd_sc_hd__a21bo_2
XTAP_TAPCELL_ROW_60_1011 VGND VPWR sky130_fd_sc_hd__tapvpwrvgnd_1
XFILLER_0_56_552 VPWR VGND VPWR VGND sky130_ef_sc_hd__decap_12
XFILLER_0_7_137 VPWR VGND VPWR VGND sky130_ef_sc_hd__decap_12
XFILLER_0_83_393 VGND VGND VPWR VPWR sky130_fd_sc_hd__decap_4
X_05332_ _04927_ _05008_ mac_inst.z\[31\] VGND VGND VPWR VPWR _05031_ sky130_fd_sc_hd__a21o_2
X_08120_ _02822_ _02913_ tanh_inst.z_\[7\] VGND VGND VPWR VPWR _02914_ sky130_fd_sc_hd__a21oi_2
X_08051_ _02795_ _02798_ _02794_ VGND VGND VPWR VPWR _02846_ sky130_fd_sc_hd__a21bo_2
X_05263_ _04957_ _04958_ _04963_ VGND VGND VPWR VPWR _04964_ sky130_fd_sc_hd__a21o_2
XFILLER_0_31_408 VGND VGND VPWR VPWR sky130_fd_sc_hd__decap_3
X_07002_ _01839_ VGND VGND VPWR VPWR _01840_ sky130_fd_sc_hd__inv_2
XFILLER_0_98_77 VGND VGND VPWR VPWR sky130_fd_sc_hd__decap_6
XFILLER_0_113_167 VGND VGND VPWR VPWR sky130_fd_sc_hd__fill_1
X_05194_ mac_inst.x\[15\] _04852_ _04853_ VGND VGND VPWR VPWR _04898_ sky130_fd_sc_hd__a21o_2
X_08953_ _04791_ _03696_ VGND VGND VPWR VPWR _03697_ sky130_fd_sc_hd__nand2_2
X_07904_ _02701_ VGND VGND VPWR VPWR _02702_ sky130_fd_sc_hd__inv_2
XTAP_TAPCELL_ROW_71_1151 VGND VPWR sky130_fd_sc_hd__tapvpwrvgnd_1
XFILLER_0_44_3 VGND VGND VPWR VPWR sky130_fd_sc_hd__decap_4
X_08884_ _03621_ _03622_ _03628_ _02019_ VGND VGND VPWR VPWR _03629_ sky130_fd_sc_hd__o211a_2
XFILLER_0_98_419 VGND VGND VPWR VPWR sky130_fd_sc_hd__fill_1
X_07835_ _02552_ _02585_ _02586_ VGND VGND VPWR VPWR _02635_ sky130_fd_sc_hd__o21ba_2
X_07766_ _02515_ _02516_ tanh_inst.z_\[7\] VGND VGND VPWR VPWR _02568_ sky130_fd_sc_hd__a21o_2
X_09505_ _04223_ _04227_ _04234_ VGND VGND VPWR VPWR _04235_ sky130_fd_sc_hd__and3_2
XTAP_TAPCELL_ROW_55_948 VGND VPWR sky130_fd_sc_hd__tapvpwrvgnd_1
XFILLER_0_2_83 VGND VGND VPWR VPWR sky130_fd_sc_hd__fill_1
X_06717_ mac_y_out[11] _01469_ _01619_ _01620_ VGND VGND VPWR VPWR _00139_ sky130_fd_sc_hd__a22o_2
X_07697_ tanh_inst.divider.y\[-17\] tanh_inst.divider.x\[-17\] VGND VGND VPWR VPWR
+ _02500_ sky130_fd_sc_hd__or2_2
XFILLER_0_93_113 VGND VGND VPWR VPWR sky130_fd_sc_hd__fill_2
X_09436_ tanh_inst.divider.y\[-11\] _04153_ _04120_ VGND VGND VPWR VPWR _04168_ sky130_fd_sc_hd__a21boi_2
X_06648_ tanh_inst.z_\[-20\] _01557_ VGND VGND VPWR VPWR _01559_ sky130_fd_sc_hd__nor2_2
X_09367_ _04099_ tanh_inst.divider.x\[-12\] VGND VGND VPWR VPWR _04101_ sky130_fd_sc_hd__and2b_2
XTAP_TAPCELL_ROW_82_1291 VGND VPWR sky130_fd_sc_hd__tapvpwrvgnd_1
X_06579_ _01490_ _01491_ _01492_ _01493_ VGND VGND VPWR VPWR _01494_ sky130_fd_sc_hd__or4_2
XTAP_TAPCELL_ROW_35_694 VGND VPWR sky130_fd_sc_hd__tapvpwrvgnd_1
X_09298_ _04032_ _04033_ VGND VGND VPWR VPWR _04034_ sky130_fd_sc_hd__nor2_2
XFILLER_0_105_602 VGND VGND VPWR VPWR sky130_fd_sc_hd__fill_2
X_08318_ _03105_ _03106_ tanh_inst.z_\[7\] _03095_ VGND VGND VPWR VPWR _03107_ sky130_fd_sc_hd__a2bb2o_2
XFILLER_0_104_101 VPWR VGND VPWR VGND sky130_ef_sc_hd__decap_12
XFILLER_0_7_671 VGND VGND VPWR VPWR sky130_fd_sc_hd__fill_1
X_08249_ _02965_ _03038_ VGND VGND VPWR VPWR _03039_ sky130_fd_sc_hd__nor2_2
XFILLER_0_30_430 VPWR VGND VPWR VGND sky130_ef_sc_hd__decap_12
X_10211_ clknet_leaf_22_clk mac_inst.y\[5\] _00000_ VGND VGND VPWR VPWR mac_y_out[5]
+ sky130_fd_sc_hd__dfrtp_2
X_10073_ clknet_leaf_14_clk _00090_ VGND VGND VPWR VPWR tanh_inst.divider.y_\[-20\]
+ sky130_fd_sc_hd__dfxtp_2
XFILLER_0_100_395 VGND VGND VPWR VPWR sky130_fd_sc_hd__fill_1
XTAP_TAPCELL_ROW_7_353 VGND VPWR sky130_fd_sc_hd__tapvpwrvgnd_1
XFILLER_0_69_132 VGND VGND VPWR VPWR sky130_fd_sc_hd__decap_4
XFILLER_0_43_28 VGND VGND VPWR VPWR sky130_fd_sc_hd__decap_8
XFILLER_0_85_636 VGND VGND VPWR VPWR sky130_fd_sc_hd__fill_1
XFILLER_0_85_625 VGND VGND VPWR VPWR sky130_fd_sc_hd__fill_1
XFILLER_0_85_658 VGND VGND VPWR VPWR sky130_fd_sc_hd__decap_6
XFILLER_0_84_124 VPWR VGND VPWR VGND sky130_ef_sc_hd__decap_12
XFILLER_0_57_349 VGND VGND VPWR VPWR sky130_fd_sc_hd__decap_6
XFILLER_0_65_393 VPWR VGND VPWR VGND sky130_ef_sc_hd__decap_12
XFILLER_0_92_190 VGND VGND VPWR VPWR sky130_fd_sc_hd__decap_6
XFILLER_0_80_352 VPWR VGND VPWR VGND sky130_ef_sc_hd__decap_12
XFILLER_0_53_588 VGND VGND VPWR VPWR sky130_fd_sc_hd__decap_6
XFILLER_0_25_279 VGND VGND VPWR VPWR sky130_fd_sc_hd__fill_1
XFILLER_0_7_39 VPWR VGND VPWR VGND sky130_ef_sc_hd__decap_12
XFILLER_0_21_441 VGND VGND VPWR VPWR sky130_fd_sc_hd__decap_6
X_10409_ clknet_leaf_36_clk _00266_ _00000_ VGND VGND VPWR VPWR mac_inst.i\[1\] sky130_fd_sc_hd__dfrtp_2
XFILLER_0_84_46 VPWR VGND VPWR VGND sky130_ef_sc_hd__decap_12
X_05950_ mac_inst.z\[18\] _00881_ _00892_ mac_inst.z\[19\] VGND VGND VPWR VPWR _00909_
+ sky130_fd_sc_hd__a22oi_2
XFILLER_0_108_53 VPWR VGND VPWR VGND sky130_ef_sc_hd__decap_12
X_05881_ mac_inst.z\[14\] _00826_ _00836_ VGND VGND VPWR VPWR _00845_ sky130_fd_sc_hd__a21oi_2
X_07620_ _02374_ _02375_ tanh_inst.z_\[7\] VGND VGND VPWR VPWR _02425_ sky130_fd_sc_hd__a21oi_2
XFILLER_0_17_51 VGND VGND VPWR VPWR sky130_fd_sc_hd__decap_4
XFILLER_0_108_97 VPWR VGND VPWR VGND sky130_ef_sc_hd__decap_12
X_07551_ _02355_ _02356_ VGND VGND VPWR VPWR _02357_ sky130_fd_sc_hd__nand2_2
X_06502_ _01385_ _01386_ _01401_ _01410_ VGND VGND VPWR VPWR _01422_ sky130_fd_sc_hd__or4_2
XTAP_TAPCELL_ROW_52_918 VGND VPWR sky130_fd_sc_hd__tapvpwrvgnd_1
XFILLER_0_48_316 VGND VGND VPWR VPWR sky130_fd_sc_hd__decap_4
XTAP_TAPCELL_ROW_52_907 VGND VPWR sky130_fd_sc_hd__tapvpwrvgnd_1
XTAP_TAPCELL_ROW_105_1578 VGND VPWR sky130_fd_sc_hd__tapvpwrvgnd_1
X_07482_ tanh_inst.divider.x\[-21\] _02288_ VGND VGND VPWR VPWR _02289_ sky130_fd_sc_hd__nand2_2
XFILLER_0_76_658 VPWR VGND VPWR VGND sky130_ef_sc_hd__decap_12
XFILLER_0_75_124 VGND VGND VPWR VPWR sky130_fd_sc_hd__decap_6
XFILLER_0_75_113 VGND VGND VPWR VPWR sky130_fd_sc_hd__fill_1
XFILLER_0_8_413 VGND VGND VPWR VPWR sky130_fd_sc_hd__decap_6
XFILLER_0_29_541 VGND VGND VPWR VPWR sky130_fd_sc_hd__fill_1
XFILLER_0_48_338 VPWR VGND VPWR VGND sky130_ef_sc_hd__decap_12
X_06433_ _04793_ _01357_ _01358_ VGND VGND VPWR VPWR _01359_ sky130_fd_sc_hd__and3_2
X_09221_ tanh_inst.divider.x\[-16\] _03958_ VGND VGND VPWR VPWR _03959_ sky130_fd_sc_hd__nor2_2
XFILLER_0_91_617 VGND VGND VPWR VPWR sky130_fd_sc_hd__fill_2
XFILLER_0_63_319 VPWR VGND VPWR VGND sky130_ef_sc_hd__decap_12
XFILLER_0_8_435 VGND VGND VPWR VPWR sky130_fd_sc_hd__fill_2
X_06364_ _01283_ _01286_ _01282_ VGND VGND VPWR VPWR _01296_ sky130_fd_sc_hd__a21o_2
X_09152_ tanh_inst.z_\[7\] _03890_ _03891_ VGND VGND VPWR VPWR _03892_ sky130_fd_sc_hd__nor3b_2
XFILLER_0_56_382 VPWR VGND VPWR VGND sky130_ef_sc_hd__decap_12
XFILLER_0_8_457 VGND VGND VPWR VPWR sky130_fd_sc_hd__decap_6
XFILLER_0_29_596 VGND VGND VPWR VPWR sky130_fd_sc_hd__fill_1
XTAP_TAPCELL_ROW_32_664 VGND VPWR sky130_fd_sc_hd__tapvpwrvgnd_1
X_08103_ _02837_ _02853_ _02896_ VGND VGND VPWR VPWR _02897_ sky130_fd_sc_hd__a21o_2
XFILLER_0_83_190 VGND VGND VPWR VPWR sky130_fd_sc_hd__fill_1
X_05315_ mac_inst.x\[31\] _04879_ _04789_ VGND VGND VPWR VPWR _05014_ sky130_fd_sc_hd__mux2_1
X_06295_ _01228_ _01231_ VGND VGND VPWR VPWR _01232_ sky130_fd_sc_hd__xnor2_2
X_09083_ _03823_ _03824_ _02019_ VGND VGND VPWR VPWR _03825_ sky130_fd_sc_hd__a21oi_2
XFILLER_0_102_627 VGND VGND VPWR VPWR sky130_fd_sc_hd__decap_8
X_08034_ _02748_ _02827_ _02825_ _02779_ VGND VGND VPWR VPWR _02830_ sky130_fd_sc_hd__a211o_2
XFILLER_0_4_674 VGND VGND VPWR VPWR sky130_fd_sc_hd__fill_2
X_05246_ mac_inst.i\[27\] mac_inst.i\[26\] mac_inst.i\[28\] VGND VGND VPWR VPWR _04947_
+ sky130_fd_sc_hd__and3_2
X_05177_ _04789_ _04875_ _04877_ _04880_ VGND VGND VPWR VPWR _04881_ sky130_fd_sc_hd__a31o_2
X_09985_ _04699_ _04700_ _04701_ VGND VGND VPWR VPWR _04702_ sky130_fd_sc_hd__a21oi_2
X_08936_ _03550_ _03562_ _03564_ _03552_ tanh_inst.LOOKUP.index\[1\] tanh_inst.LOOKUP.index\[0\]
+ VGND VGND VPWR VPWR _03680_ sky130_fd_sc_hd__mux4_2
XTAP_TAPCELL_ROW_4_312 VGND VPWR sky130_fd_sc_hd__tapvpwrvgnd_1
XFILLER_0_99_706 VGND VGND VPWR VPWR sky130_fd_sc_hd__fill_1
X_08867_ _02023_ _03588_ _03596_ _03599_ _02052_ VGND VGND VPWR VPWR _03612_ sky130_fd_sc_hd__o221ai_2
X_07818_ tanh_inst.divider.y\[-15\] _02592_ _02590_ VGND VGND VPWR VPWR _02618_ sky130_fd_sc_hd__o21a_2
X_08798_ tanh_inst.divider.x\[0\] _02028_ _03508_ VGND VGND VPWR VPWR _03544_ sky130_fd_sc_hd__o21a_2
XFILLER_0_79_441 VGND VGND VPWR VPWR sky130_fd_sc_hd__decap_6
X_07749_ _02547_ _02550_ VGND VGND VPWR VPWR _02551_ sky130_fd_sc_hd__xnor2_2
XFILLER_0_66_113 VPWR VGND VPWR VGND sky130_ef_sc_hd__decap_12
XFILLER_0_94_477 VPWR VGND VPWR VGND sky130_ef_sc_hd__decap_12
XFILLER_0_82_606 VPWR VGND VPWR VGND sky130_ef_sc_hd__decap_12
X_09419_ _04047_ _04116_ _04117_ tanh_inst.z_\[7\] VGND VGND VPWR VPWR _04152_ sky130_fd_sc_hd__a31o_2
XFILLER_0_54_319 VGND VGND VPWR VPWR sky130_fd_sc_hd__fill_1
XFILLER_0_109_259 VPWR VGND VPWR VGND sky130_ef_sc_hd__decap_12
XFILLER_0_47_393 VGND VGND VPWR VPWR sky130_fd_sc_hd__decap_3
XFILLER_0_62_341 VGND VGND VPWR VPWR sky130_fd_sc_hd__decap_8
XFILLER_0_35_566 VGND VGND VPWR VPWR sky130_fd_sc_hd__decap_3
XFILLER_0_117_281 VGND VGND VPWR VPWR sky130_fd_sc_hd__fill_2
XFILLER_0_105_487 VPWR VGND VPWR VGND sky130_ef_sc_hd__decap_12
X_10056_ rst VGND VGND VPWR VPWR _00075_ sky130_fd_sc_hd__inv_2
XFILLER_0_89_216 VGND VGND VPWR VPWR sky130_fd_sc_hd__decap_8
XFILLER_0_54_27 VGND VGND VPWR VPWR sky130_fd_sc_hd__fill_1
XFILLER_0_70_15 VGND VGND VPWR VPWR sky130_fd_sc_hd__decap_8
XFILLER_0_73_617 VGND VGND VPWR VPWR sky130_fd_sc_hd__fill_2
XFILLER_0_26_511 VGND VGND VPWR VPWR sky130_fd_sc_hd__fill_2
XFILLER_0_26_522 VGND VGND VPWR VPWR sky130_fd_sc_hd__decap_8
XFILLER_0_26_555 VGND VGND VPWR VPWR sky130_fd_sc_hd__fill_1
XFILLER_0_80_160 VGND VGND VPWR VPWR sky130_fd_sc_hd__fill_2
XFILLER_0_13_205 VPWR VGND VPWR VGND sky130_ef_sc_hd__decap_12
X_06080_ tanh_inst.divider.i\[4\] _01026_ VGND VGND VPWR VPWR _01027_ sky130_fd_sc_hd__nand2_2
XFILLER_0_102_3 VPWR VGND VPWR VGND sky130_ef_sc_hd__decap_12
XFILLER_0_79_57 VPWR VGND VPWR VGND sky130_ef_sc_hd__decap_12
XFILLER_0_13_249 VPWR VGND VPWR VGND sky130_ef_sc_hd__decap_12
X_05100_ tanh_counter\[0\] _04779_ tanh_counter\[1\] VGND VGND VPWR VPWR _04816_ sky130_fd_sc_hd__a21o_2
XFILLER_0_111_413 VPWR VGND VPWR VGND sky130_ef_sc_hd__decap_12
XFILLER_0_110_65 VPWR VGND VPWR VGND sky130_ef_sc_hd__decap_12
XPHY_EDGE_ROW_9_Right_9 VGND VGND VPWR VPWR sky130_fd_sc_hd__decap_3
XFILLER_0_0_165 VGND VGND VPWR VPWR sky130_fd_sc_hd__decap_3
XFILLER_0_21_293 VPWR VGND VPWR VGND sky130_ef_sc_hd__decap_12
X_06982_ _01821_ VGND VGND VPWR VPWR _01822_ sky130_fd_sc_hd__inv_2
XPHY_EDGE_ROW_107_Right_107 VGND VGND VPWR VPWR sky130_fd_sc_hd__decap_3
XPHY_EDGE_ROW_13_Left_135 VGND VGND VPWR VPWR sky130_fd_sc_hd__decap_3
X_09770_ tanh_inst.LOOKUP.index\[4\] _03940_ _04213_ VGND VGND VPWR VPWR _04493_ sky130_fd_sc_hd__o21a_2
X_05933_ mac_inst.z\[19\] _00892_ VGND VGND VPWR VPWR _00893_ sky130_fd_sc_hd__nor2_2
XFILLER_0_28_72 VPWR VGND VPWR VGND sky130_ef_sc_hd__decap_12
X_08721_ _00958_ _03491_ VGND VGND VPWR VPWR _00272_ sky130_fd_sc_hd__and2b_2
X_08652_ _03430_ _03431_ _03432_ VGND VGND VPWR VPWR _03433_ sky130_fd_sc_hd__a21oi_2
X_07603_ _02404_ _02407_ VGND VGND VPWR VPWR _02408_ sky130_fd_sc_hd__xnor2_2
X_05864_ _00821_ _00827_ mac_inst.z\[14\] VGND VGND VPWR VPWR _00829_ sky130_fd_sc_hd__a21bo_2
XTAP_TAPCELL_ROW_37_723 VGND VPWR sky130_fd_sc_hd__tapvpwrvgnd_1
XFILLER_0_76_400 VGND VGND VPWR VPWR sky130_fd_sc_hd__decap_8
X_08583_ _03327_ _03330_ _03363_ VGND VGND VPWR VPWR _03365_ sky130_fd_sc_hd__nor3_2
X_05795_ _00748_ _00750_ mac_inst.z\[31\] VGND VGND VPWR VPWR _00765_ sky130_fd_sc_hd__a21o_2
XFILLER_0_44_60 VGND VGND VPWR VPWR sky130_fd_sc_hd__fill_1
X_07534_ _02025_ _02058_ _02022_ VGND VGND VPWR VPWR _02340_ sky130_fd_sc_hd__a21oi_2
X_07465_ _02032_ _02036_ _02040_ _02034_ _04760_ _04761_ VGND VGND VPWR VPWR _02272_
+ sky130_fd_sc_hd__mux4_2
XFILLER_0_76_477 VGND VGND VPWR VPWR sky130_fd_sc_hd__fill_1
XTAP_TAPCELL_ROW_66_1083 VGND VPWR sky130_fd_sc_hd__tapvpwrvgnd_1
XFILLER_0_8_221 VPWR VGND VPWR VGND sky130_ef_sc_hd__decap_12
XTAP_TAPCELL_ROW_17_480 VGND VPWR sky130_fd_sc_hd__tapvpwrvgnd_1
XPHY_EDGE_ROW_22_Left_144 VGND VGND VPWR VPWR sky130_fd_sc_hd__decap_3
X_06416_ _01300_ _01332_ _01333_ tanh_inst.divider.y_\[7\] VGND VGND VPWR VPWR _01343_
+ sky130_fd_sc_hd__a31o_2
XFILLER_0_64_639 VGND VGND VPWR VPWR sky130_fd_sc_hd__decap_4
XFILLER_0_63_127 VPWR VGND VPWR VGND sky130_ef_sc_hd__decap_12
X_09204_ _04757_ _03940_ _03942_ _01525_ VGND VGND VPWR VPWR _03943_ sky130_fd_sc_hd__o22a_2
X_07396_ _02031_ _02093_ _02095_ _02033_ tanh_inst.LOOKUP.index\[1\] _04761_ VGND
+ VGND VPWR VPWR _02204_ sky130_fd_sc_hd__mux4_2
XFILLER_0_60_81 VGND VGND VPWR VPWR sky130_fd_sc_hd__decap_3
XFILLER_0_8_265 VPWR VGND VPWR VGND sky130_ef_sc_hd__decap_12
XTAP_TAPCELL_ROW_118_1736 VGND VPWR sky130_fd_sc_hd__tapvpwrvgnd_1
X_06347_ _01266_ _01267_ _04793_ VGND VGND VPWR VPWR _01280_ sky130_fd_sc_hd__o21a_2
X_09135_ tanh_inst.divider.x\[7\] _03675_ _03677_ _03679_ _02025_ _02023_ VGND VGND
+ VPWR VPWR _03875_ sky130_fd_sc_hd__mux4_2
XFILLER_0_44_363 VGND VGND VPWR VPWR sky130_fd_sc_hd__fill_1
X_06278_ tanh_inst.divider.i\[4\] _01215_ _01081_ _01031_ VGND VGND VPWR VPWR _01216_
+ sky130_fd_sc_hd__o2bb2a_2
X_09066_ _03648_ _03651_ tanh_inst.LOOKUP.index\[2\] VGND VGND VPWR VPWR _03808_ sky130_fd_sc_hd__mux2_1
X_08017_ _02722_ _02768_ VGND VGND VPWR VPWR _02813_ sky130_fd_sc_hd__nor2_2
X_05229_ tanh_counter\[7\] tanh_counter\[6\] _04930_ _04817_ VGND VGND VPWR VPWR _04931_
+ sky130_fd_sc_hd__o31a_2
XFILLER_0_4_493 VGND VGND VPWR VPWR sky130_fd_sc_hd__fill_2
XFILLER_0_69_90 VGND VGND VPWR VPWR sky130_fd_sc_hd__decap_3
XPHY_EDGE_ROW_31_Left_153 VGND VGND VPWR VPWR sky130_fd_sc_hd__decap_3
X_09968_ _04680_ _04683_ tanh_inst.z_\[7\] VGND VGND VPWR VPWR _04685_ sky130_fd_sc_hd__a21oi_2
XFILLER_0_99_503 VGND VGND VPWR VPWR sky130_fd_sc_hd__fill_1
XTAP_TAPCELL_ROW_90_1390 VGND VPWR sky130_fd_sc_hd__tapvpwrvgnd_1
X_08919_ _03662_ _03663_ VGND VGND VPWR VPWR _03664_ sky130_fd_sc_hd__xnor2_2
X_09899_ tanh_inst.divider.x\[3\] _04617_ VGND VGND VPWR VPWR _04618_ sky130_fd_sc_hd__nor2_2
XFILLER_0_79_271 VGND VGND VPWR VPWR sky130_fd_sc_hd__decap_8
XPHY_EDGE_ROW_40_Left_162 VGND VGND VPWR VPWR sky130_fd_sc_hd__decap_3
XFILLER_0_39_113 VGND VGND VPWR VPWR sky130_fd_sc_hd__decap_4
XFILLER_0_55_617 VGND VGND VPWR VPWR sky130_fd_sc_hd__fill_2
XFILLER_0_94_274 VPWR VGND VPWR VGND sky130_ef_sc_hd__decap_12
XFILLER_0_82_414 VGND VGND VPWR VPWR sky130_fd_sc_hd__decap_6
XFILLER_0_50_333 VGND VGND VPWR VPWR sky130_fd_sc_hd__decap_8
XFILLER_0_120_221 VPWR VGND VPWR VGND sky130_ef_sc_hd__decap_12
XTAP_TAPCELL_ROW_93_1419 VGND VPWR sky130_fd_sc_hd__tapvpwrvgnd_1
XFILLER_0_120_265 VPWR VGND VPWR VGND sky130_ef_sc_hd__decap_12
XFILLER_0_65_15 VPWR VGND VPWR VGND sky130_ef_sc_hd__decap_12
XFILLER_0_4_29 VPWR VGND VPWR VGND sky130_ef_sc_hd__decap_12
X_10108_ clknet_leaf_33_clk _00125_ _00075_ VGND VGND VPWR VPWR mac_counter\[7\] sky130_fd_sc_hd__dfrtp_2
X_10039_ _01513_ _04749_ VGND VGND VPWR VPWR _04752_ sky130_fd_sc_hd__nor2_2
XFILLER_0_77_208 VGND VGND VPWR VPWR sky130_fd_sc_hd__fill_2
X_05580_ _00510_ _00569_ VGND VGND VPWR VPWR _00570_ sky130_fd_sc_hd__nand2_2
XTAP_TAPCELL_ROW_102_1537 VGND VPWR sky130_fd_sc_hd__tapvpwrvgnd_1
XFILLER_0_58_477 VPWR VGND VPWR VGND sky130_ef_sc_hd__decap_12
XFILLER_0_14_41 VPWR VGND VPWR VGND sky130_ef_sc_hd__decap_12
XFILLER_0_14_85 VPWR VGND VPWR VGND sky130_ef_sc_hd__decap_12
XFILLER_0_46_639 VGND VGND VPWR VPWR sky130_fd_sc_hd__decap_4
XFILLER_0_73_458 VPWR VGND VPWR VGND sky130_ef_sc_hd__decap_12
XFILLER_0_73_447 VGND VGND VPWR VPWR sky130_fd_sc_hd__fill_1
X_07250_ _02028_ _02059_ _02029_ VGND VGND VPWR VPWR _02060_ sky130_fd_sc_hd__o21ai_2
XFILLER_0_26_341 VGND VGND VPWR VPWR sky130_fd_sc_hd__fill_1
XTAP_TAPCELL_ROW_42_781 VGND VPWR sky130_fd_sc_hd__tapvpwrvgnd_1
XTAP_TAPCELL_ROW_42_792 VGND VPWR sky130_fd_sc_hd__tapvpwrvgnd_1
XFILLER_0_121_53 VGND VGND VPWR VPWR sky130_fd_sc_hd__decap_3
X_07181_ tanh_inst.divider.z_\[5\] _01975_ VGND VGND VPWR VPWR _01998_ sky130_fd_sc_hd__or2_2
X_06201_ _01039_ _01143_ VGND VGND VPWR VPWR _01144_ sky130_fd_sc_hd__or2_2
XFILLER_0_26_363 VGND VGND VPWR VPWR sky130_fd_sc_hd__fill_1
X_06132_ tanh_inst.divider.i\[2\] _01074_ _01076_ _01077_ _01031_ VGND VGND VPWR VPWR
+ _01078_ sky130_fd_sc_hd__a221o_2
XFILLER_0_5_279 VGND VGND VPWR VPWR sky130_fd_sc_hd__fill_1
XFILLER_0_121_97 VPWR VGND VPWR VGND sky130_ef_sc_hd__decap_12
XFILLER_0_111_210 VGND VGND VPWR VPWR sky130_fd_sc_hd__fill_1
XFILLER_0_111_232 VGND VGND VPWR VPWR sky130_fd_sc_hd__fill_2
X_06063_ mac_inst.z\[30\] _01010_ VGND VGND VPWR VPWR _01012_ sky130_fd_sc_hd__or2_2
XFILLER_0_41_399 VPWR VGND VPWR VGND sky130_ef_sc_hd__decap_12
XTAP_TAPCELL_ROW_113_1677 VGND VPWR sky130_fd_sc_hd__tapvpwrvgnd_1
X_09822_ _02018_ _04531_ _04543_ _04515_ VGND VGND VPWR VPWR _04544_ sky130_fd_sc_hd__o31a_2
X_09753_ _04474_ _04475_ VGND VGND VPWR VPWR _04476_ sky130_fd_sc_hd__nand2b_2
X_06965_ _01805_ _01806_ VGND VGND VPWR VPWR _01807_ sky130_fd_sc_hd__nor2_2
X_08704_ _04791_ _03437_ _03438_ VGND VGND VPWR VPWR _03483_ sky130_fd_sc_hd__a21o_2
X_06896_ tanh_inst.div_en tanh_inst.divider.z_\[-22\] VGND VGND VPWR VPWR _00167_
+ sky130_fd_sc_hd__and2b_2
XTAP_TAPCELL_ROW_68_1112 VGND VPWR sky130_fd_sc_hd__tapvpwrvgnd_1
X_05916_ _04923_ _00680_ _00847_ VGND VGND VPWR VPWR _00877_ sky130_fd_sc_hd__or3_2
X_09684_ tanh_inst.divider.y\[-3\] _04406_ VGND VGND VPWR VPWR _04409_ sky130_fd_sc_hd__nor2_2
XFILLER_0_96_528 VGND VGND VPWR VPWR sky130_fd_sc_hd__decap_4
X_08635_ _04791_ _03414_ _03415_ VGND VGND VPWR VPWR _03416_ sky130_fd_sc_hd__and3_2
X_05847_ mac_inst.i\[2\] _04944_ _00665_ _00716_ VGND VGND VPWR VPWR _00813_ sky130_fd_sc_hd__or4_2
XFILLER_0_49_400 VGND VGND VPWR VPWR sky130_fd_sc_hd__decap_4
X_08566_ _03347_ _03348_ VGND VGND VPWR VPWR _03349_ sky130_fd_sc_hd__xnor2_2
XFILLER_0_92_701 VGND VGND VPWR VPWR sky130_fd_sc_hd__decap_6
X_07517_ tanh_inst.LOOKUP.index\[4\] _02316_ _02323_ VGND VGND VPWR VPWR _02324_ sky130_fd_sc_hd__a21oi_2
X_05778_ mac_inst.z\[31\] _00741_ _00748_ VGND VGND VPWR VPWR _00749_ sky130_fd_sc_hd__o21ai_2
XFILLER_0_37_606 VGND VGND VPWR VPWR sky130_fd_sc_hd__decap_8
XFILLER_0_37_617 VGND VGND VPWR VPWR sky130_fd_sc_hd__decap_6
XTAP_TAPCELL_ROW_12_409 VGND VPWR sky130_fd_sc_hd__tapvpwrvgnd_1
X_08497_ _02019_ _03273_ _03281_ _02015_ VGND VGND VPWR VPWR _03282_ sky130_fd_sc_hd__a211o_2
X_07448_ tanh_inst.divider.y\[-10\] tanh_inst.divider.y\[-9\] tanh_inst.divider.y\[-8\]
+ tanh_inst.divider.y\[-7\] tanh_inst.LOOKUP.index\[0\] tanh_inst.LOOKUP.index\[1\]
+ VGND VGND VPWR VPWR _02256_ sky130_fd_sc_hd__mux4_2
X_07379_ _01486_ _02186_ _02187_ VGND VGND VPWR VPWR _02188_ sky130_fd_sc_hd__o21a_2
XTAP_TAPCELL_ROW_79_1252 VGND VPWR sky130_fd_sc_hd__tapvpwrvgnd_1
X_09118_ _03815_ _03816_ VGND VGND VPWR VPWR _03859_ sky130_fd_sc_hd__and2b_2
X_10390_ clknet_leaf_1_clk _00247_ VGND VGND VPWR VPWR tanh_inst.divider.x\[-10\]
+ sky130_fd_sc_hd__dfxtp_2
X_09049_ tanh_inst.divider.x\[-20\] _03790_ VGND VGND VPWR VPWR _03791_ sky130_fd_sc_hd__nor2_2
XFILLER_0_99_333 VGND VGND VPWR VPWR sky130_fd_sc_hd__decap_3
XFILLER_0_95_561 VPWR VGND VPWR VGND sky130_ef_sc_hd__decap_12
XFILLER_0_55_425 VPWR VGND VPWR VGND sky130_ef_sc_hd__decap_12
XFILLER_0_28_628 VGND VGND VPWR VPWR sky130_fd_sc_hd__fill_1
Xclkload26 clknet_leaf_8_clk VGND VGND VPWR VPWR clkload26/Y sky130_fd_sc_hd__inv_6
XFILLER_0_70_439 VPWR VGND VPWR VGND sky130_ef_sc_hd__decap_12
Xclkload15 clknet_leaf_33_clk VGND VGND VPWR VPWR clkload15/Y sky130_fd_sc_hd__inv_8
XFILLER_0_36_683 VGND VGND VPWR VPWR sky130_fd_sc_hd__fill_1
XFILLER_0_106_571 VGND VGND VPWR VPWR sky130_fd_sc_hd__fill_1
Xclkload37 clknet_leaf_20_clk VGND VGND VPWR VPWR clkload37/Y sky130_fd_sc_hd__inv_12
XFILLER_0_23_366 VGND VGND VPWR VPWR sky130_fd_sc_hd__decap_3
XFILLER_0_11_539 VGND VGND VPWR VPWR sky130_fd_sc_hd__fill_1
XFILLER_0_50_163 VGND VGND VPWR VPWR sky130_fd_sc_hd__decap_8
X_06750_ _01648_ _01649_ VGND VGND VPWR VPWR _01650_ sky130_fd_sc_hd__nand2b_2
X_06681_ _01502_ _01587_ _01588_ _01469_ mac_y_out[7] VGND VGND VPWR VPWR _00135_
+ sky130_fd_sc_hd__a32o_2
X_05701_ _04944_ _00677_ VGND VGND VPWR VPWR _00678_ sky130_fd_sc_hd__or2_2
XFILLER_0_116_53 VPWR VGND VPWR VGND sky130_ef_sc_hd__decap_12
XFILLER_0_25_51 VGND VGND VPWR VPWR sky130_fd_sc_hd__decap_4
X_05632_ _00616_ _00617_ VGND VGND VPWR VPWR _05632_/Y sky130_fd_sc_hd__xnor2_2
X_08420_ _03177_ _03179_ _03205_ VGND VGND VPWR VPWR _03206_ sky130_fd_sc_hd__o21a_2
XTAP_TAPCELL_ROW_47_851 VGND VPWR sky130_fd_sc_hd__tapvpwrvgnd_1
XFILLER_0_116_97 VPWR VGND VPWR VGND sky130_ef_sc_hd__decap_12
XFILLER_0_86_550 VGND VGND VPWR VPWR sky130_fd_sc_hd__decap_8
XFILLER_0_74_701 VGND VGND VPWR VPWR sky130_fd_sc_hd__decap_4
XFILLER_0_86_572 VPWR VGND VPWR VGND sky130_ef_sc_hd__decap_12
XTAP_TAPCELL_ROW_63_1053 VGND VPWR sky130_fd_sc_hd__tapvpwrvgnd_1
X_08351_ _03129_ _03138_ VGND VGND VPWR VPWR _03139_ sky130_fd_sc_hd__or2_2
X_05563_ _00540_ _00541_ _00551_ VGND VGND VPWR VPWR _00555_ sky130_fd_sc_hd__and3_2
XFILLER_0_73_244 VGND VGND VPWR VPWR sky130_fd_sc_hd__decap_8
XFILLER_0_73_233 VGND VGND VPWR VPWR sky130_fd_sc_hd__fill_2
XFILLER_0_73_222 VGND VGND VPWR VPWR sky130_fd_sc_hd__fill_2
X_07302_ tanh_inst.LOOKUP.index\[2\] _01476_ _02107_ _02061_ _01481_ VGND VGND VPWR
+ VPWR _02112_ sky130_fd_sc_hd__a32o_2
X_08282_ _03070_ _03071_ VGND VGND VPWR VPWR _03072_ sky130_fd_sc_hd__or2_2
X_05494_ mac_inst.y\[13\] _00491_ VGND VGND VPWR VPWR _00492_ sky130_fd_sc_hd__xnor2_2
X_07233_ tanh_inst.divider.y\[-14\] _02028_ _02029_ VGND VGND VPWR VPWR _02043_ sky130_fd_sc_hd__o21ai_2
XFILLER_0_27_661 VGND VGND VPWR VPWR sky130_fd_sc_hd__fill_2
XFILLER_0_33_108 VGND VGND VPWR VPWR sky130_fd_sc_hd__decap_4
XFILLER_0_33_119 VPWR VGND VPWR VGND sky130_ef_sc_hd__decap_12
Xclkload9 clknet_leaf_45_clk VGND VGND VPWR VPWR clkload9/Y sky130_fd_sc_hd__inv_6
X_07164_ _01981_ _01983_ VGND VGND VPWR VPWR _01984_ sky130_fd_sc_hd__nor2_2
XFILLER_0_14_333 VPWR VGND VPWR VGND sky130_ef_sc_hd__decap_12
XFILLER_0_42_642 VGND VGND VPWR VPWR sky130_fd_sc_hd__fill_2
X_06115_ tanh_inst.divider.y_\[-24\] _01061_ VGND VGND VPWR VPWR _01062_ sky130_fd_sc_hd__xnor2_2
X_07095_ tanh_inst.divider.z_\[-6\] _01092_ _01922_ _01088_ VGND VGND VPWR VPWR _00215_
+ sky130_fd_sc_hd__a22o_2
XFILLER_0_74_3 VPWR VGND VPWR VGND sky130_ef_sc_hd__decap_12
XFILLER_0_14_377 VGND VGND VPWR VPWR sky130_fd_sc_hd__decap_8
X_06046_ mac_inst.z\[28\] _00996_ VGND VGND VPWR VPWR _00997_ sky130_fd_sc_hd__nand2_2
XTAP_TAPCELL_ROW_74_1182 VGND VPWR sky130_fd_sc_hd__tapvpwrvgnd_1
XFILLER_0_1_293 VPWR VGND VPWR VGND sky130_ef_sc_hd__decap_12
XTAP_TAPCELL_ROW_74_1193 VGND VPWR sky130_fd_sc_hd__tapvpwrvgnd_1
X_07997_ tanh_inst.divider.y\[-11\] _02755_ _02753_ VGND VGND VPWR VPWR _02793_ sky130_fd_sc_hd__o21a_2
X_09805_ _04398_ _04399_ _04464_ _04526_ VGND VGND VPWR VPWR _04527_ sky130_fd_sc_hd__a211o_2
X_06948_ _04777_ _01035_ _01784_ VGND VGND VPWR VPWR _01791_ sky130_fd_sc_hd__o21a_2
X_09736_ _04408_ _04411_ _04459_ VGND VGND VPWR VPWR _04460_ sky130_fd_sc_hd__o21a_2
XFILLER_0_69_517 VPWR VGND VPWR VGND sky130_ef_sc_hd__decap_12
X_09667_ _04391_ _04392_ VGND VGND VPWR VPWR _04393_ sky130_fd_sc_hd__nor2_2
X_06879_ _01502_ _01761_ _01762_ _01469_ mac_y_out[31] VGND VGND VPWR VPWR _00159_
+ sky130_fd_sc_hd__a32o_2
X_08618_ _03350_ _03398_ _03399_ VGND VGND VPWR VPWR _03400_ sky130_fd_sc_hd__nor3_2
XFILLER_0_84_509 VGND VGND VPWR VPWR sky130_fd_sc_hd__decap_8
X_09598_ _04281_ _04325_ VGND VGND VPWR VPWR _04326_ sky130_fd_sc_hd__or2_2
XFILLER_0_77_561 VGND VGND VPWR VPWR sky130_fd_sc_hd__decap_4
X_08549_ _03330_ _03331_ VGND VGND VPWR VPWR _03332_ sky130_fd_sc_hd__nor2_2
XFILLER_0_64_211 VGND VGND VPWR VPWR sky130_fd_sc_hd__decap_8
XFILLER_0_49_285 VGND VGND VPWR VPWR sky130_fd_sc_hd__fill_1
XFILLER_0_92_520 VPWR VGND VPWR VGND sky130_ef_sc_hd__decap_12
XFILLER_0_64_244 VGND VGND VPWR VPWR sky130_fd_sc_hd__fill_1
XTAP_TAPCELL_ROW_25_578 VGND VPWR sky130_fd_sc_hd__tapvpwrvgnd_1
XFILLER_0_37_447 VGND VGND VPWR VPWR sky130_fd_sc_hd__fill_1
XFILLER_0_49_296 VGND VGND VPWR VPWR sky130_fd_sc_hd__decap_8
XFILLER_0_64_266 VGND VGND VPWR VPWR sky130_fd_sc_hd__fill_1
XFILLER_0_52_428 VPWR VGND VPWR VGND sky130_ef_sc_hd__decap_12
X_10442_ clknet_leaf_26_clk _00299_ VGND VGND VPWR VPWR tanh_inst.divider.y\[-22\]
+ sky130_fd_sc_hd__dfxtp_2
XFILLER_0_17_193 VPWR VGND VPWR VGND sky130_ef_sc_hd__decap_12
XFILLER_0_32_141 VGND VGND VPWR VPWR sky130_fd_sc_hd__fill_1
XFILLER_0_33_664 VGND VGND VPWR VPWR sky130_fd_sc_hd__decap_8
X_10373_ clknet_leaf_25_clk _00230_ VGND VGND VPWR VPWR tanh_inst.IS_FIRST13 sky130_fd_sc_hd__dfxtp_2
XFILLER_0_32_163 VGND VGND VPWR VPWR sky130_fd_sc_hd__decap_4
XFILLER_0_87_303 VGND VGND VPWR VPWR sky130_fd_sc_hd__decap_6
XTAP_TAPCELL_ROW_44_810 VGND VPWR sky130_fd_sc_hd__tapvpwrvgnd_1
XFILLER_0_56_701 VGND VGND VPWR VPWR sky130_fd_sc_hd__decap_4
XFILLER_0_70_225 VGND VGND VPWR VPWR sky130_fd_sc_hd__fill_1
XFILLER_0_43_439 VGND VGND VPWR VPWR sky130_fd_sc_hd__decap_8
XFILLER_0_102_77 VGND VGND VPWR VPWR sky130_fd_sc_hd__decap_6
XFILLER_0_87_24 VPWR VGND VPWR VGND sky130_ef_sc_hd__decap_12
XFILLER_0_23_163 VGND VGND VPWR VPWR sky130_fd_sc_hd__decap_4
XFILLER_0_24_697 VGND VGND VPWR VPWR sky130_fd_sc_hd__decap_3
XFILLER_0_51_472 VGND VGND VPWR VPWR sky130_fd_sc_hd__fill_1
XFILLER_0_121_360 VGND VGND VPWR VPWR sky130_fd_sc_hd__decap_4
XFILLER_0_87_68 VGND VGND VPWR VPWR sky130_fd_sc_hd__fill_1
XFILLER_0_51_494 VGND VGND VPWR VPWR sky130_fd_sc_hd__decap_8
XFILLER_0_121_393 VPWR VGND VPWR VGND sky130_ef_sc_hd__decap_12
X_07920_ _02548_ _02549_ _02582_ _02714_ VGND VGND VPWR VPWR _02718_ sky130_fd_sc_hd__or4b_2
XTAP_TAPCELL_ROW_110_1636 VGND VPWR sky130_fd_sc_hd__tapvpwrvgnd_1
X_07851_ _02573_ _02650_ _02606_ VGND VGND VPWR VPWR _02651_ sky130_fd_sc_hd__o21ai_2
X_07782_ _02547_ _02550_ _02548_ VGND VGND VPWR VPWR _02583_ sky130_fd_sc_hd__a21oi_2
X_06802_ _01502_ _01695_ _01696_ _01469_ mac_y_out[20] VGND VGND VPWR VPWR _00148_
+ sky130_fd_sc_hd__a32o_2
X_09521_ _03964_ _04002_ _04106_ _04250_ VGND VGND VPWR VPWR _04251_ sky130_fd_sc_hd__and4_2
X_06733_ _01633_ _01634_ VGND VGND VPWR VPWR _01635_ sky130_fd_sc_hd__nand2_2
X_09452_ _04182_ _04183_ VGND VGND VPWR VPWR _04184_ sky130_fd_sc_hd__or2_2
X_06664_ _01547_ tanh_inst.z_\[7\] _01572_ VGND VGND VPWR VPWR _01573_ sky130_fd_sc_hd__mux2_1
X_06595_ _01489_ _01508_ VGND VGND VPWR VPWR _01509_ sky130_fd_sc_hd__or2_2
XFILLER_0_59_561 VGND VGND VPWR VPWR sky130_fd_sc_hd__decap_3
X_09383_ _04046_ _04078_ VGND VGND VPWR VPWR _04117_ sky130_fd_sc_hd__and2_2
X_05615_ _00599_ _00601_ VGND VGND VPWR VPWR _00602_ sky130_fd_sc_hd__xor2_2
X_08403_ _03189_ VGND VGND VPWR VPWR _03190_ sky130_fd_sc_hd__inv_2
XTAP_TAPCELL_ROW_121_1776 VGND VPWR sky130_fd_sc_hd__tapvpwrvgnd_1
XFILLER_0_19_447 VGND VGND VPWR VPWR sky130_fd_sc_hd__fill_1
X_08334_ tanh_inst.divider.x\[-2\] _03121_ VGND VGND VPWR VPWR _03122_ sky130_fd_sc_hd__nand2_2
X_05546_ _04911_ _05019_ _00509_ VGND VGND VPWR VPWR _00539_ sky130_fd_sc_hd__a21o_2
XFILLER_0_52_82 VGND VGND VPWR VPWR sky130_fd_sc_hd__fill_2
XTAP_TAPCELL_ROW_121_1787 VGND VPWR sky130_fd_sc_hd__tapvpwrvgnd_1
XFILLER_0_116_121 VPWR VGND VPWR VGND sky130_ef_sc_hd__decap_12
XTAP_TAPCELL_ROW_22_537 VGND VPWR sky130_fd_sc_hd__tapvpwrvgnd_1
XFILLER_0_46_277 VGND VGND VPWR VPWR sky130_fd_sc_hd__decap_8
XFILLER_0_61_225 VGND VGND VPWR VPWR sky130_fd_sc_hd__decap_8
X_05477_ _00461_ _00474_ _00475_ VGND VGND VPWR VPWR _00476_ sky130_fd_sc_hd__a21o_2
X_08265_ _03050_ _03052_ _03054_ VGND VGND VPWR VPWR _03055_ sky130_fd_sc_hd__and3_2
X_07216_ _01512_ _01522_ VGND VGND VPWR VPWR _02026_ sky130_fd_sc_hd__nor2_2
XFILLER_0_14_141 VPWR VGND VPWR VGND sky130_ef_sc_hd__decap_12
XFILLER_0_6_363 VGND VGND VPWR VPWR sky130_fd_sc_hd__fill_1
X_08196_ _02822_ _02913_ _02987_ tanh_inst.z_\[7\] VGND VGND VPWR VPWR _02988_ sky130_fd_sc_hd__a31o_2
X_07147_ tanh_inst.divider.z_\[-1\] _01960_ _01950_ VGND VGND VPWR VPWR _01969_ sky130_fd_sc_hd__o21ai_2
XTAP_TAPCELL_ROW_76_1211 VGND VPWR sky130_fd_sc_hd__tapvpwrvgnd_1
XPHY_EDGE_ROW_5_Left_127 VGND VGND VPWR VPWR sky130_fd_sc_hd__decap_3
XFILLER_0_100_533 VGND VGND VPWR VPWR sky130_fd_sc_hd__fill_1
X_07078_ _01906_ _01907_ tanh_inst.divider.z_\[-8\] _01092_ VGND VGND VPWR VPWR _00213_
+ sky130_fd_sc_hd__a2bb2o_2
XFILLER_0_2_580 VGND VGND VPWR VPWR sky130_fd_sc_hd__decap_8
X_06029_ _00938_ _00973_ _00974_ VGND VGND VPWR VPWR _00982_ sky130_fd_sc_hd__a21bo_2
XFILLER_0_97_612 VGND VGND VPWR VPWR sky130_fd_sc_hd__decap_4
XTAP_TAPCELL_ROW_87_1351 VGND VPWR sky130_fd_sc_hd__tapvpwrvgnd_1
X_09719_ _04377_ _04442_ _04430_ VGND VGND VPWR VPWR _04443_ sky130_fd_sc_hd__o21a_2
XFILLER_0_96_155 VGND VGND VPWR VPWR sky130_fd_sc_hd__fill_1
XTAP_TAPCELL_ROW_2_284 VGND VPWR sky130_fd_sc_hd__tapvpwrvgnd_1
XFILLER_0_38_701 VGND VGND VPWR VPWR sky130_fd_sc_hd__fill_2
XFILLER_0_37_222 VGND VGND VPWR VPWR sky130_fd_sc_hd__fill_2
XFILLER_0_92_383 VGND VGND VPWR VPWR sky130_fd_sc_hd__decap_3
XTAP_TAPCELL_ROW_98_1491 VGND VPWR sky130_fd_sc_hd__tapvpwrvgnd_1
X_10425_ clknet_leaf_37_clk _00282_ _00000_ VGND VGND VPWR VPWR mac_inst.i\[17\] sky130_fd_sc_hd__dfrtp_2
XFILLER_0_33_483 VGND VGND VPWR VPWR sky130_fd_sc_hd__fill_1
XFILLER_0_20_133 VGND VGND VPWR VPWR sky130_fd_sc_hd__decap_6
XFILLER_0_103_393 VGND VGND VPWR VPWR sky130_fd_sc_hd__fill_2
X_10356_ clknet_leaf_21_clk _00213_ VGND VGND VPWR VPWR tanh_inst.divider.z_\[-8\]
+ sky130_fd_sc_hd__dfxtp_2
XFILLER_0_57_27 VPWR VGND VPWR VGND sky130_ef_sc_hd__decap_12
XFILLER_0_20_177 VPWR VGND VPWR VGND sky130_ef_sc_hd__decap_12
X_10287_ clknet_leaf_27_clk _00144_ VGND VGND VPWR VPWR tanh_inst.z_\[-8\] sky130_fd_sc_hd__dfxtp_2
XFILLER_0_87_100 VGND VGND VPWR VPWR sky130_fd_sc_hd__fill_1
XFILLER_0_7_105 VGND VGND VPWR VPWR sky130_fd_sc_hd__decap_6
X_05400_ _00403_ _00404_ VGND VGND VPWR VPWR _00405_ sky130_fd_sc_hd__xnor2_2
X_06380_ tanh_inst.divider.i\[4\] _01073_ _01289_ VGND VGND VPWR VPWR _01310_ sky130_fd_sc_hd__o21a_2
XFILLER_0_90_309 VGND VGND VPWR VPWR sky130_fd_sc_hd__fill_2
XTAP_TAPCELL_ROW_60_1012 VGND VPWR sky130_fd_sc_hd__tapvpwrvgnd_1
XFILLER_0_56_564 VGND VGND VPWR VPWR sky130_fd_sc_hd__fill_1
XFILLER_0_22_41 VPWR VGND VPWR VGND sky130_ef_sc_hd__decap_12
XFILLER_0_71_523 VGND VGND VPWR VPWR sky130_fd_sc_hd__decap_6
XFILLER_0_7_149 VPWR VGND VPWR VGND sky130_ef_sc_hd__decap_12
XFILLER_0_22_85 VPWR VGND VPWR VGND sky130_ef_sc_hd__decap_12
X_05331_ _04836_ _05019_ _05021_ _05029_ VGND VGND VPWR VPWR _05030_ sky130_fd_sc_hd__o211ai_2
XFILLER_0_113_113 VPWR VGND VPWR VGND sky130_ef_sc_hd__decap_12
X_08050_ _02843_ _02844_ VGND VGND VPWR VPWR _02845_ sky130_fd_sc_hd__and2b_2
X_05262_ _04845_ _04960_ _04961_ _04962_ _04959_ VGND VGND VPWR VPWR _04963_ sky130_fd_sc_hd__a221o_2
X_07001_ tanh_inst.divider.z_\[-16\] _01832_ _01838_ VGND VGND VPWR VPWR _01839_ sky130_fd_sc_hd__and3_2
XFILLER_0_71_589 VGND VGND VPWR VPWR sky130_fd_sc_hd__fill_1
XFILLER_0_12_645 VPWR VGND VPWR VGND sky130_ef_sc_hd__decap_12
XFILLER_0_11_111 VGND VGND VPWR VPWR sky130_fd_sc_hd__fill_1
X_05193_ mac_inst.x\[15\] _04852_ _04853_ VGND VGND VPWR VPWR _04897_ sky130_fd_sc_hd__a21oi_2
XFILLER_0_12_689 VGND VGND VPWR VPWR sky130_fd_sc_hd__decap_8
X_08952_ _03694_ _03695_ VGND VGND VPWR VPWR _03696_ sky130_fd_sc_hd__xor2_2
X_07903_ _02699_ _02700_ VGND VGND VPWR VPWR _02701_ sky130_fd_sc_hd__and2_2
X_08883_ _04791_ _03627_ VGND VGND VPWR VPWR _03628_ sky130_fd_sc_hd__nand2_2
XTAP_TAPCELL_ROW_71_1152 VGND VPWR sky130_fd_sc_hd__tapvpwrvgnd_1
X_07834_ _02613_ _02632_ VGND VGND VPWR VPWR _02634_ sky130_fd_sc_hd__xnor2_2
XFILLER_0_37_3 VPWR VGND VPWR VGND sky130_ef_sc_hd__decap_12
X_07765_ tanh_inst.LOOKUP.index\[4\] _02565_ _02566_ VGND VGND VPWR VPWR _02567_ sky130_fd_sc_hd__a21bo_2
X_07696_ tanh_inst.divider.y\[-17\] tanh_inst.divider.x\[-17\] VGND VGND VPWR VPWR
+ _02499_ sky130_fd_sc_hd__nand2_2
XTAP_TAPCELL_ROW_55_949 VGND VPWR sky130_fd_sc_hd__tapvpwrvgnd_1
X_09504_ _04232_ _04233_ VGND VGND VPWR VPWR _04234_ sky130_fd_sc_hd__or2_2
X_06716_ _01617_ _01618_ _01502_ VGND VGND VPWR VPWR _01620_ sky130_fd_sc_hd__o21a_2
X_09435_ tanh_inst.divider.y\[-10\] _04165_ VGND VGND VPWR VPWR _04167_ sky130_fd_sc_hd__xnor2_2
X_06647_ tanh_inst.z_\[-20\] _01557_ VGND VGND VPWR VPWR _01558_ sky130_fd_sc_hd__and2_2
XFILLER_0_66_317 VGND VGND VPWR VPWR sky130_fd_sc_hd__fill_2
XFILLER_0_63_92 VGND VGND VPWR VPWR sky130_fd_sc_hd__fill_1
XFILLER_0_109_419 VGND VGND VPWR VPWR sky130_fd_sc_hd__fill_2
X_09366_ tanh_inst.divider.x\[-12\] _04099_ VGND VGND VPWR VPWR _04100_ sky130_fd_sc_hd__and2b_2
XTAP_TAPCELL_ROW_82_1292 VGND VPWR sky130_fd_sc_hd__tapvpwrvgnd_1
XTAP_TAPCELL_ROW_82_1281 VGND VPWR sky130_fd_sc_hd__tapvpwrvgnd_1
X_06578_ tanh_inst.z_\[5\] tanh_inst.z_\[4\] tanh_inst.z_\[7\] tanh_inst.z_\[6\] VGND
+ VGND VPWR VPWR _01493_ sky130_fd_sc_hd__or4_2
XTAP_TAPCELL_ROW_35_695 VGND VPWR sky130_fd_sc_hd__tapvpwrvgnd_1
X_09297_ _04029_ _04031_ VGND VGND VPWR VPWR _04033_ sky130_fd_sc_hd__and2_2
XFILLER_0_62_512 VPWR VGND VPWR VGND sky130_ef_sc_hd__decap_12
X_08317_ _03058_ _03065_ _03104_ tanh_inst.z_\[7\] VGND VGND VPWR VPWR _03106_ sky130_fd_sc_hd__a31o_2
X_05529_ _00465_ _00466_ _00523_ VGND VGND VPWR VPWR _00524_ sky130_fd_sc_hd__and3_2
XFILLER_0_117_496 VGND VGND VPWR VPWR sky130_fd_sc_hd__decap_8
XFILLER_0_117_485 VGND VGND VPWR VPWR sky130_fd_sc_hd__fill_2
XFILLER_0_117_474 VGND VGND VPWR VPWR sky130_fd_sc_hd__decap_3
X_08248_ _02962_ _03012_ _03013_ VGND VGND VPWR VPWR _03038_ sky130_fd_sc_hd__or3_2
XFILLER_0_104_113 VGND VGND VPWR VPWR sky130_fd_sc_hd__fill_1
XFILLER_0_62_589 VGND VGND VPWR VPWR sky130_fd_sc_hd__decap_6
XFILLER_0_104_179 VGND VGND VPWR VPWR sky130_fd_sc_hd__decap_8
X_10210_ clknet_leaf_22_clk mac_inst.y\[4\] _00000_ VGND VGND VPWR VPWR mac_y_out[4]
+ sky130_fd_sc_hd__dfrtp_2
XFILLER_0_15_483 VPWR VGND VPWR VGND sky130_ef_sc_hd__decap_12
X_08179_ tanh_inst.divider.y\[-6\] tanh_inst.divider.x\[-6\] VGND VGND VPWR VPWR _02971_
+ sky130_fd_sc_hd__nand2_2
XFILLER_0_30_442 VGND VGND VPWR VPWR sky130_fd_sc_hd__decap_6
XFILLER_0_112_190 VGND VGND VPWR VPWR sky130_fd_sc_hd__decap_6
X_10072_ clknet_leaf_13_clk _00089_ VGND VGND VPWR VPWR tanh_inst.divider.y_\[-21\]
+ sky130_fd_sc_hd__dfxtp_2
XTAP_TAPCELL_ROW_7_354 VGND VPWR sky130_fd_sc_hd__tapvpwrvgnd_1
XFILLER_0_97_420 VGND VGND VPWR VPWR sky130_fd_sc_hd__fill_1
XFILLER_0_69_111 VGND VGND VPWR VPWR sky130_fd_sc_hd__fill_1
XFILLER_0_97_442 VGND VGND VPWR VPWR sky130_fd_sc_hd__decap_6
XFILLER_0_84_136 VGND VGND VPWR VPWR sky130_fd_sc_hd__decap_4
XFILLER_0_38_531 VGND VGND VPWR VPWR sky130_fd_sc_hd__fill_1
XFILLER_0_108_452 VGND VGND VPWR VPWR sky130_fd_sc_hd__fill_1
XFILLER_0_65_361 VPWR VGND VPWR VGND sky130_ef_sc_hd__decap_12
XFILLER_0_25_225 VPWR VGND VPWR VGND sky130_ef_sc_hd__decap_12
XFILLER_0_111_617 VGND VGND VPWR VPWR sky130_fd_sc_hd__decap_4
XFILLER_0_68_15 VPWR VGND VPWR VGND sky130_ef_sc_hd__decap_12
XFILLER_0_40_228 VGND VGND VPWR VPWR sky130_fd_sc_hd__decap_3
X_10408_ clknet_leaf_36_clk _00265_ _00000_ VGND VGND VPWR VPWR mac_inst.i\[0\] sky130_fd_sc_hd__dfrtp_2
X_10339_ clknet_leaf_16_clk _00196_ VGND VGND VPWR VPWR tanh_out[31] sky130_fd_sc_hd__dfxtp_2
XFILLER_0_84_58 VPWR VGND VPWR VGND sky130_ef_sc_hd__decap_12
X_05880_ _00842_ _00843_ VGND VGND VPWR VPWR _00844_ sky130_fd_sc_hd__and2b_2
XFILLER_0_108_65 VPWR VGND VPWR VGND sky130_ef_sc_hd__decap_12
X_07550_ tanh_inst.divider.y\[-20\] tanh_inst.divider.x\[-20\] VGND VGND VPWR VPWR
+ _02356_ sky130_fd_sc_hd__or2_2
XFILLER_0_88_442 VGND VGND VPWR VPWR sky130_fd_sc_hd__fill_1
X_06501_ _04776_ _01238_ _01289_ VGND VGND VPWR VPWR _01421_ sky130_fd_sc_hd__a21boi_2
XFILLER_0_76_615 VPWR VGND VPWR VGND sky130_ef_sc_hd__decap_12
XTAP_TAPCELL_ROW_52_908 VGND VPWR sky130_fd_sc_hd__tapvpwrvgnd_1
XFILLER_0_119_706 VGND VGND VPWR VPWR sky130_fd_sc_hd__fill_1
X_09220_ _03956_ _03957_ VGND VGND VPWR VPWR _03958_ sky130_fd_sc_hd__or2_2
XTAP_TAPCELL_ROW_105_1579 VGND VPWR sky130_fd_sc_hd__tapvpwrvgnd_1
X_07481_ _02053_ _02276_ _02279_ _02287_ VGND VGND VPWR VPWR _02288_ sky130_fd_sc_hd__o31ai_2
X_06432_ _01300_ _01332_ _01333_ _01342_ VGND VGND VPWR VPWR _01358_ sky130_fd_sc_hd__nand4_2
XFILLER_0_75_169 VGND VGND VPWR VPWR sky130_fd_sc_hd__decap_8
X_06363_ _01293_ _01294_ VGND VGND VPWR VPWR _01295_ sky130_fd_sc_hd__and2b_2
X_09151_ _03801_ _03805_ _03836_ _03889_ _03835_ VGND VGND VPWR VPWR _03891_ sky130_fd_sc_hd__a311o_2
XFILLER_0_90_139 VGND VGND VPWR VPWR sky130_fd_sc_hd__fill_1
XPHY_EDGE_ROW_86_Left_208 VGND VGND VPWR VPWR sky130_fd_sc_hd__decap_3
XFILLER_0_84_681 VGND VGND VPWR VPWR sky130_fd_sc_hd__fill_1
XFILLER_0_56_361 VGND VGND VPWR VPWR sky130_fd_sc_hd__decap_3
XFILLER_0_8_469 VGND VGND VPWR VPWR sky130_fd_sc_hd__decap_6
XTAP_TAPCELL_ROW_32_665 VGND VPWR sky130_fd_sc_hd__tapvpwrvgnd_1
XFILLER_0_44_501 VGND VGND VPWR VPWR sky130_fd_sc_hd__decap_8
XFILLER_0_44_523 VGND VGND VPWR VPWR sky130_fd_sc_hd__fill_1
X_08102_ _02837_ _02853_ _02810_ VGND VGND VPWR VPWR _02896_ sky130_fd_sc_hd__o21a_2
X_09082_ _03821_ _03822_ VGND VGND VPWR VPWR _03824_ sky130_fd_sc_hd__nand2_2
XFILLER_0_71_342 VPWR VGND VPWR VGND sky130_ef_sc_hd__decap_12
XFILLER_0_56_394 VGND VGND VPWR VPWR sky130_fd_sc_hd__fill_1
X_05314_ _04871_ _04872_ _04874_ _04876_ _04783_ mac_inst.i\[1\] VGND VGND VPWR VPWR
+ _05013_ sky130_fd_sc_hd__mux4_2
X_06294_ tanh_inst.divider.y_\[7\] _01230_ VGND VGND VPWR VPWR _01231_ sky130_fd_sc_hd__nor2_2
XFILLER_0_114_433 VPWR VGND VPWR VGND sky130_ef_sc_hd__decap_12
X_08033_ _02825_ _02828_ VGND VGND VPWR VPWR _02829_ sky130_fd_sc_hd__nand2_2
XFILLER_0_44_589 VGND VGND VPWR VPWR sky130_fd_sc_hd__decap_4
XFILLER_0_114_455 VGND VGND VPWR VPWR sky130_fd_sc_hd__decap_6
XFILLER_0_4_664 VGND VGND VPWR VPWR sky130_fd_sc_hd__fill_2
X_05245_ _04840_ _04848_ _04851_ _04938_ VGND VGND VPWR VPWR _04946_ sky130_fd_sc_hd__or4_2
XFILLER_0_101_127 VGND VGND VPWR VPWR sky130_fd_sc_hd__decap_4
XFILLER_0_12_453 VGND VGND VPWR VPWR sky130_fd_sc_hd__fill_1
XFILLER_0_4_697 VGND VGND VPWR VPWR sky130_fd_sc_hd__decap_3
X_05176_ _04783_ _04790_ _04852_ _04878_ _04789_ VGND VGND VPWR VPWR _04880_ sky130_fd_sc_hd__a311oi_2
XFILLER_0_12_497 VGND VGND VPWR VPWR sky130_fd_sc_hd__decap_6
X_09984_ _04633_ _04643_ _04645_ _04646_ _04642_ VGND VGND VPWR VPWR _04701_ sky130_fd_sc_hd__o41ai_2
X_08935_ _03544_ _03554_ _03556_ _03545_ tanh_inst.LOOKUP.index\[1\] tanh_inst.LOOKUP.index\[0\]
+ VGND VGND VPWR VPWR _03679_ sky130_fd_sc_hd__mux4_2
XPHY_EDGE_ROW_95_Left_217 VGND VGND VPWR VPWR sky130_fd_sc_hd__decap_3
XTAP_TAPCELL_ROW_4_313 VGND VPWR sky130_fd_sc_hd__tapvpwrvgnd_1
X_08866_ _02022_ _03609_ _03610_ VGND VGND VPWR VPWR _03611_ sky130_fd_sc_hd__o21a_2
X_07817_ _04766_ _02616_ VGND VGND VPWR VPWR _02617_ sky130_fd_sc_hd__xnor2_2
X_08797_ tanh_inst.divider.x\[7\] _03541_ _03542_ _03539_ _04761_ _04760_ VGND VGND
+ VPWR VPWR _03543_ sky130_fd_sc_hd__mux4_2
X_07748_ _02548_ _02549_ VGND VGND VPWR VPWR _02550_ sky130_fd_sc_hd__nor2_2
XTAP_TAPCELL_ROW_84_1310 VGND VPWR sky130_fd_sc_hd__tapvpwrvgnd_1
X_07679_ _02465_ _02482_ _02014_ VGND VGND VPWR VPWR _02483_ sky130_fd_sc_hd__o21ai_2
XFILLER_0_66_125 VGND VGND VPWR VPWR sky130_fd_sc_hd__decap_6
XFILLER_0_94_456 VGND VGND VPWR VPWR sky130_fd_sc_hd__decap_4
XFILLER_0_82_618 VGND VGND VPWR VPWR sky130_fd_sc_hd__decap_4
X_09418_ _04757_ _04149_ _04150_ VGND VGND VPWR VPWR _04151_ sky130_fd_sc_hd__o21ai_2
XFILLER_0_94_489 VPWR VGND VPWR VGND sky130_ef_sc_hd__decap_12
X_09349_ _04050_ _04055_ _04082_ _02019_ VGND VGND VPWR VPWR _04084_ sky130_fd_sc_hd__a31oi_2
XFILLER_0_35_545 VPWR VGND VPWR VGND sky130_ef_sc_hd__decap_12
XFILLER_0_105_444 VGND VGND VPWR VPWR sky130_fd_sc_hd__decap_4
XFILLER_0_105_499 VGND VGND VPWR VPWR sky130_fd_sc_hd__decap_4
XTAP_TAPCELL_ROW_95_1450 VGND VPWR sky130_fd_sc_hd__tapvpwrvgnd_1
XFILLER_0_101_683 VGND VGND VPWR VPWR sky130_fd_sc_hd__decap_6
XFILLER_0_38_29 VGND VGND VPWR VPWR sky130_fd_sc_hd__fill_1
XFILLER_0_100_182 VPWR VGND VPWR VGND sky130_ef_sc_hd__decap_12
X_10055_ rst VGND VGND VPWR VPWR _00074_ sky130_fd_sc_hd__inv_2
XFILLER_0_89_239 VGND VGND VPWR VPWR sky130_fd_sc_hd__decap_4
XFILLER_0_97_294 VGND VGND VPWR VPWR sky130_fd_sc_hd__fill_1
XFILLER_0_57_169 VGND VGND VPWR VPWR sky130_fd_sc_hd__decap_6
XFILLER_0_115_219 VGND VGND VPWR VPWR sky130_fd_sc_hd__decap_4
XFILLER_0_81_673 VGND VGND VPWR VPWR sky130_fd_sc_hd__fill_1
XFILLER_0_26_589 VGND VGND VPWR VPWR sky130_fd_sc_hd__fill_2
XFILLER_0_79_69 VGND VGND VPWR VPWR sky130_fd_sc_hd__decap_4
XFILLER_0_13_217 VGND VGND VPWR VPWR sky130_fd_sc_hd__decap_6
XFILLER_0_111_425 VGND VGND VPWR VPWR sky130_fd_sc_hd__decap_8
XFILLER_0_110_77 VGND VGND VPWR VPWR sky130_fd_sc_hd__decap_6
XFILLER_0_21_261 VPWR VGND VPWR VGND sky130_ef_sc_hd__decap_12
XFILLER_0_95_57 VPWR VGND VPWR VGND sky130_ef_sc_hd__decap_12
X_06981_ tanh_inst.divider.z_\[-18\] _01820_ VGND VGND VPWR VPWR _01821_ sky130_fd_sc_hd__nand2_2
X_05932_ mac_inst.z\[31\] _00876_ _00880_ _00889_ VGND VGND VPWR VPWR _00892_ sky130_fd_sc_hd__o211ai_2
X_08720_ mac_inst.i\[6\] _00954_ _00956_ mac_inst.i\[7\] VGND VGND VPWR VPWR _03491_
+ sky130_fd_sc_hd__a31o_2
X_05863_ mac_inst.z\[14\] _00826_ VGND VGND VPWR VPWR _00828_ sky130_fd_sc_hd__or2_2
X_08651_ _03350_ _03396_ _03398_ _03399_ _03395_ VGND VGND VPWR VPWR _03432_ sky130_fd_sc_hd__o41ai_2
X_07602_ _02405_ _02406_ VGND VGND VPWR VPWR _02407_ sky130_fd_sc_hd__nand2_2
XTAP_TAPCELL_ROW_37_724 VGND VPWR sky130_fd_sc_hd__tapvpwrvgnd_1
X_08582_ _03327_ _03330_ _03363_ VGND VGND VPWR VPWR _03364_ sky130_fd_sc_hd__o21a_2
X_05794_ _04944_ _00665_ _00760_ VGND VGND VPWR VPWR _00764_ sky130_fd_sc_hd__or3_2
XFILLER_0_119_503 VGND VGND VPWR VPWR sky130_fd_sc_hd__fill_1
X_07533_ _02024_ _02049_ VGND VGND VPWR VPWR _02339_ sky130_fd_sc_hd__nand2_2
XFILLER_0_44_83 VGND VGND VPWR VPWR sky130_fd_sc_hd__fill_1
XFILLER_0_119_536 VGND VGND VPWR VPWR sky130_fd_sc_hd__decap_3
X_07464_ _02030_ _02090_ _02092_ _02094_ tanh_inst.LOOKUP.index\[0\] _04760_ VGND
+ VGND VPWR VPWR _02271_ sky130_fd_sc_hd__mux4_2
XTAP_TAPCELL_ROW_66_1084 VGND VPWR sky130_fd_sc_hd__tapvpwrvgnd_1
XTAP_TAPCELL_ROW_17_470 VGND VPWR sky130_fd_sc_hd__tapvpwrvgnd_1
XFILLER_0_36_309 VGND VGND VPWR VPWR sky130_fd_sc_hd__decap_4
XFILLER_0_48_158 VGND VGND VPWR VPWR sky130_fd_sc_hd__decap_3
X_06415_ tanh_inst.divider.i\[4\] _01140_ _01289_ VGND VGND VPWR VPWR _01342_ sky130_fd_sc_hd__o21ai_2
XFILLER_0_91_426 VPWR VGND VPWR VGND sky130_ef_sc_hd__decap_12
XFILLER_0_63_106 VGND VGND VPWR VPWR sky130_fd_sc_hd__decap_6
XFILLER_0_8_233 VPWR VGND VPWR VGND sky130_ef_sc_hd__decap_12
XFILLER_0_17_501 VGND VGND VPWR VPWR sky130_fd_sc_hd__decap_3
X_09203_ _03757_ _03768_ _04759_ VGND VGND VPWR VPWR _03942_ sky130_fd_sc_hd__mux2_1
X_09134_ _03677_ _03679_ _02025_ VGND VGND VPWR VPWR _03874_ sky130_fd_sc_hd__mux2_1
X_07395_ tanh_inst.divider.x\[-22\] _02015_ VGND VGND VPWR VPWR _02203_ sky130_fd_sc_hd__nand2_2
XFILLER_0_8_277 VPWR VGND VPWR VGND sky130_ef_sc_hd__decap_12
XTAP_TAPCELL_ROW_118_1737 VGND VPWR sky130_fd_sc_hd__tapvpwrvgnd_1
X_06346_ _01039_ _01173_ _01277_ _04776_ _01278_ VGND VGND VPWR VPWR _01279_ sky130_fd_sc_hd__o221a_2
XFILLER_0_71_150 VPWR VGND VPWR VGND sky130_ef_sc_hd__decap_12
X_06277_ tanh_inst.divider.i\[3\] _01072_ _01187_ VGND VGND VPWR VPWR _01215_ sky130_fd_sc_hd__o21ai_2
X_09065_ _03804_ _03806_ _02019_ _03800_ VGND VGND VPWR VPWR _03807_ sky130_fd_sc_hd__o211a_2
X_08016_ _02810_ _02811_ VGND VGND VPWR VPWR _02812_ sky130_fd_sc_hd__nand2_2
X_05228_ tanh_counter\[3\] tanh_counter\[2\] tanh_counter\[1\] tanh_counter\[4\] tanh_counter\[5\]
+ VGND VGND VPWR VPWR _04930_ sky130_fd_sc_hd__o311a_2
XFILLER_0_8_83 VGND VGND VPWR VPWR sky130_fd_sc_hd__fill_1
X_05159_ mac_inst.x\[21\] _04852_ _04853_ VGND VGND VPWR VPWR _04863_ sky130_fd_sc_hd__a21o_2
XFILLER_0_110_491 VGND VGND VPWR VPWR sky130_fd_sc_hd__fill_2
X_09967_ _04680_ _04683_ VGND VGND VPWR VPWR _04684_ sky130_fd_sc_hd__or2_2
XTAP_TAPCELL_ROW_90_1391 VGND VPWR sky130_fd_sc_hd__tapvpwrvgnd_1
X_08918_ tanh_inst.divider.y\[-24\] _03658_ VGND VGND VPWR VPWR _03663_ sky130_fd_sc_hd__or2_2
X_09898_ _04615_ _04616_ VGND VGND VPWR VPWR _04617_ sky130_fd_sc_hd__or2_2
X_08849_ _02028_ _03593_ _03508_ VGND VGND VPWR VPWR _03594_ sky130_fd_sc_hd__o21ai_2
XFILLER_0_67_401 VGND VGND VPWR VPWR sky130_fd_sc_hd__decap_6
XFILLER_0_94_242 VGND VGND VPWR VPWR sky130_fd_sc_hd__decap_8
XFILLER_0_39_136 VGND VGND VPWR VPWR sky130_fd_sc_hd__decap_8
XFILLER_0_94_286 VGND VGND VPWR VPWR sky130_fd_sc_hd__decap_3
XFILLER_0_39_169 VGND VGND VPWR VPWR sky130_fd_sc_hd__decap_3
XFILLER_0_47_191 VGND VGND VPWR VPWR sky130_fd_sc_hd__fill_1
XFILLER_0_63_673 VGND VGND VPWR VPWR sky130_fd_sc_hd__decap_4
XFILLER_0_35_364 VGND VGND VPWR VPWR sky130_fd_sc_hd__decap_4
XFILLER_0_63_695 VGND VGND VPWR VPWR sky130_fd_sc_hd__fill_1
XFILLER_0_2_409 VGND VGND VPWR VPWR sky130_fd_sc_hd__fill_2
XFILLER_0_23_526 VPWR VGND VPWR VGND sky130_ef_sc_hd__decap_12
XFILLER_0_50_323 VGND VGND VPWR VPWR sky130_fd_sc_hd__fill_1
XFILLER_0_105_274 VGND VGND VPWR VPWR sky130_fd_sc_hd__decap_6
XFILLER_0_120_233 VPWR VGND VPWR VGND sky130_ef_sc_hd__decap_12
XFILLER_0_10_209 VPWR VGND VPWR VGND sky130_ef_sc_hd__decap_12
XFILLER_0_120_277 VPWR VGND VPWR VGND sky130_ef_sc_hd__decap_12
XFILLER_0_101_491 VPWR VGND VPWR VGND sky130_ef_sc_hd__decap_12
XFILLER_0_65_38 VGND VGND VPWR VPWR sky130_fd_sc_hd__decap_8
XFILLER_0_65_27 VGND VGND VPWR VPWR sky130_fd_sc_hd__decap_6
X_10107_ clknet_leaf_33_clk _00124_ _00074_ VGND VGND VPWR VPWR mac_counter\[6\] sky130_fd_sc_hd__dfrtp_2
X_10038_ tanh_inst.LOOKUP.index\[0\] _04748_ tanh_inst.LOOKUP.index\[1\] VGND VGND
+ VPWR VPWR _04751_ sky130_fd_sc_hd__a21o_2
XFILLER_0_105_55 VGND VGND VPWR VPWR sky130_fd_sc_hd__fill_1
XFILLER_0_14_53 VPWR VGND VPWR VGND sky130_ef_sc_hd__decap_12
XTAP_TAPCELL_ROW_102_1538 VGND VPWR sky130_fd_sc_hd__tapvpwrvgnd_1
XFILLER_0_58_489 VPWR VGND VPWR VGND sky130_ef_sc_hd__decap_12
XTAP_TAPCELL_ROW_14_440 VGND VPWR sky130_fd_sc_hd__tapvpwrvgnd_1
XFILLER_0_18_309 VPWR VGND VPWR VGND sky130_ef_sc_hd__decap_12
X_06200_ _01019_ _01041_ _04777_ VGND VGND VPWR VPWR _01143_ sky130_fd_sc_hd__mux2_1
XFILLER_0_14_97 VPWR VGND VPWR VGND sky130_ef_sc_hd__decap_12
XFILLER_0_38_180 VGND VGND VPWR VPWR sky130_fd_sc_hd__decap_3
XTAP_TAPCELL_ROW_42_782 VGND VPWR sky130_fd_sc_hd__tapvpwrvgnd_1
X_07180_ _01992_ _01994_ _01993_ VGND VGND VPWR VPWR _01997_ sky130_fd_sc_hd__o21bai_2
XFILLER_0_5_225 VPWR VGND VPWR VGND sky130_ef_sc_hd__decap_12
XFILLER_0_30_41 VGND VGND VPWR VPWR sky130_fd_sc_hd__decap_8
XTAP_TAPCELL_ROW_42_793 VGND VPWR sky130_fd_sc_hd__tapvpwrvgnd_1
XFILLER_0_112_701 VGND VGND VPWR VPWR sky130_fd_sc_hd__fill_1
X_06131_ tanh_inst.divider.x\[-22\] _01035_ _01075_ _04778_ _04777_ VGND VGND VPWR
+ VPWR _01077_ sky130_fd_sc_hd__o221a_2
XFILLER_0_81_492 VPWR VGND VPWR VGND sky130_ef_sc_hd__decap_12
XFILLER_0_81_481 VGND VGND VPWR VPWR sky130_fd_sc_hd__fill_2
XFILLER_0_112_723 VGND VGND VPWR VPWR sky130_fd_sc_hd__fill_1
X_06062_ mac_inst.z\[30\] _01010_ VGND VGND VPWR VPWR _01011_ sky130_fd_sc_hd__nand2_2
XFILLER_0_30_85 VPWR VGND VPWR VGND sky130_ef_sc_hd__decap_12
XFILLER_0_111_266 VGND VGND VPWR VPWR sky130_fd_sc_hd__decap_4
XTAP_TAPCELL_ROW_113_1678 VGND VPWR sky130_fd_sc_hd__tapvpwrvgnd_1
XFILLER_0_39_83 VGND VGND VPWR VPWR sky130_fd_sc_hd__decap_4
X_09821_ _04542_ _04541_ VGND VGND VPWR VPWR _04543_ sky130_fd_sc_hd__and2b_2
X_09752_ _03168_ _03169_ _04473_ VGND VGND VPWR VPWR _04475_ sky130_fd_sc_hd__nand3_2
X_06964_ _01803_ _01804_ VGND VGND VPWR VPWR _01806_ sky130_fd_sc_hd__and2_2
X_08703_ tanh_inst.divider.y\[7\] tanh_inst.divider.x\[7\] VGND VGND VPWR VPWR _03482_
+ sky130_fd_sc_hd__xnor2_2
X_06895_ tanh_inst.div_en tanh_inst.divider.z_\[-23\] VGND VGND VPWR VPWR _00166_
+ sky130_fd_sc_hd__and2b_2
XTAP_TAPCELL_ROW_68_1113 VGND VPWR sky130_fd_sc_hd__tapvpwrvgnd_1
X_05915_ _00677_ _00847_ VGND VGND VPWR VPWR _00876_ sky130_fd_sc_hd__or2_2
X_09683_ tanh_inst.divider.y\[-3\] _04406_ VGND VGND VPWR VPWR _04408_ sky130_fd_sc_hd__and2_2
X_08634_ _03385_ _03388_ _03413_ VGND VGND VPWR VPWR _03415_ sky130_fd_sc_hd__o21ai_2
X_05846_ _00811_ _00812_ VGND VGND VPWR VPWR _05846_/X sky130_fd_sc_hd__and2_2
X_05777_ mac_inst.i\[3\] _04934_ _04944_ _04977_ VGND VGND VPWR VPWR _00748_ sky130_fd_sc_hd__or4_2
X_08565_ tanh_inst.z_\[7\] _03283_ _03284_ VGND VGND VPWR VPWR _03348_ sky130_fd_sc_hd__o21ai_2
X_07516_ _02318_ _02319_ _02322_ _01524_ VGND VGND VPWR VPWR _02323_ sky130_fd_sc_hd__a22o_2
XFILLER_0_64_404 VPWR VGND VPWR VGND sky130_ef_sc_hd__decap_12
X_08496_ _03279_ _03280_ VGND VGND VPWR VPWR _03281_ sky130_fd_sc_hd__nor2_2
X_07447_ tanh_inst.divider.y\[-14\] tanh_inst.divider.y\[-13\] tanh_inst.divider.y\[-12\]
+ tanh_inst.divider.y\[-11\] tanh_inst.LOOKUP.index\[0\] tanh_inst.LOOKUP.index\[1\]
+ VGND VGND VPWR VPWR _02255_ sky130_fd_sc_hd__mux4_2
XFILLER_0_29_191 VPWR VGND VPWR VGND sky130_ef_sc_hd__decap_12
X_07378_ _02110_ _02150_ _02152_ _01482_ VGND VGND VPWR VPWR _02187_ sky130_fd_sc_hd__o22a_2
X_06329_ tanh_inst.divider.y\[-12\] tanh_inst.div_en tanh_inst.divider.y_\[-12\] _01092_
+ _01263_ VGND VGND VPWR VPWR _00098_ sky130_fd_sc_hd__a221o_2
XFILLER_0_91_289 VGND VGND VPWR VPWR sky130_fd_sc_hd__fill_2
X_09117_ _03857_ VGND VGND VPWR VPWR _03858_ sky130_fd_sc_hd__inv_2
X_09048_ tanh_inst.divider.y\[-20\] _03788_ VGND VGND VPWR VPWR _03790_ sky130_fd_sc_hd__xnor2_2
XTAP_TAPCELL_ROW_79_1253 VGND VPWR sky130_fd_sc_hd__tapvpwrvgnd_1
XFILLER_0_44_194 VGND VGND VPWR VPWR sky130_fd_sc_hd__fill_2
XFILLER_0_102_244 VGND VGND VPWR VPWR sky130_fd_sc_hd__fill_1
XFILLER_0_102_266 VGND VGND VPWR VPWR sky130_fd_sc_hd__fill_1
XFILLER_0_99_389 VGND VGND VPWR VPWR sky130_fd_sc_hd__decap_3
XFILLER_0_95_573 VGND VGND VPWR VPWR sky130_fd_sc_hd__decap_4
XFILLER_0_82_201 VGND VGND VPWR VPWR sky130_fd_sc_hd__fill_1
XFILLER_0_55_459 VGND VGND VPWR VPWR sky130_fd_sc_hd__decap_6
XFILLER_0_55_437 VGND VGND VPWR VPWR sky130_fd_sc_hd__decap_8
Xclkload16 clknet_leaf_34_clk VGND VGND VPWR VPWR clkload16/Y sky130_fd_sc_hd__inv_16
Xclkload27 clknet_leaf_10_clk VGND VGND VPWR VPWR clkload27/Y sky130_fd_sc_hd__clkinv_4
Xclkload38 clknet_leaf_22_clk VGND VGND VPWR VPWR clkload38/Y sky130_fd_sc_hd__inv_8
XFILLER_0_35_194 VGND VGND VPWR VPWR sky130_fd_sc_hd__fill_2
XFILLER_0_76_15 VPWR VGND VPWR VGND sky130_ef_sc_hd__decap_12
XFILLER_0_92_47 VGND VGND VPWR VPWR sky130_fd_sc_hd__fill_1
X_06680_ _01585_ _01586_ VGND VGND VPWR VPWR _01588_ sky130_fd_sc_hd__or2_2
X_05700_ _04923_ _04955_ _04975_ _00675_ VGND VGND VPWR VPWR _00677_ sky130_fd_sc_hd__or4_2
XFILLER_0_116_65 VPWR VGND VPWR VGND sky130_ef_sc_hd__decap_12
X_05631_ _00603_ _00606_ VGND VGND VPWR VPWR _00617_ sky130_fd_sc_hd__or2_2
XTAP_TAPCELL_ROW_47_852 VGND VPWR sky130_fd_sc_hd__tapvpwrvgnd_1
XFILLER_0_86_540 VGND VGND VPWR VPWR sky130_fd_sc_hd__decap_4
XFILLER_0_25_74 VGND VGND VPWR VPWR sky130_fd_sc_hd__decap_8
X_08350_ _03133_ _03136_ VGND VGND VPWR VPWR _03138_ sky130_fd_sc_hd__xnor2_2
XFILLER_0_86_584 VGND VGND VPWR VPWR sky130_fd_sc_hd__decap_4
X_07301_ tanh_inst.LOOKUP.index\[1\] _01479_ _02059_ VGND VGND VPWR VPWR _02111_ sky130_fd_sc_hd__and3_2
XFILLER_0_58_253 VGND VGND VPWR VPWR sky130_fd_sc_hd__decap_6
X_05562_ _00524_ _00540_ _00541_ _00553_ VGND VGND VPWR VPWR _00554_ sky130_fd_sc_hd__a31o_2
XTAP_TAPCELL_ROW_63_1054 VGND VPWR sky130_fd_sc_hd__tapvpwrvgnd_1
XFILLER_0_18_139 VGND VGND VPWR VPWR sky130_fd_sc_hd__fill_1
X_08281_ _04791_ _03068_ _03069_ VGND VGND VPWR VPWR _03071_ sky130_fd_sc_hd__and3_2
X_05493_ _00489_ _00490_ VGND VGND VPWR VPWR _00491_ sky130_fd_sc_hd__xnor2_2
X_07232_ tanh_inst.divider.y\[-14\] _02028_ _02029_ VGND VGND VPWR VPWR _02042_ sky130_fd_sc_hd__o21a_2
XFILLER_0_41_62 VPWR VGND VPWR VGND sky130_ef_sc_hd__decap_12
XFILLER_0_116_358 VGND VGND VPWR VPWR sky130_fd_sc_hd__decap_6
X_07163_ _01974_ _01976_ _01982_ VGND VGND VPWR VPWR _01983_ sky130_fd_sc_hd__o21ai_2
XFILLER_0_14_301 VGND VGND VPWR VPWR sky130_fd_sc_hd__decap_6
X_06114_ _01044_ _01059_ VGND VGND VPWR VPWR _01061_ sky130_fd_sc_hd__or2_2
XFILLER_0_14_345 VGND VGND VPWR VPWR sky130_fd_sc_hd__decap_6
XFILLER_0_41_131 VGND VGND VPWR VPWR sky130_fd_sc_hd__fill_1
X_07094_ _01918_ _01921_ VGND VGND VPWR VPWR _01922_ sky130_fd_sc_hd__xnor2_2
XFILLER_0_41_164 VGND VGND VPWR VPWR sky130_fd_sc_hd__decap_4
XFILLER_0_112_586 VGND VGND VPWR VPWR sky130_fd_sc_hd__fill_2
XFILLER_0_67_3 VGND VGND VPWR VPWR sky130_fd_sc_hd__decap_8
XFILLER_0_1_261 VPWR VGND VPWR VGND sky130_ef_sc_hd__decap_12
X_06045_ _04795_ _00987_ _00994_ VGND VGND VPWR VPWR _00996_ sky130_fd_sc_hd__a21o_2
XTAP_TAPCELL_ROW_74_1183 VGND VPWR sky130_fd_sc_hd__tapvpwrvgnd_1
XFILLER_0_5_51 VGND VGND VPWR VPWR sky130_fd_sc_hd__decap_4
X_09804_ _04463_ _04489_ VGND VGND VPWR VPWR _04526_ sky130_fd_sc_hd__nand2_2
X_07996_ _02790_ _02791_ VGND VGND VPWR VPWR _02792_ sky130_fd_sc_hd__nor2_2
X_06947_ _01088_ _01789_ _01790_ _01092_ tanh_inst.divider.z_\[-22\] VGND VGND VPWR
+ VPWR _00199_ sky130_fd_sc_hd__a32o_2
XFILLER_0_66_92 VGND VGND VPWR VPWR sky130_fd_sc_hd__decap_4
X_09735_ _04457_ _04458_ VGND VGND VPWR VPWR _04459_ sky130_fd_sc_hd__nor2_2
X_09666_ tanh_inst.divider.x\[-4\] _04390_ VGND VGND VPWR VPWR _04392_ sky130_fd_sc_hd__and2_2
XFILLER_0_69_529 VGND VGND VPWR VPWR sky130_fd_sc_hd__decap_6
X_06878_ tanh_inst.z_\[6\] _01666_ _04791_ VGND VGND VPWR VPWR _01762_ sky130_fd_sc_hd__o21ai_2
X_08617_ _03288_ _03352_ VGND VGND VPWR VPWR _03399_ sky130_fd_sc_hd__and2_2
X_09597_ _04262_ _04282_ VGND VGND VPWR VPWR _04325_ sky130_fd_sc_hd__nor2_2
X_05829_ mac_inst.i\[3\] mac_inst.i\[2\] _04932_ _04976_ VGND VGND VPWR VPWR _00796_
+ sky130_fd_sc_hd__and4_2
X_08548_ tanh_inst.divider.y\[3\] _03329_ VGND VGND VPWR VPWR _03331_ sky130_fd_sc_hd__and2_2
XFILLER_0_64_201 VGND VGND VPWR VPWR sky130_fd_sc_hd__fill_1
XTAP_TAPCELL_ROW_25_579 VGND VPWR sky130_fd_sc_hd__tapvpwrvgnd_1
X_08479_ tanh_inst.divider.y\[1\] _03263_ VGND VGND VPWR VPWR _03264_ sky130_fd_sc_hd__nor2_2
XFILLER_0_92_587 VGND VGND VPWR VPWR sky130_fd_sc_hd__fill_1
X_10441_ clknet_leaf_26_clk _00298_ VGND VGND VPWR VPWR tanh_inst.divider.y\[-23\]
+ sky130_fd_sc_hd__dfxtp_2
XFILLER_0_64_289 VGND VGND VPWR VPWR sky130_fd_sc_hd__fill_1
XFILLER_0_17_161 VGND VGND VPWR VPWR sky130_fd_sc_hd__decap_6
XFILLER_0_33_632 VGND VGND VPWR VPWR sky130_fd_sc_hd__decap_8
XFILLER_0_45_470 VPWR VGND VPWR VGND sky130_ef_sc_hd__decap_12
X_10372_ clknet_leaf_25_clk _00229_ VGND VGND VPWR VPWR tanh_inst.IS_Z_ZERO sky130_fd_sc_hd__dfxtp_2
XFILLER_0_103_586 VGND VGND VPWR VPWR sky130_fd_sc_hd__fill_1
XFILLER_0_32_186 VGND VGND VPWR VPWR sky130_fd_sc_hd__fill_1
XFILLER_0_46_29 VPWR VGND VPWR VGND sky130_ef_sc_hd__decap_12
XTAP_TAPCELL_ROW_44_811 VGND VPWR sky130_fd_sc_hd__tapvpwrvgnd_1
XFILLER_0_68_573 VGND VGND VPWR VPWR sky130_fd_sc_hd__fill_2
XFILLER_0_95_381 VGND VGND VPWR VPWR sky130_fd_sc_hd__decap_4
XFILLER_0_68_595 VGND VGND VPWR VPWR sky130_fd_sc_hd__decap_4
XFILLER_0_28_459 VGND VGND VPWR VPWR sky130_fd_sc_hd__fill_2
XFILLER_0_43_407 VPWR VGND VPWR VGND sky130_ef_sc_hd__decap_12
XFILLER_0_55_278 VGND VGND VPWR VPWR sky130_fd_sc_hd__fill_2
XFILLER_0_106_380 VGND VGND VPWR VPWR sky130_fd_sc_hd__decap_4
XFILLER_0_87_36 VPWR VGND VPWR VGND sky130_ef_sc_hd__decap_12
XFILLER_0_11_337 VPWR VGND VPWR VGND sky130_ef_sc_hd__decap_12
XTAP_TAPCELL_ROW_110_1637 VGND VPWR sky130_fd_sc_hd__tapvpwrvgnd_1
XPHY_EDGE_ROW_18_Right_18 VGND VGND VPWR VPWR sky130_fd_sc_hd__decap_3
X_07850_ _02571_ _02605_ VGND VGND VPWR VPWR _02650_ sky130_fd_sc_hd__nand2_2
X_07781_ _02580_ _02581_ VGND VGND VPWR VPWR _02582_ sky130_fd_sc_hd__nand2_2
X_06801_ _01689_ _01694_ VGND VGND VPWR VPWR _01696_ sky130_fd_sc_hd__or2_2
X_09520_ _04137_ _04249_ _04138_ _04105_ VGND VGND VPWR VPWR _04250_ sky130_fd_sc_hd__and4bb_2
XFILLER_0_36_62 VGND VGND VPWR VPWR sky130_fd_sc_hd__decap_4
X_06732_ _01616_ _01624_ _01626_ _01623_ VGND VGND VPWR VPWR _01634_ sky130_fd_sc_hd__a31o_2
X_09451_ _04179_ _04180_ _04181_ _04791_ VGND VGND VPWR VPWR _04183_ sky130_fd_sc_hd__a31o_2
X_06663_ _01473_ _01528_ _01570_ VGND VGND VPWR VPWR _01572_ sky130_fd_sc_hd__or3_2
X_06594_ tanh_inst.z_\[-23\] _01506_ VGND VGND VPWR VPWR _01508_ sky130_fd_sc_hd__xnor2_2
X_09382_ tanh_inst.LOOKUP.index\[4\] _04114_ _04115_ VGND VGND VPWR VPWR _04116_ sky130_fd_sc_hd__a21bo_2
XPHY_EDGE_ROW_27_Right_27 VGND VGND VPWR VPWR sky130_fd_sc_hd__decap_3
X_05614_ _04795_ _00600_ VGND VGND VPWR VPWR _00601_ sky130_fd_sc_hd__nand2_2
X_08402_ tanh_inst.LOOKUP.index\[4\] _02511_ _02859_ VGND VGND VPWR VPWR _03189_ sky130_fd_sc_hd__o21ai_2
XTAP_TAPCELL_ROW_121_1777 VGND VPWR sky130_fd_sc_hd__tapvpwrvgnd_1
XFILLER_0_59_595 VGND VGND VPWR VPWR sky130_fd_sc_hd__fill_1
X_08333_ _03119_ _03120_ VGND VGND VPWR VPWR _03121_ sky130_fd_sc_hd__xnor2_2
X_05545_ _00537_ _00538_ VGND VGND VPWR VPWR _05545_/Y sky130_fd_sc_hd__xnor2_2
XTAP_TAPCELL_ROW_121_1788 VGND VPWR sky130_fd_sc_hd__tapvpwrvgnd_1
XFILLER_0_117_634 VGND VGND VPWR VPWR sky130_fd_sc_hd__fill_1
X_08264_ _02882_ _02884_ _02886_ _03053_ VGND VGND VPWR VPWR _03054_ sky130_fd_sc_hd__a31o_2
XTAP_TAPCELL_ROW_22_538 VGND VPWR sky130_fd_sc_hd__tapvpwrvgnd_1
XFILLER_0_116_133 VGND VGND VPWR VPWR sky130_fd_sc_hd__decap_6
XFILLER_0_74_587 VGND VGND VPWR VPWR sky130_fd_sc_hd__fill_1
X_05476_ _00458_ _00469_ _00470_ VGND VGND VPWR VPWR _00475_ sky130_fd_sc_hd__o21a_2
X_07215_ _01514_ _02021_ VGND VGND VPWR VPWR _02025_ sky130_fd_sc_hd__or2_2
XFILLER_0_27_492 VGND VGND VPWR VPWR sky130_fd_sc_hd__fill_1
X_08195_ _02911_ _02944_ VGND VGND VPWR VPWR _02987_ sky130_fd_sc_hd__nor2_2
X_07146_ _01966_ _01967_ VGND VGND VPWR VPWR _01968_ sky130_fd_sc_hd__nand2_2
XTAP_TAPCELL_ROW_76_1212 VGND VPWR sky130_fd_sc_hd__tapvpwrvgnd_1
XFILLER_0_14_153 VPWR VGND VPWR VGND sky130_ef_sc_hd__decap_12
XFILLER_0_15_665 VGND VGND VPWR VPWR sky130_fd_sc_hd__decap_6
XFILLER_0_15_687 VPWR VGND VPWR VGND sky130_ef_sc_hd__decap_12
XFILLER_0_42_451 VGND VGND VPWR VPWR sky130_fd_sc_hd__decap_6
XFILLER_0_100_501 VGND VGND VPWR VPWR sky130_fd_sc_hd__fill_2
X_07077_ _01897_ _01900_ _01905_ _01089_ VGND VGND VPWR VPWR _01907_ sky130_fd_sc_hd__a31o_2
XFILLER_0_14_197 VPWR VGND VPWR VGND sky130_ef_sc_hd__decap_12
X_06028_ _00978_ _00980_ VGND VGND VPWR VPWR _00981_ sky130_fd_sc_hd__nand2_2
XPHY_EDGE_ROW_36_Right_36 VGND VGND VPWR VPWR sky130_fd_sc_hd__decap_3
XFILLER_0_10_381 VGND VGND VPWR VPWR sky130_fd_sc_hd__decap_3
XFILLER_0_10_392 VGND VGND VPWR VPWR sky130_fd_sc_hd__fill_1
X_07979_ _02645_ _02735_ _02736_ tanh_inst.z_\[7\] VGND VGND VPWR VPWR _02776_ sky130_fd_sc_hd__a31o_2
X_09718_ tanh_inst.divider.y\[-3\] _04429_ _04368_ VGND VGND VPWR VPWR _04442_ sky130_fd_sc_hd__a21o_2
XTAP_TAPCELL_ROW_87_1352 VGND VPWR sky130_fd_sc_hd__tapvpwrvgnd_1
XFILLER_0_69_337 VPWR VGND VPWR VGND sky130_ef_sc_hd__decap_12
XTAP_TAPCELL_ROW_2_285 VGND VPWR sky130_fd_sc_hd__tapvpwrvgnd_1
XPHY_EDGE_ROW_45_Right_45 VGND VGND VPWR VPWR sky130_fd_sc_hd__decap_3
X_09649_ _04236_ _04372_ _04374_ _04358_ VGND VGND VPWR VPWR _04375_ sky130_fd_sc_hd__a211oi_2
XPHY_EDGE_ROW_106_Left_228 VGND VGND VPWR VPWR sky130_fd_sc_hd__decap_3
XFILLER_0_107_111 VGND VGND VPWR VPWR sky130_fd_sc_hd__fill_1
XFILLER_0_108_656 VGND VGND VPWR VPWR sky130_fd_sc_hd__fill_1
XFILLER_0_92_373 VGND VGND VPWR VPWR sky130_fd_sc_hd__decap_3
XFILLER_0_52_204 VGND VGND VPWR VPWR sky130_fd_sc_hd__decap_4
XTAP_TAPCELL_ROW_98_1492 VGND VPWR sky130_fd_sc_hd__tapvpwrvgnd_1
XTAP_TAPCELL_ROW_98_1481 VGND VPWR sky130_fd_sc_hd__tapvpwrvgnd_1
X_10424_ clknet_leaf_37_clk _00281_ _00000_ VGND VGND VPWR VPWR mac_inst.i\[16\] sky130_fd_sc_hd__dfrtp_2
XPHY_EDGE_ROW_115_Left_237 VGND VGND VPWR VPWR sky130_fd_sc_hd__decap_3
XFILLER_0_110_309 VPWR VGND VPWR VGND sky130_ef_sc_hd__decap_12
XPHY_EDGE_ROW_54_Right_54 VGND VGND VPWR VPWR sky130_fd_sc_hd__decap_3
XFILLER_0_103_372 VGND VGND VPWR VPWR sky130_fd_sc_hd__decap_8
X_10355_ clknet_leaf_21_clk _00212_ VGND VGND VPWR VPWR tanh_inst.divider.z_\[-9\]
+ sky130_fd_sc_hd__dfxtp_2
XFILLER_0_57_39 VGND VGND VPWR VPWR sky130_fd_sc_hd__decap_6
XFILLER_0_20_189 VGND VGND VPWR VPWR sky130_fd_sc_hd__decap_6
X_10286_ clknet_leaf_29_clk _00143_ VGND VGND VPWR VPWR tanh_inst.z_\[-9\] sky130_fd_sc_hd__dfxtp_2
XFILLER_0_88_635 VGND VGND VPWR VPWR sky130_fd_sc_hd__fill_2
XFILLER_0_73_49 VGND VGND VPWR VPWR sky130_fd_sc_hd__fill_2
XPHY_EDGE_ROW_63_Right_63 VGND VGND VPWR VPWR sky130_fd_sc_hd__decap_3
XTAP_TAPCELL_ROW_57_980 VGND VPWR sky130_fd_sc_hd__tapvpwrvgnd_1
XFILLER_0_56_521 VGND VGND VPWR VPWR sky130_fd_sc_hd__fill_1
XFILLER_0_113_55 VGND VGND VPWR VPWR sky130_fd_sc_hd__fill_1
XTAP_TAPCELL_ROW_60_1013 VGND VPWR sky130_fd_sc_hd__tapvpwrvgnd_1
X_05330_ mac_inst.i\[3\] _05024_ _05028_ _04912_ VGND VGND VPWR VPWR _05029_ sky130_fd_sc_hd__a211o_2
XFILLER_0_56_598 VPWR VGND VPWR VGND sky130_ef_sc_hd__decap_12
XFILLER_0_22_53 VPWR VGND VPWR VGND sky130_ef_sc_hd__decap_12
XFILLER_0_22_97 VPWR VGND VPWR VGND sky130_ef_sc_hd__decap_12
X_05261_ mac_inst.i\[15\] mac_inst.i\[17\] VGND VGND VPWR VPWR _04962_ sky130_fd_sc_hd__nand2_2
XFILLER_0_113_125 VGND VGND VPWR VPWR sky130_fd_sc_hd__decap_3
X_07000_ _01057_ _01776_ VGND VGND VPWR VPWR _01838_ sky130_fd_sc_hd__or2_2
XPHY_EDGE_ROW_72_Right_72 VGND VGND VPWR VPWR sky130_fd_sc_hd__decap_3
X_05192_ mac_inst.x\[12\] _04852_ _04853_ VGND VGND VPWR VPWR _04896_ sky130_fd_sc_hd__a21o_2
XFILLER_0_24_473 VGND VGND VPWR VPWR sky130_fd_sc_hd__decap_3
XFILLER_0_113_169 VGND VGND VPWR VPWR sky130_fd_sc_hd__decap_8
XFILLER_0_12_624 VGND VGND VPWR VPWR sky130_fd_sc_hd__fill_1
XFILLER_0_12_657 VPWR VGND VPWR VGND sky130_ef_sc_hd__decap_12
X_08951_ _03624_ _03626_ _03623_ VGND VGND VPWR VPWR _03695_ sky130_fd_sc_hd__a21o_2
XFILLER_0_11_167 VGND VGND VPWR VPWR sky130_fd_sc_hd__fill_1
X_07902_ _02657_ _02660_ _02697_ VGND VGND VPWR VPWR _02700_ sky130_fd_sc_hd__or3_2
X_08882_ _03625_ _03626_ VGND VGND VPWR VPWR _03627_ sky130_fd_sc_hd__xnor2_2
XTAP_TAPCELL_ROW_71_1153 VGND VPWR sky130_fd_sc_hd__tapvpwrvgnd_1
X_07833_ _02613_ _02632_ VGND VGND VPWR VPWR _02633_ sky130_fd_sc_hd__nand2_2
XFILLER_0_47_50 VGND VGND VPWR VPWR sky130_fd_sc_hd__decap_6
XFILLER_0_47_72 VGND VGND VPWR VPWR sky130_fd_sc_hd__decap_8
XPHY_EDGE_ROW_81_Right_81 VGND VGND VPWR VPWR sky130_fd_sc_hd__decap_3
XFILLER_0_2_41 VPWR VGND VPWR VGND sky130_ef_sc_hd__decap_12
X_07764_ _01477_ _02106_ _02120_ _01525_ VGND VGND VPWR VPWR _02566_ sky130_fd_sc_hd__o22a_2
X_07695_ _02449_ _02451_ _02447_ VGND VGND VPWR VPWR _02498_ sky130_fd_sc_hd__a21boi_2
XFILLER_0_79_646 VGND VGND VPWR VPWR sky130_fd_sc_hd__decap_4
XFILLER_0_78_145 VGND VGND VPWR VPWR sky130_fd_sc_hd__fill_1
XFILLER_0_78_112 VGND VGND VPWR VPWR sky130_fd_sc_hd__fill_1
X_09503_ tanh_inst.divider.y\[-8\] _04231_ VGND VGND VPWR VPWR _04233_ sky130_fd_sc_hd__and2_2
XFILLER_0_2_85 VPWR VGND VPWR VGND sky130_ef_sc_hd__decap_12
X_06715_ _01617_ _01618_ VGND VGND VPWR VPWR _01619_ sky130_fd_sc_hd__nand2_2
XFILLER_0_94_605 VGND VGND VPWR VPWR sky130_fd_sc_hd__decap_4
X_09434_ tanh_inst.divider.y\[-10\] _04165_ VGND VGND VPWR VPWR _04166_ sky130_fd_sc_hd__nand2_2
X_06646_ tanh_inst.z_\[7\] _01547_ _01556_ VGND VGND VPWR VPWR _01557_ sky130_fd_sc_hd__mux2_1
XFILLER_0_19_223 VGND VGND VPWR VPWR sky130_fd_sc_hd__fill_1
X_09365_ tanh_inst.divider.y\[-12\] _04087_ VGND VGND VPWR VPWR _04099_ sky130_fd_sc_hd__xor2_2
XTAP_TAPCELL_ROW_82_1282 VGND VPWR sky130_fd_sc_hd__tapvpwrvgnd_1
X_06577_ tanh_inst.z_\[1\] tanh_inst.z_\[0\] tanh_inst.z_\[3\] tanh_inst.z_\[2\] VGND
+ VGND VPWR VPWR _01492_ sky130_fd_sc_hd__or4_2
XTAP_TAPCELL_ROW_35_696 VGND VPWR sky130_fd_sc_hd__tapvpwrvgnd_1
XFILLER_0_35_705 VPWR VGND VPWR VGND sky130_ef_sc_hd__decap_12
XFILLER_0_47_543 VPWR VGND VPWR VGND sky130_ef_sc_hd__decap_12
X_09296_ _04029_ _04031_ VGND VGND VPWR VPWR _04032_ sky130_fd_sc_hd__nor2_2
XTAP_TAPCELL_ROW_82_1293 VGND VPWR sky130_fd_sc_hd__tapvpwrvgnd_1
XFILLER_0_74_362 VGND VGND VPWR VPWR sky130_fd_sc_hd__fill_2
XFILLER_0_62_524 VGND VGND VPWR VPWR sky130_fd_sc_hd__decap_8
X_08316_ _03058_ _03065_ _03104_ VGND VGND VPWR VPWR _03105_ sky130_fd_sc_hd__a21oi_2
XFILLER_0_34_215 VGND VGND VPWR VPWR sky130_fd_sc_hd__fill_1
X_05528_ _00497_ _00498_ _00512_ VGND VGND VPWR VPWR _00523_ sky130_fd_sc_hd__nor3_2
XPHY_EDGE_ROW_90_Right_90 VGND VGND VPWR VPWR sky130_fd_sc_hd__decap_3
XFILLER_0_62_557 VGND VGND VPWR VPWR sky130_fd_sc_hd__fill_1
XFILLER_0_7_673 VGND VGND VPWR VPWR sky130_fd_sc_hd__decap_6
X_05459_ _00434_ _00445_ _00446_ VGND VGND VPWR VPWR _00460_ sky130_fd_sc_hd__o21a_2
X_08247_ _03034_ _03035_ VGND VGND VPWR VPWR _03037_ sky130_fd_sc_hd__xnor2_2
XFILLER_0_104_169 VGND VGND VPWR VPWR sky130_fd_sc_hd__decap_3
XFILLER_0_15_495 VGND VGND VPWR VPWR sky130_fd_sc_hd__decap_4
XFILLER_0_30_410 VGND VGND VPWR VPWR sky130_fd_sc_hd__decap_8
XFILLER_0_30_421 VGND VGND VPWR VPWR sky130_fd_sc_hd__fill_2
X_08178_ tanh_inst.divider.y\[-6\] tanh_inst.divider.x\[-6\] VGND VGND VPWR VPWR _02970_
+ sky130_fd_sc_hd__or2_2
X_07129_ _01935_ _01943_ _01945_ VGND VGND VPWR VPWR _01953_ sky130_fd_sc_hd__or3_2
X_10071_ clknet_leaf_13_clk _00088_ VGND VGND VPWR VPWR tanh_inst.divider.y_\[-22\]
+ sky130_fd_sc_hd__dfxtp_2
XTAP_TAPCELL_ROW_7_355 VGND VPWR sky130_fd_sc_hd__tapvpwrvgnd_1
XTAP_TAPCELL_ROW_7_344 VGND VPWR sky130_fd_sc_hd__tapvpwrvgnd_1
XFILLER_0_78_690 VGND VGND VPWR VPWR sky130_fd_sc_hd__decap_4
XFILLER_0_93_671 VGND VGND VPWR VPWR sky130_fd_sc_hd__fill_1
XFILLER_0_92_170 VGND VGND VPWR VPWR sky130_fd_sc_hd__decap_8
XFILLER_0_65_373 VPWR VGND VPWR VGND sky130_ef_sc_hd__decap_12
XFILLER_0_108_475 VGND VGND VPWR VPWR sky130_fd_sc_hd__fill_1
XFILLER_0_4_109 VPWR VGND VPWR VGND sky130_ef_sc_hd__decap_12
XFILLER_0_25_237 VPWR VGND VPWR VGND sky130_ef_sc_hd__decap_12
XFILLER_0_53_546 VGND VGND VPWR VPWR sky130_fd_sc_hd__fill_1
XFILLER_0_80_365 VGND VGND VPWR VPWR sky130_fd_sc_hd__decap_8
XFILLER_0_41_719 VGND VGND VPWR VPWR sky130_fd_sc_hd__decap_4
XFILLER_0_53_579 VGND VGND VPWR VPWR sky130_fd_sc_hd__fill_1
XFILLER_0_111_607 VGND VGND VPWR VPWR sky130_fd_sc_hd__decap_8
XFILLER_0_33_281 VGND VGND VPWR VPWR sky130_fd_sc_hd__decap_6
X_10407_ clknet_leaf_3_clk _00264_ VGND VGND VPWR VPWR tanh_inst.divider.x\[7\] sky130_fd_sc_hd__dfxtp_2
XFILLER_0_68_27 VGND VGND VPWR VPWR sky130_fd_sc_hd__fill_1
XFILLER_0_0_337 VPWR VGND VPWR VGND sky130_ef_sc_hd__decap_12
X_10338_ clknet_leaf_16_clk _00195_ VGND VGND VPWR VPWR tanh_out[30] sky130_fd_sc_hd__dfxtp_2
XFILLER_0_110_139 VGND VGND VPWR VPWR sky130_fd_sc_hd__fill_1
XFILLER_0_84_15 VPWR VGND VPWR VGND sky130_ef_sc_hd__decap_12
X_10269_ clknet_leaf_31_clk mac_inst.x\[31\] _00000_ VGND VGND VPWR VPWR mac_x_out[31]
+ sky130_fd_sc_hd__dfrtp_2
XFILLER_0_108_77 VGND VGND VPWR VPWR sky130_fd_sc_hd__decap_6
X_06500_ _01088_ _01418_ _01419_ _01420_ VGND VGND VPWR VPWR _00112_ sky130_fd_sc_hd__a31o_2
XFILLER_0_76_627 VGND VGND VPWR VPWR sky130_fd_sc_hd__decap_3
X_07480_ _02053_ _02286_ VGND VGND VPWR VPWR _02287_ sky130_fd_sc_hd__nand2_2
XTAP_TAPCELL_ROW_52_909 VGND VPWR sky130_fd_sc_hd__tapvpwrvgnd_1
XTAP_TAPCELL_ROW_105_1569 VGND VPWR sky130_fd_sc_hd__tapvpwrvgnd_1
XFILLER_0_75_104 VGND VGND VPWR VPWR sky130_fd_sc_hd__decap_3
XFILLER_0_29_521 VGND VGND VPWR VPWR sky130_fd_sc_hd__fill_2
X_06431_ tanh_inst.divider.i\[4\] _01159_ _01289_ VGND VGND VPWR VPWR _01357_ sky130_fd_sc_hd__o21a_2
XFILLER_0_91_608 VGND VGND VPWR VPWR sky130_fd_sc_hd__decap_8
X_06362_ tanh_inst.divider.y_\[-9\] _01292_ VGND VGND VPWR VPWR _01294_ sky130_fd_sc_hd__or2_2
X_09150_ _03835_ _03838_ _03889_ _03836_ VGND VGND VPWR VPWR _03890_ sky130_fd_sc_hd__o211a_2
XFILLER_0_84_660 VGND VGND VPWR VPWR sky130_fd_sc_hd__fill_1
XTAP_TAPCELL_ROW_32_666 VGND VPWR sky130_fd_sc_hd__tapvpwrvgnd_1
X_06293_ _01193_ _01217_ _01195_ _01206_ VGND VGND VPWR VPWR _01230_ sky130_fd_sc_hd__and4bb_2
X_09081_ _03821_ _03822_ VGND VGND VPWR VPWR _03823_ sky130_fd_sc_hd__or2_2
X_08101_ _02894_ VGND VGND VPWR VPWR _02895_ sky130_fd_sc_hd__inv_2
X_05313_ _04928_ _05012_ VGND VGND VPWR VPWR _05313_/X sky130_fd_sc_hd__xor2_2
XFILLER_0_114_445 VGND VGND VPWR VPWR sky130_fd_sc_hd__fill_2
XFILLER_0_71_354 VGND VGND VPWR VPWR sky130_fd_sc_hd__decap_8
X_08032_ _02748_ _02827_ _02779_ VGND VGND VPWR VPWR _02828_ sky130_fd_sc_hd__a21o_2
X_05244_ _04847_ _04939_ VGND VGND VPWR VPWR _04945_ sky130_fd_sc_hd__nor2_2
X_05175_ _04783_ _04790_ _04852_ _04878_ VGND VGND VPWR VPWR _04879_ sky130_fd_sc_hd__a31oi_2
XFILLER_0_101_139 VGND VGND VPWR VPWR sky130_fd_sc_hd__decap_4
X_09983_ tanh_inst.divider.y\[5\] _04698_ VGND VGND VPWR VPWR _04700_ sky130_fd_sc_hd__or2_2
X_08934_ _02025_ _03677_ VGND VGND VPWR VPWR _03678_ sky130_fd_sc_hd__and2_2
XTAP_TAPCELL_ROW_4_314 VGND VPWR sky130_fd_sc_hd__tapvpwrvgnd_1
X_08865_ _02025_ _03605_ _03604_ _02023_ VGND VGND VPWR VPWR _03610_ sky130_fd_sc_hd__a211o_2
X_07816_ _02614_ _02615_ VGND VGND VPWR VPWR _02616_ sky130_fd_sc_hd__nand2_2
XFILLER_0_98_207 VGND VGND VPWR VPWR sky130_fd_sc_hd__decap_8
X_08796_ tanh_inst.divider.x\[5\] _02028_ _03508_ VGND VGND VPWR VPWR _03542_ sky130_fd_sc_hd__o21a_2
XFILLER_0_79_410 VGND VGND VPWR VPWR sky130_fd_sc_hd__fill_2
X_07747_ tanh_inst.divider.y\[-16\] tanh_inst.divider.x\[-16\] VGND VGND VPWR VPWR
+ _02549_ sky130_fd_sc_hd__nor2_2
XTAP_TAPCELL_ROW_84_1311 VGND VPWR sky130_fd_sc_hd__tapvpwrvgnd_1
X_07678_ _02480_ _02481_ _02018_ VGND VGND VPWR VPWR _02482_ sky130_fd_sc_hd__o21a_2
XPHY_EDGE_ROW_0_Right_0 VGND VGND VPWR VPWR sky130_fd_sc_hd__decap_3
X_06629_ _01539_ _01540_ VGND VGND VPWR VPWR _01542_ sky130_fd_sc_hd__nand2_2
XFILLER_0_66_148 VGND VGND VPWR VPWR sky130_fd_sc_hd__decap_6
X_09417_ _01525_ _03851_ _03855_ _01477_ VGND VGND VPWR VPWR _04150_ sky130_fd_sc_hd__o22a_2
X_09348_ _04050_ _04055_ _04082_ VGND VGND VPWR VPWR _04083_ sky130_fd_sc_hd__a21o_2
XFILLER_0_90_641 VGND VGND VPWR VPWR sky130_fd_sc_hd__decap_3
XFILLER_0_35_557 VGND VGND VPWR VPWR sky130_fd_sc_hd__decap_3
XFILLER_0_105_434 VGND VGND VPWR VPWR sky130_fd_sc_hd__decap_3
XFILLER_0_105_412 VGND VGND VPWR VPWR sky130_fd_sc_hd__decap_8
X_09279_ _03983_ _03985_ _04014_ _02019_ VGND VGND VPWR VPWR _04016_ sky130_fd_sc_hd__a31o_2
XFILLER_0_62_365 VGND VGND VPWR VPWR sky130_fd_sc_hd__decap_3
XFILLER_0_7_492 VGND VGND VPWR VPWR sky130_fd_sc_hd__fill_1
XFILLER_0_15_281 VPWR VGND VPWR VGND sky130_ef_sc_hd__decap_12
XTAP_TAPCELL_ROW_95_1451 VGND VPWR sky130_fd_sc_hd__tapvpwrvgnd_1
XFILLER_0_100_161 VGND VGND VPWR VPWR sky130_fd_sc_hd__decap_3
XFILLER_0_100_194 VGND VGND VPWR VPWR sky130_fd_sc_hd__fill_2
X_10054_ rst VGND VGND VPWR VPWR _00073_ sky130_fd_sc_hd__inv_2
XFILLER_0_89_229 VGND VGND VPWR VPWR sky130_fd_sc_hd__fill_1
XFILLER_0_54_29 VPWR VGND VPWR VGND sky130_ef_sc_hd__decap_12
XPHY_EDGE_ROW_121_Right_121 VGND VGND VPWR VPWR sky130_fd_sc_hd__decap_3
XFILLER_0_97_240 VGND VGND VPWR VPWR sky130_fd_sc_hd__decap_4
XFILLER_0_72_107 VGND VGND VPWR VPWR sky130_fd_sc_hd__decap_4
XFILLER_0_5_407 VGND VGND VPWR VPWR sky130_fd_sc_hd__decap_4
XFILLER_0_108_294 VGND VGND VPWR VPWR sky130_fd_sc_hd__fill_1
XFILLER_0_41_505 VGND VGND VPWR VPWR sky130_fd_sc_hd__decap_6
XFILLER_0_41_538 VGND VGND VPWR VPWR sky130_fd_sc_hd__decap_4
XFILLER_0_21_273 VGND VGND VPWR VPWR sky130_fd_sc_hd__decap_6
X_06980_ tanh_inst.divider.y_\[7\] _01811_ _01819_ VGND VGND VPWR VPWR _01820_ sky130_fd_sc_hd__o21a_2
XFILLER_0_95_69 VGND VGND VPWR VPWR sky130_fd_sc_hd__decap_8
XFILLER_0_28_41 VPWR VGND VPWR VGND sky130_ef_sc_hd__decap_12
X_05931_ mac_inst.z\[31\] _00890_ VGND VGND VPWR VPWR _00891_ sky130_fd_sc_hd__or2_2
X_08650_ tanh_inst.divider.x\[5\] _03429_ VGND VGND VPWR VPWR _03431_ sky130_fd_sc_hd__or2_2
X_05862_ _00795_ _00799_ _00813_ mac_inst.z\[31\] VGND VGND VPWR VPWR _00827_ sky130_fd_sc_hd__a31o_2
X_07601_ tanh_inst.divider.y\[-19\] tanh_inst.divider.x\[-19\] VGND VGND VPWR VPWR
+ _02406_ sky130_fd_sc_hd__nand2_2
XTAP_TAPCELL_ROW_37_725 VGND VPWR sky130_fd_sc_hd__tapvpwrvgnd_1
X_08581_ _03361_ _03362_ VGND VGND VPWR VPWR _03363_ sky130_fd_sc_hd__nor2_2
X_05793_ _00761_ _00762_ VGND VGND VPWR VPWR _00763_ sky130_fd_sc_hd__nand2_2
XFILLER_0_88_262 VGND VGND VPWR VPWR sky130_fd_sc_hd__decap_8
X_07532_ _02039_ _02096_ _02024_ VGND VGND VPWR VPWR _02338_ sky130_fd_sc_hd__mux2_1
XFILLER_0_76_435 VGND VGND VPWR VPWR sky130_fd_sc_hd__decap_3
X_07463_ _02031_ _02091_ _02093_ _02095_ tanh_inst.LOOKUP.index\[0\] _04760_ VGND
+ VGND VPWR VPWR _02270_ sky130_fd_sc_hd__mux4_2
XTAP_TAPCELL_ROW_66_1085 VGND VPWR sky130_fd_sc_hd__tapvpwrvgnd_1
XTAP_TAPCELL_ROW_17_471 VGND VPWR sky130_fd_sc_hd__tapvpwrvgnd_1
XFILLER_0_119_548 VPWR VGND VPWR VGND sky130_ef_sc_hd__decap_12
X_06414_ _01088_ _01339_ _01340_ _01341_ VGND VGND VPWR VPWR _00105_ sky130_fd_sc_hd__a31o_2
XFILLER_0_91_405 VPWR VGND VPWR VGND sky130_ef_sc_hd__decap_12
X_09202_ _01480_ _03764_ _03767_ _01486_ VGND VGND VPWR VPWR _03941_ sky130_fd_sc_hd__o22a_2
XFILLER_0_8_245 VGND VGND VPWR VPWR sky130_fd_sc_hd__decap_6
X_09133_ tanh_inst.divider.x\[7\] _03675_ _02025_ VGND VGND VPWR VPWR _03873_ sky130_fd_sc_hd__mux2_1
XFILLER_0_91_449 VGND VGND VPWR VPWR sky130_fd_sc_hd__decap_8
XFILLER_0_91_438 VGND VGND VPWR VPWR sky130_fd_sc_hd__decap_4
X_07394_ _01469_ _02202_ VGND VGND VPWR VPWR _00234_ sky130_fd_sc_hd__nor2_2
X_06345_ _01031_ _01177_ VGND VGND VPWR VPWR _01278_ sky130_fd_sc_hd__or2_2
XFILLER_0_97_3 VPWR VGND VPWR VGND sky130_ef_sc_hd__decap_12
XFILLER_0_8_289 VPWR VGND VPWR VGND sky130_ef_sc_hd__decap_12
XFILLER_0_44_365 VGND VGND VPWR VPWR sky130_fd_sc_hd__fill_1
X_06276_ _01088_ _01213_ _01214_ VGND VGND VPWR VPWR _00094_ sky130_fd_sc_hd__a21o_2
XTAP_TAPCELL_ROW_118_1738 VGND VPWR sky130_fd_sc_hd__tapvpwrvgnd_1
XFILLER_0_114_253 VPWR VGND VPWR VGND sky130_ef_sc_hd__decap_12
X_09064_ _04791_ _03805_ VGND VGND VPWR VPWR _03806_ sky130_fd_sc_hd__nand2_2
XFILLER_0_71_162 VGND VGND VPWR VPWR sky130_fd_sc_hd__decap_6
X_08015_ _02786_ _02809_ VGND VGND VPWR VPWR _02811_ sky130_fd_sc_hd__nand2_2
X_05227_ current_state\[1\] current_state\[0\] VGND VGND VPWR VPWR _05032_ sky130_fd_sc_hd__and2_2
XFILLER_0_4_462 VPWR VGND VPWR VGND sky130_ef_sc_hd__decap_12
XFILLER_0_102_459 VPWR VGND VPWR VGND sky130_ef_sc_hd__decap_12
XFILLER_0_102_437 VGND VGND VPWR VPWR sky130_fd_sc_hd__decap_4
XFILLER_0_12_251 VGND VGND VPWR VPWR sky130_fd_sc_hd__fill_1
X_05158_ _04861_ VGND VGND VPWR VPWR _04862_ sky130_fd_sc_hd__inv_2
XFILLER_0_40_582 VGND VGND VPWR VPWR sky130_fd_sc_hd__decap_6
X_09966_ _04679_ _04681_ VGND VGND VPWR VPWR _04683_ sky130_fd_sc_hd__nand2_2
X_05089_ tanh_counter\[7\] _04808_ _04810_ VGND VGND VPWR VPWR _00341_ sky130_fd_sc_hd__o21ba_2
XTAP_TAPCELL_ROW_90_1392 VGND VPWR sky130_fd_sc_hd__tapvpwrvgnd_1
XTAP_TAPCELL_ROW_90_1381 VGND VPWR sky130_fd_sc_hd__tapvpwrvgnd_1
X_08917_ _04768_ _03660_ VGND VGND VPWR VPWR _03662_ sky130_fd_sc_hd__xnor2_2
X_09897_ tanh_inst.divider.y\[3\] _04611_ VGND VGND VPWR VPWR _04616_ sky130_fd_sc_hd__nor2_2
XFILLER_0_99_505 VPWR VGND VPWR VGND sky130_ef_sc_hd__decap_12
X_08848_ tanh_inst.divider.x\[-21\] tanh_inst.divider.x\[-20\] tanh_inst.LOOKUP.index\[0\]
+ VGND VGND VPWR VPWR _03593_ sky130_fd_sc_hd__mux2_1
X_08779_ _03508_ _03523_ VGND VGND VPWR VPWR _03525_ sky130_fd_sc_hd__nand2_2
XFILLER_0_67_446 VGND VGND VPWR VPWR sky130_fd_sc_hd__fill_2
XFILLER_0_54_129 VGND VGND VPWR VPWR sky130_fd_sc_hd__decap_4
XFILLER_0_90_460 VGND VGND VPWR VPWR sky130_fd_sc_hd__fill_1
Xclkbuf_leaf_20_clk clknet_2_3__leaf_clk VGND VGND VPWR VPWR clknet_leaf_20_clk sky130_fd_sc_hd__clkbuf_8
XFILLER_0_63_652 VGND VGND VPWR VPWR sky130_fd_sc_hd__decap_3
XFILLER_0_23_505 VGND VGND VPWR VPWR sky130_fd_sc_hd__decap_3
XFILLER_0_90_471 VGND VGND VPWR VPWR sky130_fd_sc_hd__decap_4
XFILLER_0_23_538 VGND VGND VPWR VPWR sky130_fd_sc_hd__fill_2
XFILLER_0_23_549 VGND VGND VPWR VPWR sky130_fd_sc_hd__decap_8
XFILLER_0_120_245 VGND VGND VPWR VPWR sky130_fd_sc_hd__decap_6
XFILLER_0_120_289 VGND VGND VPWR VPWR sky130_fd_sc_hd__fill_2
X_10106_ clknet_leaf_33_clk _00123_ _00073_ VGND VGND VPWR VPWR mac_counter\[5\] sky130_fd_sc_hd__dfrtp_2
X_10037_ _01470_ _04750_ VGND VGND VPWR VPWR _00329_ sky130_fd_sc_hd__nand2_2
XFILLER_0_81_16 VPWR VGND VPWR VGND sky130_ef_sc_hd__decap_12
XFILLER_0_81_38 VGND VGND VPWR VPWR sky130_fd_sc_hd__decap_4
XFILLER_0_85_221 VGND VGND VPWR VPWR sky130_fd_sc_hd__decap_3
XTAP_TAPCELL_ROW_102_1539 VGND VPWR sky130_fd_sc_hd__tapvpwrvgnd_1
XFILLER_0_73_405 VGND VGND VPWR VPWR sky130_fd_sc_hd__decap_3
XFILLER_0_14_65 VPWR VGND VPWR VGND sky130_ef_sc_hd__decap_12
XFILLER_0_73_449 VGND VGND VPWR VPWR sky130_fd_sc_hd__fill_2
XTAP_TAPCELL_ROW_14_441 VGND VPWR sky130_fd_sc_hd__tapvpwrvgnd_1
XFILLER_0_26_321 VPWR VGND VPWR VGND sky130_ef_sc_hd__decap_12
XTAP_TAPCELL_ROW_42_783 VGND VPWR sky130_fd_sc_hd__tapvpwrvgnd_1
Xclkbuf_leaf_11_clk clknet_2_2__leaf_clk VGND VGND VPWR VPWR clknet_leaf_11_clk sky130_fd_sc_hd__clkbuf_8
XFILLER_0_5_237 VPWR VGND VPWR VGND sky130_ef_sc_hd__decap_12
XFILLER_0_26_365 VGND VGND VPWR VPWR sky130_fd_sc_hd__decap_3
X_06130_ tanh_inst.divider.x\[-23\] _01034_ VGND VGND VPWR VPWR _01076_ sky130_fd_sc_hd__or2_2
XFILLER_0_30_64 VGND VGND VPWR VPWR sky130_fd_sc_hd__decap_3
XFILLER_0_53_162 VGND VGND VPWR VPWR sky130_fd_sc_hd__decap_6
X_06061_ mac_inst.z\[31\] _01003_ _01009_ VGND VGND VPWR VPWR _01010_ sky130_fd_sc_hd__o21ai_2
XFILLER_0_30_75 VGND VGND VPWR VPWR sky130_fd_sc_hd__decap_8
XFILLER_0_30_97 VPWR VGND VPWR VGND sky130_ef_sc_hd__decap_12
XFILLER_0_10_722 VGND VGND VPWR VPWR sky130_fd_sc_hd__fill_2
XTAP_TAPCELL_ROW_113_1679 VGND VPWR sky130_fd_sc_hd__tapvpwrvgnd_1
X_09820_ _04534_ _04535_ _04537_ _04540_ tanh_inst.z_\[7\] VGND VGND VPWR VPWR _04542_
+ sky130_fd_sc_hd__a41o_2
X_06963_ _01803_ _01804_ VGND VGND VPWR VPWR _01805_ sky130_fd_sc_hd__nor2_2
X_09751_ _03168_ _03169_ _04473_ VGND VGND VPWR VPWR _04474_ sky130_fd_sc_hd__a21oi_2
X_08702_ _03442_ _03443_ _03440_ VGND VGND VPWR VPWR _03481_ sky130_fd_sc_hd__o21a_2
X_05914_ _00874_ _00875_ VGND VGND VPWR VPWR _05914_/X sky130_fd_sc_hd__xor2_2
X_06894_ tanh_inst.div_en tanh_inst.divider.z_\[-24\] VGND VGND VPWR VPWR _00165_
+ sky130_fd_sc_hd__and2b_2
XTAP_TAPCELL_ROW_68_1114 VGND VPWR sky130_fd_sc_hd__tapvpwrvgnd_1
X_09682_ _04406_ VGND VGND VPWR VPWR _04407_ sky130_fd_sc_hd__inv_2
X_08633_ _03385_ _03388_ _03413_ VGND VGND VPWR VPWR _03414_ sky130_fd_sc_hd__or3_2
X_05845_ _00803_ _00807_ VGND VGND VPWR VPWR _00812_ sky130_fd_sc_hd__nand2_2
XFILLER_0_12_3 VPWR VGND VPWR VGND sky130_ef_sc_hd__decap_12
X_05776_ _00746_ _00747_ VGND VGND VPWR VPWR _05776_/X sky130_fd_sc_hd__xor2_2
X_08564_ tanh_inst.LOOKUP.index\[4\] _02678_ _02859_ VGND VGND VPWR VPWR _03347_ sky130_fd_sc_hd__o21ai_2
X_07515_ _02320_ _02321_ tanh_inst.LOOKUP.index\[2\] VGND VGND VPWR VPWR _02322_ sky130_fd_sc_hd__mux2_1
XFILLER_0_64_416 VGND VGND VPWR VPWR sky130_fd_sc_hd__decap_4
XFILLER_0_9_521 VGND VGND VPWR VPWR sky130_fd_sc_hd__decap_4
X_08495_ _03244_ _03246_ _03278_ _02019_ VGND VGND VPWR VPWR _03280_ sky130_fd_sc_hd__a31o_2
XFILLER_0_91_213 VGND VGND VPWR VPWR sky130_fd_sc_hd__decap_4
X_07446_ _01482_ _02059_ _02252_ _01486_ VGND VGND VPWR VPWR _02254_ sky130_fd_sc_hd__o22a_2
XFILLER_0_36_129 VGND VGND VPWR VPWR sky130_fd_sc_hd__decap_8
XFILLER_0_91_279 VGND VGND VPWR VPWR sky130_fd_sc_hd__fill_1
X_07377_ _02144_ _02145_ _04760_ VGND VGND VPWR VPWR _02186_ sky130_fd_sc_hd__mux2_1
X_06328_ _01255_ _01260_ _01262_ VGND VGND VPWR VPWR _01263_ sky130_fd_sc_hd__o21a_2
X_09116_ _04757_ _03853_ _03854_ _03856_ VGND VGND VPWR VPWR _03857_ sky130_fd_sc_hd__o211a_2
X_09047_ tanh_inst.divider.y\[-20\] _03788_ VGND VGND VPWR VPWR _03789_ sky130_fd_sc_hd__and2_2
XTAP_TAPCELL_ROW_79_1254 VGND VPWR sky130_fd_sc_hd__tapvpwrvgnd_1
XFILLER_0_32_346 VGND VGND VPWR VPWR sky130_fd_sc_hd__decap_4
X_06259_ tanh_inst.divider.y_\[-17\] _01197_ VGND VGND VPWR VPWR _01199_ sky130_fd_sc_hd__or2_2
XTAP_TAPCELL_ROW_92_1410 VGND VPWR sky130_fd_sc_hd__tapvpwrvgnd_1
XFILLER_0_13_571 VGND VGND VPWR VPWR sky130_fd_sc_hd__decap_8
XFILLER_0_40_390 VGND VGND VPWR VPWR sky130_fd_sc_hd__fill_1
X_09949_ _03342_ _04611_ _04586_ VGND VGND VPWR VPWR _04667_ sky130_fd_sc_hd__o21ba_2
XFILLER_0_87_519 VGND VGND VPWR VPWR sky130_fd_sc_hd__decap_8
XFILLER_0_95_541 VGND VGND VPWR VPWR sky130_fd_sc_hd__decap_8
XFILLER_0_82_213 VGND VGND VPWR VPWR sky130_fd_sc_hd__fill_1
XFILLER_0_67_298 VPWR VGND VPWR VGND sky130_ef_sc_hd__decap_12
XFILLER_0_55_449 VGND VGND VPWR VPWR sky130_fd_sc_hd__fill_1
XFILLER_0_70_419 VGND VGND VPWR VPWR sky130_fd_sc_hd__fill_1
XTAP_TAPCELL_ROW_11_400 VGND VPWR sky130_fd_sc_hd__tapvpwrvgnd_1
XFILLER_0_36_663 VGND VGND VPWR VPWR sky130_fd_sc_hd__decap_8
Xclkload17 clknet_leaf_35_clk VGND VGND VPWR VPWR clkload17/Y sky130_fd_sc_hd__inv_12
XFILLER_0_51_622 VGND VGND VPWR VPWR sky130_fd_sc_hd__decap_3
Xclkload28 clknet_leaf_11_clk VGND VGND VPWR VPWR clkload28/Y sky130_fd_sc_hd__clkinv_4
XFILLER_0_90_290 VPWR VGND VPWR VGND sky130_ef_sc_hd__decap_12
Xclkload39 clknet_leaf_23_clk VGND VGND VPWR VPWR clkload39/Y sky130_fd_sc_hd__clkinv_8
XFILLER_0_23_335 VGND VGND VPWR VPWR sky130_fd_sc_hd__fill_1
XFILLER_0_121_587 VGND VGND VPWR VPWR sky130_fd_sc_hd__fill_1
XFILLER_0_76_27 VGND VGND VPWR VPWR sky130_fd_sc_hd__fill_1
XFILLER_0_92_15 VPWR VGND VPWR VGND sky130_ef_sc_hd__decap_12
Xclkbuf_leaf_0_clk clknet_2_0__leaf_clk VGND VGND VPWR VPWR clknet_leaf_0_clk sky130_fd_sc_hd__clkbuf_8
XTAP_TAPCELL_ROW_19_500 VGND VPWR sky130_fd_sc_hd__tapvpwrvgnd_1
XFILLER_0_59_722 VGND VGND VPWR VPWR sky130_fd_sc_hd__fill_2
XFILLER_0_59_700 VGND VGND VPWR VPWR sky130_fd_sc_hd__fill_1
X_05630_ _00614_ _00615_ VGND VGND VPWR VPWR _00616_ sky130_fd_sc_hd__or2_2
XTAP_TAPCELL_ROW_47_853 VGND VPWR sky130_fd_sc_hd__tapvpwrvgnd_1
XFILLER_0_116_77 VGND VGND VPWR VPWR sky130_fd_sc_hd__decap_6
XTAP_TAPCELL_ROW_63_1044 VGND VPWR sky130_fd_sc_hd__tapvpwrvgnd_1
X_07300_ tanh_inst.LOOKUP.index\[4\] tanh_inst.LOOKUP.index\[3\] tanh_inst.LOOKUP.index\[2\]
+ tanh_inst.LOOKUP.index\[1\] VGND VGND VPWR VPWR _02110_ sky130_fd_sc_hd__or4b_2
XFILLER_0_19_608 VGND VGND VPWR VPWR sky130_fd_sc_hd__decap_8
X_05561_ _00552_ VGND VGND VPWR VPWR _00553_ sky130_fd_sc_hd__inv_2
XTAP_TAPCELL_ROW_63_1055 VGND VPWR sky130_fd_sc_hd__tapvpwrvgnd_1
X_05492_ _00465_ _00466_ _00481_ mac_inst.z\[31\] VGND VGND VPWR VPWR _00490_ sky130_fd_sc_hd__a31o_2
X_08280_ _04791_ _03069_ _03068_ VGND VGND VPWR VPWR _03070_ sky130_fd_sc_hd__a21oi_2
X_07231_ tanh_inst.divider.y\[-13\] _02028_ _02029_ VGND VGND VPWR VPWR _02041_ sky130_fd_sc_hd__o21ai_2
XFILLER_0_41_74 VGND VGND VPWR VPWR sky130_fd_sc_hd__decap_8
X_07162_ tanh_inst.divider.z_\[0\] _01965_ _01975_ tanh_inst.divider.z_\[1\] VGND
+ VGND VPWR VPWR _01982_ sky130_fd_sc_hd__a22oi_2
XFILLER_0_73_279 VGND VGND VPWR VPWR sky130_fd_sc_hd__fill_1
X_06113_ _01059_ VGND VGND VPWR VPWR _01060_ sky130_fd_sc_hd__inv_2
XFILLER_0_26_195 VGND VGND VPWR VPWR sky130_fd_sc_hd__fill_1
X_07093_ _01919_ _01920_ VGND VGND VPWR VPWR _01921_ sky130_fd_sc_hd__and2_2
XFILLER_0_10_530 VGND VGND VPWR VPWR sky130_fd_sc_hd__fill_2
X_06044_ _00987_ _00994_ VGND VGND VPWR VPWR _00995_ sky130_fd_sc_hd__nor2_2
XFILLER_0_41_198 VGND VGND VPWR VPWR sky130_fd_sc_hd__fill_1
XFILLER_0_1_273 VGND VGND VPWR VPWR sky130_fd_sc_hd__decap_6
XTAP_TAPCELL_ROW_74_1184 VGND VPWR sky130_fd_sc_hd__tapvpwrvgnd_1
X_09803_ _04523_ _04524_ VGND VGND VPWR VPWR _04525_ sky130_fd_sc_hd__and2_2
X_07995_ tanh_inst.divider.y\[-10\] _02789_ VGND VGND VPWR VPWR _02791_ sky130_fd_sc_hd__and2_2
X_06946_ _01787_ _01788_ VGND VGND VPWR VPWR _01790_ sky130_fd_sc_hd__nand2_2
XFILLER_0_66_82 VGND VGND VPWR VPWR sky130_fd_sc_hd__fill_2
X_09734_ tanh_inst.divider.x\[-2\] _04456_ VGND VGND VPWR VPWR _04458_ sky130_fd_sc_hd__and2_2
X_06877_ _01502_ _01760_ _01761_ _01469_ mac_y_out[30] VGND VGND VPWR VPWR _00158_
+ sky130_fd_sc_hd__a32o_2
XPHY_EDGE_ROW_19_Left_141 VGND VGND VPWR VPWR sky130_fd_sc_hd__decap_3
X_09665_ tanh_inst.divider.x\[-4\] _04390_ VGND VGND VPWR VPWR _04391_ sky130_fd_sc_hd__nor2_2
XFILLER_0_96_327 VGND VGND VPWR VPWR sky130_fd_sc_hd__fill_1
X_05828_ _04943_ _00794_ VGND VGND VPWR VPWR _00795_ sky130_fd_sc_hd__nand2_2
X_08616_ _03240_ _03290_ _03292_ _03397_ VGND VGND VPWR VPWR _03398_ sky130_fd_sc_hd__o211a_2
XFILLER_0_96_349 VGND VGND VPWR VPWR sky130_fd_sc_hd__decap_3
XFILLER_0_89_390 VGND VGND VPWR VPWR sky130_fd_sc_hd__fill_2
XFILLER_0_82_92 VGND VGND VPWR VPWR sky130_fd_sc_hd__decap_4
X_09596_ _04322_ _04323_ VGND VGND VPWR VPWR _04324_ sky130_fd_sc_hd__nand2_2
X_08547_ tanh_inst.divider.y\[3\] _03329_ VGND VGND VPWR VPWR _03330_ sky130_fd_sc_hd__nor2_2
X_05759_ mac_inst.z\[31\] _00719_ _00731_ VGND VGND VPWR VPWR _00732_ sky130_fd_sc_hd__o21a_2
XFILLER_0_49_254 VGND VGND VPWR VPWR sky130_fd_sc_hd__fill_2
XTAP_TAPCELL_ROW_25_569 VGND VPWR sky130_fd_sc_hd__tapvpwrvgnd_1
XFILLER_0_37_449 VPWR VGND VPWR VGND sky130_ef_sc_hd__decap_12
X_08478_ tanh_inst.divider.x\[1\] _03250_ VGND VGND VPWR VPWR _03263_ sky130_fd_sc_hd__xnor2_2
X_07429_ _02235_ _02236_ VGND VGND VPWR VPWR _02237_ sky130_fd_sc_hd__xor2_2
X_10440_ clknet_leaf_25_clk _00297_ VGND VGND VPWR VPWR tanh_inst.divider.y\[-24\]
+ sky130_fd_sc_hd__dfxtp_2
XFILLER_0_33_611 VGND VGND VPWR VPWR sky130_fd_sc_hd__decap_4
XFILLER_0_45_482 VPWR VGND VPWR VGND sky130_ef_sc_hd__decap_12
XFILLER_0_52_419 VGND VGND VPWR VPWR sky130_fd_sc_hd__fill_1
XFILLER_0_60_441 VPWR VGND VPWR VGND sky130_ef_sc_hd__decap_12
XPHY_EDGE_ROW_28_Left_150 VGND VGND VPWR VPWR sky130_fd_sc_hd__decap_3
X_10371_ clknet_leaf_16_clk _00228_ VGND VGND VPWR VPWR tanh_inst.divider.z_\[7\]
+ sky130_fd_sc_hd__dfxtp_2
XFILLER_0_1_3 VPWR VGND VPWR VGND sky130_ef_sc_hd__decap_12
XFILLER_0_62_18 VGND VGND VPWR VPWR sky130_fd_sc_hd__decap_8
XTAP_TAPCELL_ROW_44_812 VGND VPWR sky130_fd_sc_hd__tapvpwrvgnd_1
XFILLER_0_83_500 VGND VGND VPWR VPWR sky130_fd_sc_hd__decap_4
XFILLER_0_43_419 VGND VGND VPWR VPWR sky130_fd_sc_hd__decap_8
XFILLER_0_11_55 VGND VGND VPWR VPWR sky130_fd_sc_hd__fill_1
XFILLER_0_11_305 VPWR VGND VPWR VGND sky130_ef_sc_hd__decap_12
XFILLER_0_87_48 VGND VGND VPWR VPWR sky130_fd_sc_hd__decap_8
XFILLER_0_11_349 VPWR VGND VPWR VGND sky130_ef_sc_hd__decap_12
XTAP_TAPCELL_ROW_110_1638 VGND VPWR sky130_fd_sc_hd__tapvpwrvgnd_1
X_07780_ tanh_inst.divider.y\[-15\] tanh_inst.divider.x\[-15\] VGND VGND VPWR VPWR
+ _02581_ sky130_fd_sc_hd__or2_2
X_06800_ _01689_ _01694_ VGND VGND VPWR VPWR _01695_ sky130_fd_sc_hd__nand2_2
XFILLER_0_36_41 VGND VGND VPWR VPWR sky130_fd_sc_hd__fill_2
X_06731_ _01631_ _01632_ VGND VGND VPWR VPWR _01633_ sky130_fd_sc_hd__nor2_2
X_09450_ _04180_ _04181_ _04179_ VGND VGND VPWR VPWR _04182_ sky130_fd_sc_hd__a21oi_2
XFILLER_0_36_85 VGND VGND VPWR VPWR sky130_fd_sc_hd__decap_8
X_06662_ tanh_inst.LOOKUP.index\[2\] _01526_ _01474_ VGND VGND VPWR VPWR _01571_ sky130_fd_sc_hd__o21ai_2
X_08401_ _03176_ _03187_ _02018_ VGND VGND VPWR VPWR _03188_ sky130_fd_sc_hd__a21oi_2
Xclkbuf_2_1__f_clk clknet_0_clk VGND VGND VPWR VPWR clknet_2_1__leaf_clk sky130_fd_sc_hd__clkbuf_16
X_06593_ tanh_inst.z_\[-23\] _01506_ VGND VGND VPWR VPWR _01507_ sky130_fd_sc_hd__nand2_2
X_09381_ _01525_ _03808_ _03814_ _01477_ VGND VGND VPWR VPWR _04115_ sky130_fd_sc_hd__o22a_2
X_05613_ _00575_ _00576_ _00587_ VGND VGND VPWR VPWR _00600_ sky130_fd_sc_hd__nand3_2
XFILLER_0_74_533 VGND VGND VPWR VPWR sky130_fd_sc_hd__decap_4
XFILLER_0_19_449 VGND VGND VPWR VPWR sky130_fd_sc_hd__decap_8
X_08332_ _03068_ _03069_ _03108_ _04791_ VGND VGND VPWR VPWR _03120_ sky130_fd_sc_hd__o31a_2
X_05544_ _00530_ _00527_ _00526_ mac_inst.y\[16\] VGND VGND VPWR VPWR _00538_ sky130_fd_sc_hd__a2bb2o_2
XTAP_TAPCELL_ROW_121_1789 VGND VPWR sky130_fd_sc_hd__tapvpwrvgnd_1
XTAP_TAPCELL_ROW_121_1778 VGND VPWR sky130_fd_sc_hd__tapvpwrvgnd_1
XFILLER_0_74_555 VGND VGND VPWR VPWR sky130_fd_sc_hd__decap_6
X_08263_ _02889_ _02927_ _03051_ VGND VGND VPWR VPWR _03053_ sky130_fd_sc_hd__or3_2
XTAP_TAPCELL_ROW_22_539 VGND VPWR sky130_fd_sc_hd__tapvpwrvgnd_1
X_07214_ _01514_ _02021_ VGND VGND VPWR VPWR _02024_ sky130_fd_sc_hd__nor2_2
XFILLER_0_6_321 VPWR VGND VPWR VGND sky130_ef_sc_hd__decap_12
X_05475_ _00457_ _00471_ _00469_ VGND VGND VPWR VPWR _00474_ sky130_fd_sc_hd__o21bai_2
XFILLER_0_14_121 VPWR VGND VPWR VGND sky130_ef_sc_hd__decap_12
XFILLER_0_6_365 VPWR VGND VPWR VGND sky130_ef_sc_hd__decap_12
XFILLER_0_42_430 VGND VGND VPWR VPWR sky130_fd_sc_hd__decap_8
X_08194_ tanh_inst.LOOKUP.index\[4\] _02251_ _02859_ VGND VGND VPWR VPWR _02986_ sky130_fd_sc_hd__o21a_2
X_07145_ tanh_inst.divider.z_\[0\] _01965_ VGND VGND VPWR VPWR _01967_ sky130_fd_sc_hd__or2_2
XTAP_TAPCELL_ROW_76_1213 VGND VPWR sky130_fd_sc_hd__tapvpwrvgnd_1
XFILLER_0_14_165 VPWR VGND VPWR VGND sky130_ef_sc_hd__decap_12
X_07076_ _01897_ _01900_ _01905_ VGND VGND VPWR VPWR _01906_ sky130_fd_sc_hd__a21oi_2
XFILLER_0_15_699 VGND VGND VPWR VPWR sky130_fd_sc_hd__decap_3
XFILLER_0_30_625 VGND VGND VPWR VPWR sky130_fd_sc_hd__decap_4
X_06027_ mac_inst.z\[26\] _00977_ VGND VGND VPWR VPWR _00980_ sky130_fd_sc_hd__nand2_2
X_07978_ _04757_ _02773_ _02774_ VGND VGND VPWR VPWR _02775_ sky130_fd_sc_hd__o21ai_2
X_06929_ tanh_inst.divider.z_\[-24\] _01055_ _01772_ tanh_inst.div_en VGND VGND VPWR
+ VPWR _01775_ sky130_fd_sc_hd__a31o_2
X_09717_ _04439_ _04440_ VGND VGND VPWR VPWR _04441_ sky130_fd_sc_hd__nor2_2
XTAP_TAPCELL_ROW_87_1353 VGND VPWR sky130_fd_sc_hd__tapvpwrvgnd_1
XFILLER_0_69_349 VPWR VGND VPWR VGND sky130_ef_sc_hd__decap_12
XTAP_TAPCELL_ROW_2_286 VGND VPWR sky130_fd_sc_hd__tapvpwrvgnd_1
X_09648_ _04292_ _04303_ _04371_ _04373_ VGND VGND VPWR VPWR _04374_ sky130_fd_sc_hd__a31o_2
X_09579_ _03682_ _03683_ _02053_ VGND VGND VPWR VPWR _04307_ sky130_fd_sc_hd__a21o_2
XFILLER_0_92_352 VPWR VGND VPWR VGND sky130_ef_sc_hd__decap_12
XFILLER_0_9_181 VPWR VGND VPWR VGND sky130_ef_sc_hd__decap_12
XFILLER_0_18_482 VGND VGND VPWR VPWR sky130_fd_sc_hd__decap_6
XTAP_TAPCELL_ROW_98_1482 VGND VPWR sky130_fd_sc_hd__tapvpwrvgnd_1
X_10423_ clknet_leaf_37_clk _00280_ _00000_ VGND VGND VPWR VPWR mac_inst.i\[15\] sky130_fd_sc_hd__dfrtp_2
XTAP_TAPCELL_ROW_98_1493 VGND VPWR sky130_fd_sc_hd__tapvpwrvgnd_1
X_10354_ clknet_leaf_21_clk _00211_ VGND VGND VPWR VPWR tanh_inst.divider.z_\[-10\]
+ sky130_fd_sc_hd__dfxtp_2
X_10285_ clknet_leaf_30_clk _00142_ VGND VGND VPWR VPWR tanh_inst.z_\[-10\] sky130_fd_sc_hd__dfxtp_2
XTAP_TAPCELL_ROW_57_970 VGND VPWR sky130_fd_sc_hd__tapvpwrvgnd_1
XFILLER_0_56_533 VGND VGND VPWR VPWR sky130_fd_sc_hd__decap_8
XTAP_TAPCELL_ROW_60_1014 VGND VPWR sky130_fd_sc_hd__tapvpwrvgnd_1
XFILLER_0_71_503 VGND VGND VPWR VPWR sky130_fd_sc_hd__fill_1
XFILLER_0_16_419 VGND VGND VPWR VPWR sky130_fd_sc_hd__fill_1
XFILLER_0_22_65 VPWR VGND VPWR VGND sky130_ef_sc_hd__decap_12
XFILLER_0_118_3 VPWR VGND VPWR VGND sky130_ef_sc_hd__decap_12
X_05260_ mac_inst.i\[15\] mac_inst.i\[17\] VGND VGND VPWR VPWR _04961_ sky130_fd_sc_hd__or2_2
XFILLER_0_3_335 VGND VGND VPWR VPWR sky130_fd_sc_hd__fill_1
X_05191_ mac_inst.x\[12\] _04852_ _04853_ VGND VGND VPWR VPWR _04895_ sky130_fd_sc_hd__a21oi_2
XFILLER_0_24_441 VGND VGND VPWR VPWR sky130_fd_sc_hd__decap_6
XFILLER_0_11_113 VPWR VGND VPWR VGND sky130_ef_sc_hd__decap_12
XFILLER_0_12_669 VGND VGND VPWR VPWR sky130_fd_sc_hd__decap_4
XFILLER_0_121_181 VPWR VGND VPWR VGND sky130_ef_sc_hd__decap_12
X_08950_ _02237_ _03684_ VGND VGND VPWR VPWR _03694_ sky130_fd_sc_hd__xnor2_2
XFILLER_0_51_7 VGND VGND VPWR VPWR sky130_fd_sc_hd__fill_1
X_07901_ _02698_ VGND VGND VPWR VPWR _02699_ sky130_fd_sc_hd__inv_2
X_08881_ _02052_ _03568_ _03569_ _02173_ VGND VGND VPWR VPWR _03626_ sky130_fd_sc_hd__o211ai_2
XTAP_TAPCELL_ROW_71_1154 VGND VPWR sky130_fd_sc_hd__tapvpwrvgnd_1
X_07832_ _02630_ _02631_ VGND VGND VPWR VPWR _02632_ sky130_fd_sc_hd__and2_2
XFILLER_0_79_614 VGND VGND VPWR VPWR sky130_fd_sc_hd__fill_2
XFILLER_0_79_603 VGND VGND VPWR VPWR sky130_fd_sc_hd__decap_6
X_09502_ tanh_inst.divider.y\[-8\] _04231_ VGND VGND VPWR VPWR _04232_ sky130_fd_sc_hd__nor2_2
X_07763_ tanh_inst.LOOKUP.index\[3\] _02117_ _02509_ VGND VGND VPWR VPWR _02565_ sky130_fd_sc_hd__o21ai_2
X_07694_ _02495_ _02496_ VGND VGND VPWR VPWR _02497_ sky130_fd_sc_hd__and2b_2
XFILLER_0_63_50 VGND VGND VPWR VPWR sky130_fd_sc_hd__fill_1
X_06714_ _01601_ _01608_ _01610_ _01607_ VGND VGND VPWR VPWR _01618_ sky130_fd_sc_hd__a31o_2
XFILLER_0_2_53 VPWR VGND VPWR VGND sky130_ef_sc_hd__decap_12
X_06645_ tanh_inst.LOOKUP.index\[2\] _04761_ _01476_ _01555_ VGND VGND VPWR VPWR _01556_
+ sky130_fd_sc_hd__a31oi_2
XFILLER_0_2_97 VPWR VGND VPWR VGND sky130_ef_sc_hd__decap_12
X_09433_ _04161_ _04164_ VGND VGND VPWR VPWR _04165_ sky130_fd_sc_hd__xnor2_2
X_09364_ tanh_inst.z_\[7\] _04097_ VGND VGND VPWR VPWR _04098_ sky130_fd_sc_hd__or2_2
XFILLER_0_93_149 VGND VGND VPWR VPWR sky130_fd_sc_hd__decap_3
XTAP_TAPCELL_ROW_82_1283 VGND VPWR sky130_fd_sc_hd__tapvpwrvgnd_1
XFILLER_0_59_393 VPWR VGND VPWR VGND sky130_ef_sc_hd__decap_12
X_06576_ tanh_inst.z_\[-7\] tanh_inst.z_\[-8\] tanh_inst.z_\[-5\] tanh_inst.z_\[-6\]
+ VGND VGND VPWR VPWR _01491_ sky130_fd_sc_hd__or4_2
X_08315_ _03102_ _03103_ VGND VGND VPWR VPWR _03104_ sky130_fd_sc_hd__or2_2
XTAP_TAPCELL_ROW_35_697 VGND VPWR sky130_fd_sc_hd__tapvpwrvgnd_1
X_09295_ _03964_ _03966_ _04002_ _04030_ VGND VGND VPWR VPWR _04031_ sky130_fd_sc_hd__a31o_2
XFILLER_0_19_279 VGND VGND VPWR VPWR sky130_fd_sc_hd__fill_1
XFILLER_0_35_717 VGND VGND VPWR VPWR sky130_fd_sc_hd__decap_6
X_05527_ _00510_ _00521_ VGND VGND VPWR VPWR _00522_ sky130_fd_sc_hd__nand2_2
XFILLER_0_117_454 VPWR VGND VPWR VGND sky130_ef_sc_hd__decap_12
X_05458_ _00457_ _00458_ VGND VGND VPWR VPWR _00459_ sky130_fd_sc_hd__nor2_2
X_08246_ _03035_ _03034_ VGND VGND VPWR VPWR _03036_ sky130_fd_sc_hd__and2b_2
XFILLER_0_105_649 VGND VGND VPWR VPWR sky130_fd_sc_hd__fill_1
XFILLER_0_6_195 VGND VGND VPWR VPWR sky130_fd_sc_hd__fill_1
X_08177_ _02962_ _02964_ _02967_ VGND VGND VPWR VPWR _02969_ sky130_fd_sc_hd__and3_2
X_07128_ _01950_ _01951_ VGND VGND VPWR VPWR _01952_ sky130_fd_sc_hd__or2_2
X_05389_ mac_inst.y\[5\] _00394_ VGND VGND VPWR VPWR _00395_ sky130_fd_sc_hd__nor2_2
XFILLER_0_30_455 VGND VGND VPWR VPWR sky130_fd_sc_hd__fill_2
XFILLER_0_112_170 VGND VGND VPWR VPWR sky130_fd_sc_hd__fill_1
XFILLER_0_100_321 VGND VGND VPWR VPWR sky130_fd_sc_hd__decap_4
X_07059_ _01881_ _01890_ _01889_ VGND VGND VPWR VPWR _01891_ sky130_fd_sc_hd__a21o_2
XFILLER_0_100_365 VPWR VGND VPWR VGND sky130_ef_sc_hd__decap_12
X_10070_ clknet_leaf_13_clk _00087_ VGND VGND VPWR VPWR tanh_inst.divider.y_\[-23\]
+ sky130_fd_sc_hd__dfxtp_2
XTAP_TAPCELL_ROW_7_345 VGND VPWR sky130_fd_sc_hd__tapvpwrvgnd_1
XPHY_EDGE_ROW_102_Right_102 VGND VGND VPWR VPWR sky130_fd_sc_hd__decap_3
XFILLER_0_69_113 VGND VGND VPWR VPWR sky130_fd_sc_hd__fill_1
XFILLER_0_85_617 VGND VGND VPWR VPWR sky130_fd_sc_hd__decap_8
XTAP_TAPCELL_ROW_54_940 VGND VPWR sky130_fd_sc_hd__tapvpwrvgnd_1
XFILLER_0_78_680 VGND VGND VPWR VPWR sky130_fd_sc_hd__fill_1
XFILLER_0_84_149 VGND VGND VPWR VPWR sky130_fd_sc_hd__fill_2
XFILLER_0_77_190 VGND VGND VPWR VPWR sky130_fd_sc_hd__decap_3
XFILLER_0_65_385 VGND VGND VPWR VPWR sky130_fd_sc_hd__decap_6
XFILLER_0_53_503 VGND VGND VPWR VPWR sky130_fd_sc_hd__fill_1
XFILLER_0_80_333 VGND VGND VPWR VPWR sky130_fd_sc_hd__fill_1
XFILLER_0_25_249 VPWR VGND VPWR VGND sky130_ef_sc_hd__decap_12
X_10406_ clknet_leaf_3_clk _00263_ VGND VGND VPWR VPWR tanh_inst.divider.x\[6\] sky130_fd_sc_hd__dfxtp_2
XFILLER_0_0_305 VGND VGND VPWR VPWR sky130_fd_sc_hd__decap_3
X_10337_ clknet_leaf_16_clk _00194_ VGND VGND VPWR VPWR tanh_out[29] sky130_fd_sc_hd__dfxtp_2
XFILLER_0_103_181 VGND VGND VPWR VPWR sky130_fd_sc_hd__decap_6
XFILLER_0_0_349 VPWR VGND VPWR VGND sky130_ef_sc_hd__decap_12
X_10268_ clknet_leaf_31_clk mac_inst.x\[30\] _00000_ VGND VGND VPWR VPWR mac_x_out[30]
+ sky130_fd_sc_hd__dfrtp_2
XFILLER_0_84_27 VGND VGND VPWR VPWR sky130_fd_sc_hd__fill_1
X_10199_ x_in[25] _00000_ VGND VGND VPWR VPWR mac_inst.x\[25\] sky130_fd_sc_hd__dlxtn_1
X_06430_ tanh_inst.divider.y\[-4\] tanh_inst.div_en tanh_inst.divider.y_\[-4\] _01092_
+ _01356_ VGND VGND VPWR VPWR _00106_ sky130_fd_sc_hd__a221o_2
XFILLER_0_56_330 VGND VGND VPWR VPWR sky130_fd_sc_hd__fill_1
XFILLER_0_8_427 VGND VGND VPWR VPWR sky130_fd_sc_hd__decap_8
X_06361_ tanh_inst.divider.y_\[-9\] _01292_ VGND VGND VPWR VPWR _01293_ sky130_fd_sc_hd__and2_2
XFILLER_0_56_374 VGND VGND VPWR VPWR sky130_fd_sc_hd__decap_3
XTAP_TAPCELL_ROW_32_656 VGND VPWR sky130_fd_sc_hd__tapvpwrvgnd_1
XFILLER_0_33_97 VGND VGND VPWR VPWR sky130_fd_sc_hd__decap_3
X_06292_ _01228_ VGND VGND VPWR VPWR _01229_ sky130_fd_sc_hd__inv_2
X_09080_ _03776_ _03777_ _03774_ VGND VGND VPWR VPWR _03822_ sky130_fd_sc_hd__a21o_2
X_08100_ _02868_ _02892_ VGND VGND VPWR VPWR _02894_ sky130_fd_sc_hd__xnor2_2
XTAP_TAPCELL_ROW_32_667 VGND VPWR sky130_fd_sc_hd__tapvpwrvgnd_1
X_05312_ mac_inst.y\[1\] _05010_ VGND VGND VPWR VPWR _05012_ sky130_fd_sc_hd__xnor2_2
X_08031_ _02826_ VGND VGND VPWR VPWR _02827_ sky130_fd_sc_hd__inv_2
X_05243_ mac_inst.i\[4\] _04935_ _04937_ VGND VGND VPWR VPWR _04944_ sky130_fd_sc_hd__o21ai_2
X_05174_ mac_inst.i\[0\] _04841_ _04844_ _04850_ _04788_ VGND VGND VPWR VPWR _04878_
+ sky130_fd_sc_hd__o41a_2
X_09982_ tanh_inst.divider.y\[5\] _04698_ VGND VGND VPWR VPWR _04699_ sky130_fd_sc_hd__nand2_2
XFILLER_0_12_477 VGND VGND VPWR VPWR sky130_fd_sc_hd__decap_6
XFILLER_0_110_674 VGND VGND VPWR VPWR sky130_fd_sc_hd__fill_1
X_08933_ _03541_ _03546_ _03547_ _03542_ tanh_inst.LOOKUP.index\[1\] tanh_inst.LOOKUP.index\[0\]
+ VGND VGND VPWR VPWR _03677_ sky130_fd_sc_hd__mux4_2
XTAP_TAPCELL_ROW_4_315 VGND VPWR sky130_fd_sc_hd__tapvpwrvgnd_1
XFILLER_0_42_3 VPWR VGND VPWR VGND sky130_ef_sc_hd__decap_12
X_08864_ _03607_ _03608_ _02025_ VGND VGND VPWR VPWR _03609_ sky130_fd_sc_hd__mux2_1
X_07815_ _04772_ _02613_ VGND VGND VPWR VPWR _02615_ sky130_fd_sc_hd__nand2_2
X_08795_ tanh_inst.divider.x\[4\] _02028_ _03508_ VGND VGND VPWR VPWR _03541_ sky130_fd_sc_hd__o21a_2
X_07746_ tanh_inst.divider.y\[-16\] tanh_inst.divider.x\[-16\] VGND VGND VPWR VPWR
+ _02548_ sky130_fd_sc_hd__and2_2
XFILLER_0_94_403 VGND VGND VPWR VPWR sky130_fd_sc_hd__decap_6
XTAP_TAPCELL_ROW_84_1312 VGND VPWR sky130_fd_sc_hd__tapvpwrvgnd_1
XFILLER_0_79_477 VGND VGND VPWR VPWR sky130_fd_sc_hd__fill_1
X_07677_ _02429_ _02479_ _02478_ VGND VGND VPWR VPWR _02481_ sky130_fd_sc_hd__a21oi_2
X_09416_ tanh_inst.LOOKUP.index\[3\] _03852_ _03938_ VGND VGND VPWR VPWR _04149_ sky130_fd_sc_hd__o21a_2
XFILLER_0_75_650 VGND VGND VPWR VPWR sky130_fd_sc_hd__fill_1
X_06628_ _01539_ _01540_ VGND VGND VPWR VPWR _01541_ sky130_fd_sc_hd__or2_2
X_09347_ tanh_inst.divider.y\[-13\] _04080_ VGND VGND VPWR VPWR _04082_ sky130_fd_sc_hd__xnor2_2
XFILLER_0_74_160 VGND VGND VPWR VPWR sky130_fd_sc_hd__decap_8
X_06559_ tanh_inst.LOOKUP.index\[4\] tanh_inst.LOOKUP.index\[3\] tanh_inst.LOOKUP.index\[2\]
+ tanh_inst.LOOKUP.index\[1\] VGND VGND VPWR VPWR _01474_ sky130_fd_sc_hd__nand4_2
XFILLER_0_35_503 VGND VGND VPWR VPWR sky130_fd_sc_hd__fill_1
XFILLER_0_90_631 VGND VGND VPWR VPWR sky130_fd_sc_hd__fill_1
X_09278_ _03983_ _03985_ _04014_ VGND VGND VPWR VPWR _04015_ sky130_fd_sc_hd__a21oi_2
XFILLER_0_62_322 VGND VGND VPWR VPWR sky130_fd_sc_hd__fill_2
XFILLER_0_7_471 VGND VGND VPWR VPWR sky130_fd_sc_hd__decap_4
XFILLER_0_23_709 VPWR VGND VPWR VGND sky130_ef_sc_hd__decap_12
X_08229_ _02822_ _02913_ _03019_ tanh_inst.z_\[7\] VGND VGND VPWR VPWR _03020_ sky130_fd_sc_hd__a31o_2
XFILLER_0_62_388 VPWR VGND VPWR VGND sky130_ef_sc_hd__decap_12
XTAP_TAPCELL_ROW_95_1452 VGND VPWR sky130_fd_sc_hd__tapvpwrvgnd_1
XFILLER_0_15_293 VPWR VGND VPWR VGND sky130_ef_sc_hd__decap_12
XFILLER_0_120_438 VGND VGND VPWR VPWR sky130_fd_sc_hd__fill_1
XFILLER_0_30_296 VGND VGND VPWR VPWR sky130_fd_sc_hd__decap_6
XFILLER_0_101_696 VGND VGND VPWR VPWR sky130_fd_sc_hd__fill_1
X_10053_ rst VGND VGND VPWR VPWR _00072_ sky130_fd_sc_hd__inv_2
XFILLER_0_26_503 VGND VGND VPWR VPWR sky130_fd_sc_hd__decap_8
XFILLER_0_38_363 VGND VGND VPWR VPWR sky130_fd_sc_hd__fill_1
XFILLER_0_53_333 VGND VGND VPWR VPWR sky130_fd_sc_hd__decap_3
XFILLER_0_53_377 VGND VGND VPWR VPWR sky130_fd_sc_hd__fill_2
XFILLER_0_0_113 VPWR VGND VPWR VGND sky130_ef_sc_hd__decap_12
XFILLER_0_95_15 VPWR VGND VPWR VGND sky130_ef_sc_hd__decap_12
XFILLER_0_119_55 VGND VGND VPWR VPWR sky130_fd_sc_hd__fill_1
X_05930_ _00867_ _00877_ _00889_ VGND VGND VPWR VPWR _00890_ sky130_fd_sc_hd__and3_2
XFILLER_0_28_53 VPWR VGND VPWR VGND sky130_ef_sc_hd__decap_12
X_05861_ mac_inst.z\[31\] _00825_ _00823_ VGND VGND VPWR VPWR _00826_ sky130_fd_sc_hd__o21ai_2
X_07600_ tanh_inst.divider.y\[-19\] tanh_inst.divider.x\[-19\] VGND VGND VPWR VPWR
+ _02405_ sky130_fd_sc_hd__or2_2
XFILLER_0_89_720 VGND VGND VPWR VPWR sky130_fd_sc_hd__decap_4
X_08580_ tanh_inst.divider.y\[4\] _03360_ VGND VGND VPWR VPWR _03362_ sky130_fd_sc_hd__and2_2
XFILLER_0_88_230 VGND VGND VPWR VPWR sky130_fd_sc_hd__decap_8
X_07531_ _02229_ _02230_ _02295_ _02336_ _02294_ VGND VGND VPWR VPWR _02337_ sky130_fd_sc_hd__a311o_2
X_05792_ _00741_ _00748_ _00761_ mac_inst.z\[31\] VGND VGND VPWR VPWR _00762_ sky130_fd_sc_hd__a31o_2
XTAP_TAPCELL_ROW_37_726 VGND VPWR sky130_fd_sc_hd__tapvpwrvgnd_1
XFILLER_0_49_628 VGND VGND VPWR VPWR sky130_fd_sc_hd__fill_2
X_07462_ _02203_ _02269_ _01469_ VGND VGND VPWR VPWR _00235_ sky130_fd_sc_hd__a21oi_2
XTAP_TAPCELL_ROW_66_1086 VGND VPWR sky130_fd_sc_hd__tapvpwrvgnd_1
XTAP_TAPCELL_ROW_17_472 VGND VPWR sky130_fd_sc_hd__tapvpwrvgnd_1
XFILLER_0_44_96 VGND VGND VPWR VPWR sky130_fd_sc_hd__fill_2
X_06413_ tanh_inst.divider.y\[-5\] tanh_inst.div_en tanh_inst.divider.y_\[-5\] _01092_
+ VGND VGND VPWR VPWR _01341_ sky130_fd_sc_hd__a22o_2
XFILLER_0_91_417 VGND VGND VPWR VPWR sky130_fd_sc_hd__decap_4
X_07393_ tanh_inst.divider.x\[-23\] _02015_ _02201_ VGND VGND VPWR VPWR _02202_ sky130_fd_sc_hd__a21oi_2
X_09201_ tanh_inst.LOOKUP.index\[3\] _03939_ _03938_ VGND VGND VPWR VPWR _03940_ sky130_fd_sc_hd__o21a_2
X_06344_ tanh_inst.divider.i\[3\] _01174_ _01187_ VGND VGND VPWR VPWR _01277_ sky130_fd_sc_hd__o21a_2
X_09132_ _02022_ _03869_ _03871_ _02053_ VGND VGND VPWR VPWR _03872_ sky130_fd_sc_hd__a211o_2
XFILLER_0_72_642 VGND VGND VPWR VPWR sky130_fd_sc_hd__fill_2
XFILLER_0_56_171 VPWR VGND VPWR VGND sky130_ef_sc_hd__decap_12
XFILLER_0_29_385 VGND VGND VPWR VPWR sky130_fd_sc_hd__fill_1
X_06275_ tanh_inst.divider.y\[-16\] tanh_inst.div_en tanh_inst.divider.y_\[-16\] _01092_
+ VGND VGND VPWR VPWR _01214_ sky130_fd_sc_hd__a22o_2
XTAP_TAPCELL_ROW_118_1739 VGND VPWR sky130_fd_sc_hd__tapvpwrvgnd_1
X_09063_ _03749_ _03754_ _03803_ VGND VGND VPWR VPWR _03805_ sky130_fd_sc_hd__a21o_2
XFILLER_0_8_41 VPWR VGND VPWR VGND sky130_ef_sc_hd__decap_12
X_08014_ _02786_ _02809_ VGND VGND VPWR VPWR _02810_ sky130_fd_sc_hd__or2_2
XFILLER_0_71_196 VGND VGND VPWR VPWR sky130_fd_sc_hd__fill_2
XFILLER_0_4_485 VGND VGND VPWR VPWR sky130_fd_sc_hd__decap_8
XFILLER_0_4_474 VGND VGND VPWR VPWR sky130_fd_sc_hd__fill_2
X_05226_ _04928_ _04929_ VGND VGND VPWR VPWR _05226_/Y sky130_fd_sc_hd__nand2_2
XFILLER_0_69_82 VGND VGND VPWR VPWR sky130_fd_sc_hd__decap_8
XFILLER_0_8_85 VPWR VGND VPWR VGND sky130_ef_sc_hd__decap_12
X_05157_ _04855_ _04857_ _04858_ _04860_ _04783_ mac_inst.i\[1\] VGND VGND VPWR VPWR
+ _04861_ sky130_fd_sc_hd__mux4_2
XFILLER_0_40_561 VGND VGND VPWR VPWR sky130_fd_sc_hd__decap_3
X_09965_ _04681_ VGND VGND VPWR VPWR _04682_ sky130_fd_sc_hd__inv_2
X_05088_ tanh_counter\[7\] tanh_counter\[6\] _04807_ _04809_ VGND VGND VPWR VPWR _04810_
+ sky130_fd_sc_hd__a31o_2
XTAP_TAPCELL_ROW_90_1393 VGND VPWR sky130_fd_sc_hd__tapvpwrvgnd_1
XTAP_TAPCELL_ROW_90_1382 VGND VPWR sky130_fd_sc_hd__tapvpwrvgnd_1
XFILLER_0_85_70 VGND VGND VPWR VPWR sky130_fd_sc_hd__decap_6
X_08916_ tanh_inst.divider.y\[-23\] _03660_ VGND VGND VPWR VPWR _03661_ sky130_fd_sc_hd__and2_2
X_09896_ tanh_inst.divider.y\[3\] _04611_ VGND VGND VPWR VPWR _04615_ sky130_fd_sc_hd__and2_2
XFILLER_0_99_517 VPWR VGND VPWR VGND sky130_ef_sc_hd__decap_12
X_08847_ _03508_ _03590_ _02027_ VGND VGND VPWR VPWR _03592_ sky130_fd_sc_hd__a21o_2
X_08778_ _03508_ _03523_ VGND VGND VPWR VPWR _03524_ sky130_fd_sc_hd__and2_2
X_07729_ _02022_ _02078_ _02488_ VGND VGND VPWR VPWR _02531_ sky130_fd_sc_hd__o21a_2
XFILLER_0_105_243 VGND VGND VPWR VPWR sky130_fd_sc_hd__fill_1
XFILLER_0_105_287 VGND VGND VPWR VPWR sky130_fd_sc_hd__decap_6
XFILLER_0_31_561 VPWR VGND VPWR VGND sky130_ef_sc_hd__decap_12
X_10105_ clknet_leaf_32_clk _00122_ _00072_ VGND VGND VPWR VPWR mac_counter\[4\] sky130_fd_sc_hd__dfrtp_2
X_10036_ _04761_ _04749_ VGND VGND VPWR VPWR _04750_ sky130_fd_sc_hd__xnor2_2
XFILLER_0_86_701 VGND VGND VPWR VPWR sky130_fd_sc_hd__decap_6
XFILLER_0_81_28 VGND VGND VPWR VPWR sky130_fd_sc_hd__fill_2
XFILLER_0_105_57 VPWR VGND VPWR VGND sky130_ef_sc_hd__decap_12
XFILLER_0_14_77 VGND VGND VPWR VPWR sky130_fd_sc_hd__decap_6
XTAP_TAPCELL_ROW_14_431 VGND VPWR sky130_fd_sc_hd__tapvpwrvgnd_1
XTAP_TAPCELL_ROW_14_442 VGND VPWR sky130_fd_sc_hd__tapvpwrvgnd_1
XFILLER_0_5_205 VPWR VGND VPWR VGND sky130_ef_sc_hd__decap_12
XFILLER_0_26_333 VGND VGND VPWR VPWR sky130_fd_sc_hd__decap_8
XTAP_TAPCELL_ROW_42_784 VGND VPWR sky130_fd_sc_hd__tapvpwrvgnd_1
XFILLER_0_53_141 VGND VGND VPWR VPWR sky130_fd_sc_hd__decap_8
XFILLER_0_5_249 VPWR VGND VPWR VGND sky130_ef_sc_hd__decap_12
XFILLER_0_14_528 VGND VGND VPWR VPWR sky130_fd_sc_hd__decap_4
XFILLER_0_100_3 VPWR VGND VPWR VGND sky130_ef_sc_hd__decap_12
X_06060_ _00822_ _00847_ VGND VGND VPWR VPWR _01009_ sky130_fd_sc_hd__or2_2
XFILLER_0_1_411 VGND VGND VPWR VPWR sky130_fd_sc_hd__fill_1
XTAP_TAPCELL_ROW_113_1669 VGND VPWR sky130_fd_sc_hd__tapvpwrvgnd_1
X_06962_ _01795_ _01797_ _01794_ VGND VGND VPWR VPWR _01804_ sky130_fd_sc_hd__a21o_2
X_09750_ _02053_ _03918_ _04193_ VGND VGND VPWR VPWR _04473_ sky130_fd_sc_hd__o21ai_2
X_09681_ _02053_ _03833_ _04193_ VGND VGND VPWR VPWR _04406_ sky130_fd_sc_hd__o21a_2
X_08701_ _03474_ _03479_ _02019_ VGND VGND VPWR VPWR _03480_ sky130_fd_sc_hd__o21a_2
X_05913_ _00856_ _00861_ _00854_ VGND VGND VPWR VPWR _00875_ sky130_fd_sc_hd__a21bo_2
X_06893_ tanh_inst.divider.i\[4\] _01770_ tanh_inst.div_en VGND VGND VPWR VPWR _00164_
+ sky130_fd_sc_hd__o21ba_2
X_08632_ _03410_ _03412_ VGND VGND VPWR VPWR _03413_ sky130_fd_sc_hd__nor2_2
XFILLER_0_89_550 VGND VGND VPWR VPWR sky130_fd_sc_hd__decap_3
XTAP_TAPCELL_ROW_68_1115 VGND VPWR sky130_fd_sc_hd__tapvpwrvgnd_1
X_05844_ _00803_ _00807_ VGND VGND VPWR VPWR _00811_ sky130_fd_sc_hd__or2_2
XFILLER_0_89_561 VGND VGND VPWR VPWR sky130_fd_sc_hd__decap_6
XFILLER_0_77_723 VGND VGND VPWR VPWR sky130_fd_sc_hd__fill_1
X_05775_ _00724_ _00737_ _00738_ _00732_ _04798_ VGND VGND VPWR VPWR _00747_ sky130_fd_sc_hd__o32a_2
X_08563_ _03337_ _03345_ _04791_ VGND VGND VPWR VPWR _03346_ sky130_fd_sc_hd__mux2_1
X_07514_ tanh_inst.divider.y\[-9\] tanh_inst.divider.y\[-8\] tanh_inst.divider.y\[-7\]
+ tanh_inst.divider.y\[-6\] tanh_inst.LOOKUP.index\[0\] tanh_inst.LOOKUP.index\[1\]
+ VGND VGND VPWR VPWR _02321_ sky130_fd_sc_hd__mux4_2
X_08494_ _03244_ _03246_ _03278_ VGND VGND VPWR VPWR _03279_ sky130_fd_sc_hd__a21oi_2
XFILLER_0_49_447 VGND VGND VPWR VPWR sky130_fd_sc_hd__fill_1
XFILLER_0_71_83 VGND VGND VPWR VPWR sky130_fd_sc_hd__decap_4
X_07445_ _02054_ _02110_ VGND VGND VPWR VPWR _02253_ sky130_fd_sc_hd__or2_2
XFILLER_0_9_533 VPWR VGND VPWR VGND sky130_ef_sc_hd__decap_12
X_07376_ _02178_ _02179_ _02181_ _02183_ tanh_inst.LOOKUP.index\[2\] tanh_inst.LOOKUP.index\[3\]
+ VGND VGND VPWR VPWR _02185_ sky130_fd_sc_hd__mux4_2
XFILLER_0_9_588 VGND VGND VPWR VPWR sky130_fd_sc_hd__fill_1
XFILLER_0_44_141 VGND VGND VPWR VPWR sky130_fd_sc_hd__decap_4
X_06327_ _01088_ _01261_ VGND VGND VPWR VPWR _01262_ sky130_fd_sc_hd__and2_2
XFILLER_0_72_461 VPWR VGND VPWR VGND sky130_ef_sc_hd__decap_12
X_09115_ _01525_ _03855_ VGND VGND VPWR VPWR _03856_ sky130_fd_sc_hd__or2_2
XFILLER_0_32_314 VGND VGND VPWR VPWR sky130_fd_sc_hd__decap_4
X_06258_ tanh_inst.divider.y_\[-17\] _01197_ VGND VGND VPWR VPWR _01198_ sky130_fd_sc_hd__and2_2
X_09046_ _03783_ _03784_ _03785_ _03786_ _02023_ _02053_ VGND VGND VPWR VPWR _03788_
+ sky130_fd_sc_hd__mux4_2
XTAP_TAPCELL_ROW_79_1255 VGND VPWR sky130_fd_sc_hd__tapvpwrvgnd_1
XTAP_TAPCELL_ROW_79_1244 VGND VPWR sky130_fd_sc_hd__tapvpwrvgnd_1
XFILLER_0_60_645 VPWR VGND VPWR VGND sky130_ef_sc_hd__decap_12
XTAP_TAPCELL_ROW_92_1411 VGND VPWR sky130_fd_sc_hd__tapvpwrvgnd_1
X_05209_ mac_inst.x\[4\] _04852_ _04853_ VGND VGND VPWR VPWR _04913_ sky130_fd_sc_hd__a21oi_2
X_06189_ tanh_inst.divider.y_\[-21\] _01131_ VGND VGND VPWR VPWR _01133_ sky130_fd_sc_hd__nor2_2
X_09948_ _04547_ _04588_ _04589_ _04612_ VGND VGND VPWR VPWR _04666_ sky130_fd_sc_hd__or4b_2
X_09879_ _04598_ VGND VGND VPWR VPWR _04599_ sky130_fd_sc_hd__inv_2
XFILLER_0_68_723 VGND VGND VPWR VPWR sky130_fd_sc_hd__fill_1
XFILLER_0_67_222 VGND VGND VPWR VPWR sky130_fd_sc_hd__fill_2
XFILLER_0_67_255 VGND VGND VPWR VPWR sky130_fd_sc_hd__fill_1
XTAP_TAPCELL_ROW_11_401 VGND VPWR sky130_fd_sc_hd__tapvpwrvgnd_1
XFILLER_0_63_461 VPWR VGND VPWR VGND sky130_ef_sc_hd__decap_12
Xclkload29 clknet_leaf_12_clk VGND VGND VPWR VPWR clkload29/Y sky130_fd_sc_hd__inv_12
XFILLER_0_106_585 VGND VGND VPWR VPWR sky130_fd_sc_hd__decap_3
XFILLER_0_106_552 VGND VGND VPWR VPWR sky130_fd_sc_hd__decap_3
Xclkload18 clknet_leaf_36_clk VGND VGND VPWR VPWR clkload18/Y sky130_fd_sc_hd__inv_12
XFILLER_0_121_533 VPWR VGND VPWR VGND sky130_ef_sc_hd__decap_12
XFILLER_0_121_511 VGND VGND VPWR VPWR sky130_fd_sc_hd__fill_1
XFILLER_0_121_577 VGND VGND VPWR VPWR sky130_fd_sc_hd__fill_1
XFILLER_0_101_290 VGND VGND VPWR VPWR sky130_fd_sc_hd__decap_6
XFILLER_0_92_27 VGND VGND VPWR VPWR sky130_fd_sc_hd__fill_1
X_10019_ tanh_inst.divider.y\[7\] _03470_ VGND VGND VPWR VPWR _04734_ sky130_fd_sc_hd__xnor2_2
XTAP_TAPCELL_ROW_19_501 VGND VPWR sky130_fd_sc_hd__tapvpwrvgnd_1
XFILLER_0_59_712 VGND VGND VPWR VPWR sky130_fd_sc_hd__fill_1
XTAP_TAPCELL_ROW_47_854 VGND VPWR sky130_fd_sc_hd__tapvpwrvgnd_1
XFILLER_0_25_65 VGND VGND VPWR VPWR sky130_fd_sc_hd__fill_2
X_05560_ _00510_ _00551_ VGND VGND VPWR VPWR _00552_ sky130_fd_sc_hd__nand2_2
XFILLER_0_46_406 VPWR VGND VPWR VGND sky130_ef_sc_hd__decap_12
XFILLER_0_73_225 VGND VGND VPWR VPWR sky130_fd_sc_hd__decap_8
XFILLER_0_73_214 VGND VGND VPWR VPWR sky130_fd_sc_hd__decap_8
XTAP_TAPCELL_ROW_63_1045 VGND VPWR sky130_fd_sc_hd__tapvpwrvgnd_1
X_05491_ _04835_ _00488_ _00487_ _05020_ VGND VGND VPWR VPWR _00489_ sky130_fd_sc_hd__a211o_2
XFILLER_0_46_428 VPWR VGND VPWR VGND sky130_ef_sc_hd__decap_12
X_07230_ tanh_inst.divider.y\[-13\] _02028_ _02029_ VGND VGND VPWR VPWR _02040_ sky130_fd_sc_hd__o21a_2
XFILLER_0_41_53 VGND VGND VPWR VPWR sky130_fd_sc_hd__decap_3
X_07161_ _01979_ _01980_ VGND VGND VPWR VPWR _01981_ sky130_fd_sc_hd__and2_2
XFILLER_0_26_141 VPWR VGND VPWR VGND sky130_ef_sc_hd__decap_12
X_06112_ tanh_inst.divider.i\[4\] tanh_inst.divider.i\[3\] _01057_ _01056_ VGND VGND
+ VPWR VPWR _01059_ sky130_fd_sc_hd__a31o_2
XFILLER_0_81_7 VGND VGND VPWR VPWR sky130_fd_sc_hd__fill_1
XFILLER_0_41_100 VPWR VGND VPWR VGND sky130_ef_sc_hd__decap_12
X_07092_ _01903_ _01910_ _01911_ VGND VGND VPWR VPWR _01920_ sky130_fd_sc_hd__o21ai_2
XFILLER_0_112_566 VPWR VGND VPWR VGND sky130_ef_sc_hd__decap_12
X_06043_ _00794_ _00846_ VGND VGND VPWR VPWR _00994_ sky130_fd_sc_hd__and2_2
XTAP_TAPCELL_ROW_74_1185 VGND VPWR sky130_fd_sc_hd__tapvpwrvgnd_1
X_09802_ _04480_ _04483_ _04522_ VGND VGND VPWR VPWR _04524_ sky130_fd_sc_hd__or3_2
X_07994_ tanh_inst.divider.y\[-10\] _02789_ VGND VGND VPWR VPWR _02790_ sky130_fd_sc_hd__nor2_2
X_06945_ _01787_ _01788_ VGND VGND VPWR VPWR _01789_ sky130_fd_sc_hd__or2_2
X_09733_ tanh_inst.divider.x\[-2\] _04456_ VGND VGND VPWR VPWR _04457_ sky130_fd_sc_hd__nor2_2
X_06876_ _01758_ _01759_ VGND VGND VPWR VPWR _01761_ sky130_fd_sc_hd__or2_2
X_09664_ _04388_ _04389_ VGND VGND VPWR VPWR _04390_ sky130_fd_sc_hd__or2_2
XFILLER_0_96_306 VGND VGND VPWR VPWR sky130_fd_sc_hd__fill_2
X_09595_ _04275_ _04278_ _04321_ VGND VGND VPWR VPWR _04323_ sky130_fd_sc_hd__or3_2
X_05827_ _04781_ _04977_ _00703_ VGND VGND VPWR VPWR _00794_ sky130_fd_sc_hd__nor3_2
X_08615_ _03287_ _03352_ _03350_ VGND VGND VPWR VPWR _03397_ sky130_fd_sc_hd__a21o_2
XFILLER_0_82_71 VGND VGND VPWR VPWR sky130_fd_sc_hd__fill_1
XFILLER_0_49_233 VGND VGND VPWR VPWR sky130_fd_sc_hd__decap_4
X_08546_ _03327_ _03328_ VGND VGND VPWR VPWR _03329_ sky130_fd_sc_hd__or2_2
X_05758_ _04944_ _00717_ _00730_ VGND VGND VPWR VPWR _00731_ sky130_fd_sc_hd__or3_2
X_05689_ _04944_ _00666_ VGND VGND VPWR VPWR _00667_ sky130_fd_sc_hd__or2_2
X_08477_ _03260_ _03261_ VGND VGND VPWR VPWR _03262_ sky130_fd_sc_hd__xnor2_2
X_07428_ tanh_inst.divider.y\[-24\] tanh_inst.divider.x\[-24\] _02166_ _02165_ VGND
+ VGND VPWR VPWR _02236_ sky130_fd_sc_hd__a31oi_2
XFILLER_0_80_718 VGND VGND VPWR VPWR sky130_fd_sc_hd__decap_6
XFILLER_0_92_589 VPWR VGND VPWR VGND sky130_ef_sc_hd__decap_12
X_07359_ _02166_ _02167_ VGND VGND VPWR VPWR _02168_ sky130_fd_sc_hd__xnor2_2
XFILLER_0_18_697 VGND VGND VPWR VPWR sky130_fd_sc_hd__decap_3
XFILLER_0_33_656 VGND VGND VPWR VPWR sky130_fd_sc_hd__fill_1
XFILLER_0_45_494 VGND VGND VPWR VPWR sky130_fd_sc_hd__decap_8
X_10370_ clknet_leaf_15_clk _00227_ VGND VGND VPWR VPWR tanh_inst.divider.z_\[6\]
+ sky130_fd_sc_hd__dfxtp_2
XFILLER_0_60_464 VPWR VGND VPWR VGND sky130_ef_sc_hd__decap_12
XFILLER_0_60_453 VGND VGND VPWR VPWR sky130_fd_sc_hd__decap_3
X_09029_ _03646_ _03658_ _03713_ tanh_inst.z_\[7\] VGND VGND VPWR VPWR _03772_ sky130_fd_sc_hd__a31o_2
XFILLER_0_13_391 VGND VGND VPWR VPWR sky130_fd_sc_hd__fill_1
XFILLER_0_87_317 VPWR VGND VPWR VGND sky130_ef_sc_hd__decap_12
XFILLER_0_68_531 VGND VGND VPWR VPWR sky130_fd_sc_hd__fill_1
XTAP_TAPCELL_ROW_44_813 VGND VPWR sky130_fd_sc_hd__tapvpwrvgnd_1
XFILLER_0_106_360 VGND VGND VPWR VPWR sky130_fd_sc_hd__decap_4
XFILLER_0_23_111 VGND VGND VPWR VPWR sky130_fd_sc_hd__fill_1
XPHY_EDGE_ROW_116_Right_116 VGND VGND VPWR VPWR sky130_fd_sc_hd__decap_3
XFILLER_0_51_442 VGND VGND VPWR VPWR sky130_fd_sc_hd__decap_6
XFILLER_0_121_352 VGND VGND VPWR VPWR sky130_fd_sc_hd__decap_3
XFILLER_0_11_317 VPWR VGND VPWR VGND sky130_ef_sc_hd__decap_12
XFILLER_0_23_188 VPWR VGND VPWR VGND sky130_ef_sc_hd__decap_12
XTAP_TAPCELL_ROW_110_1639 VGND VPWR sky130_fd_sc_hd__tapvpwrvgnd_1
X_06730_ tanh_inst.z_\[-11\] _01630_ VGND VGND VPWR VPWR _01632_ sky130_fd_sc_hd__nor2_2
X_06661_ _01486_ _01523_ VGND VGND VPWR VPWR _01570_ sky130_fd_sc_hd__nor2_2
XFILLER_0_78_339 VGND VGND VPWR VPWR sky130_fd_sc_hd__fill_1
X_08400_ _03185_ _03186_ VGND VGND VPWR VPWR _03187_ sky130_fd_sc_hd__nand2_2
X_05612_ _04912_ _00430_ _00510_ VGND VGND VPWR VPWR _00599_ sky130_fd_sc_hd__o21ai_2
X_06592_ _01504_ _01505_ VGND VGND VPWR VPWR _01506_ sky130_fd_sc_hd__xnor2_2
X_09380_ tanh_inst.LOOKUP.index\[3\] _03809_ _03938_ VGND VGND VPWR VPWR _04114_ sky130_fd_sc_hd__o21ai_2
XFILLER_0_47_704 VGND VGND VPWR VPWR sky130_fd_sc_hd__decap_3
X_05543_ mac_inst.y\[17\] _00536_ VGND VGND VPWR VPWR _00537_ sky130_fd_sc_hd__xnor2_2
X_08331_ tanh_inst.LOOKUP.index\[4\] _02473_ _02859_ VGND VGND VPWR VPWR _03119_ sky130_fd_sc_hd__o21a_2
XFILLER_0_52_74 VGND VGND VPWR VPWR sky130_fd_sc_hd__decap_8
XTAP_TAPCELL_ROW_121_1779 VGND VPWR sky130_fd_sc_hd__tapvpwrvgnd_1
XFILLER_0_117_614 VGND VGND VPWR VPWR sky130_fd_sc_hd__fill_2
X_05474_ _00472_ _00473_ VGND VGND VPWR VPWR _05474_/X sky130_fd_sc_hd__xor2_2
X_08262_ _02926_ _02973_ _03051_ VGND VGND VPWR VPWR _03052_ sky130_fd_sc_hd__a21o_2
XFILLER_0_74_589 VGND VGND VPWR VPWR sky130_fd_sc_hd__decap_4
X_07213_ _04758_ _02021_ _02020_ VGND VGND VPWR VPWR _02023_ sky130_fd_sc_hd__o21ai_2
XFILLER_0_6_333 VPWR VGND VPWR VGND sky130_ef_sc_hd__decap_12
XFILLER_0_54_291 VPWR VGND VPWR VGND sky130_ef_sc_hd__decap_12
X_08193_ _04791_ _02968_ _02969_ _02984_ VGND VGND VPWR VPWR _02985_ sky130_fd_sc_hd__o31ai_2
X_07144_ tanh_inst.divider.z_\[0\] _01965_ VGND VGND VPWR VPWR _01966_ sky130_fd_sc_hd__nand2_2
XTAP_TAPCELL_ROW_76_1214 VGND VPWR sky130_fd_sc_hd__tapvpwrvgnd_1
XFILLER_0_14_133 VGND VGND VPWR VPWR sky130_fd_sc_hd__decap_6
XFILLER_0_42_464 VPWR VGND VPWR VGND sky130_ef_sc_hd__decap_12
X_07075_ _01903_ _01904_ VGND VGND VPWR VPWR _01905_ sky130_fd_sc_hd__or2_2
XFILLER_0_72_3 VGND VGND VPWR VPWR sky130_fd_sc_hd__decap_8
XFILLER_0_14_177 VPWR VGND VPWR VGND sky130_ef_sc_hd__decap_12
X_06026_ mac_inst.z\[26\] _00977_ VGND VGND VPWR VPWR _00979_ sky130_fd_sc_hd__and2_2
X_07977_ _01525_ _02417_ _02421_ _01477_ VGND VGND VPWR VPWR _02774_ sky130_fd_sc_hd__o22a_2
X_06928_ _01055_ _01772_ tanh_inst.divider.z_\[-24\] VGND VGND VPWR VPWR _01774_ sky130_fd_sc_hd__a21oi_2
X_09716_ tanh_inst.divider.y\[-2\] _04438_ VGND VGND VPWR VPWR _04440_ sky130_fd_sc_hd__nor2_2
XFILLER_0_96_103 VGND VGND VPWR VPWR sky130_fd_sc_hd__decap_4
XFILLER_0_97_637 VGND VGND VPWR VPWR sky130_fd_sc_hd__decap_8
XFILLER_0_96_125 VGND VGND VPWR VPWR sky130_fd_sc_hd__decap_6
XTAP_TAPCELL_ROW_87_1354 VGND VPWR sky130_fd_sc_hd__tapvpwrvgnd_1
X_06859_ _01734_ _01740_ VGND VGND VPWR VPWR _01746_ sky130_fd_sc_hd__or2_2
XTAP_TAPCELL_ROW_2_287 VGND VPWR sky130_fd_sc_hd__tapvpwrvgnd_1
X_09647_ _04301_ _04357_ VGND VGND VPWR VPWR _04373_ sky130_fd_sc_hd__nor2_2
XFILLER_0_77_350 VPWR VGND VPWR VGND sky130_ef_sc_hd__decap_12
X_09578_ _04302_ _04304_ VGND VGND VPWR VPWR _04306_ sky130_fd_sc_hd__nand2_2
XFILLER_0_37_225 VGND VGND VPWR VPWR sky130_fd_sc_hd__fill_1
X_08529_ tanh_inst.divider.y\[2\] _03311_ VGND VGND VPWR VPWR _03313_ sky130_fd_sc_hd__and2_2
XFILLER_0_107_113 VPWR VGND VPWR VGND sky130_ef_sc_hd__decap_12
XFILLER_0_80_526 VGND VGND VPWR VPWR sky130_fd_sc_hd__fill_1
XFILLER_0_65_578 VPWR VGND VPWR VGND sky130_ef_sc_hd__decap_12
XFILLER_0_9_193 VPWR VGND VPWR VGND sky130_ef_sc_hd__decap_12
XFILLER_0_80_548 VGND VGND VPWR VPWR sky130_fd_sc_hd__decap_6
XTAP_TAPCELL_ROW_98_1483 VGND VPWR sky130_fd_sc_hd__tapvpwrvgnd_1
XFILLER_0_33_453 VGND VGND VPWR VPWR sky130_fd_sc_hd__fill_1
X_10422_ clknet_leaf_37_clk _00279_ _00000_ VGND VGND VPWR VPWR mac_inst.i\[14\] sky130_fd_sc_hd__dfrtp_2
X_10353_ clknet_leaf_21_clk _00210_ VGND VGND VPWR VPWR tanh_inst.divider.z_\[-11\]
+ sky130_fd_sc_hd__dfxtp_2
XFILLER_0_60_261 VGND VGND VPWR VPWR sky130_fd_sc_hd__decap_4
XFILLER_0_33_475 VGND VGND VPWR VPWR sky130_fd_sc_hd__decap_8
X_10284_ clknet_leaf_29_clk _00141_ VGND VGND VPWR VPWR tanh_inst.z_\[-11\] sky130_fd_sc_hd__dfxtp_2
XTAP_TAPCELL_ROW_57_971 VGND VPWR sky130_fd_sc_hd__tapvpwrvgnd_1
XFILLER_0_87_169 VPWR VGND VPWR VGND sky130_ef_sc_hd__decap_12
XFILLER_0_8_609 VGND VGND VPWR VPWR sky130_fd_sc_hd__fill_1
XPHY_EDGE_ROW_1_Left_123 VGND VGND VPWR VPWR sky130_fd_sc_hd__decap_3
XTAP_TAPCELL_ROW_60_1015 VGND VPWR sky130_fd_sc_hd__tapvpwrvgnd_1
XFILLER_0_28_247 VGND VGND VPWR VPWR sky130_fd_sc_hd__decap_4
XFILLER_0_113_57 VPWR VGND VPWR VGND sky130_ef_sc_hd__decap_12
XFILLER_0_56_589 VGND VGND VPWR VPWR sky130_fd_sc_hd__decap_3
XFILLER_0_98_15 VPWR VGND VPWR VGND sky130_ef_sc_hd__decap_12
XFILLER_0_83_397 VGND VGND VPWR VPWR sky130_fd_sc_hd__fill_1
XFILLER_0_22_77 VGND VGND VPWR VPWR sky130_fd_sc_hd__decap_6
XFILLER_0_113_105 VGND VGND VPWR VPWR sky130_fd_sc_hd__decap_6
X_05190_ mac_inst.x\[13\] _04852_ _04853_ VGND VGND VPWR VPWR _04894_ sky130_fd_sc_hd__a21o_2
XFILLER_0_106_190 VGND VGND VPWR VPWR sky130_fd_sc_hd__fill_1
XFILLER_0_11_125 VPWR VGND VPWR VGND sky130_ef_sc_hd__decap_12
XFILLER_0_121_193 VGND VGND VPWR VPWR sky130_fd_sc_hd__decap_3
XFILLER_0_11_169 VPWR VGND VPWR VGND sky130_ef_sc_hd__decap_12
XPHY_EDGE_ROW_47_Left_169 VGND VGND VPWR VPWR sky130_fd_sc_hd__decap_3
X_07900_ _02657_ _02660_ _02697_ VGND VGND VPWR VPWR _02698_ sky130_fd_sc_hd__o21a_2
X_08880_ _03623_ _03624_ VGND VGND VPWR VPWR _03625_ sky130_fd_sc_hd__nand2b_2
XTAP_TAPCELL_ROW_71_1144 VGND VPWR sky130_fd_sc_hd__tapvpwrvgnd_1
X_07831_ _02581_ _02629_ _02627_ VGND VGND VPWR VPWR _02631_ sky130_fd_sc_hd__a21o_2
XTAP_TAPCELL_ROW_71_1155 VGND VPWR sky130_fd_sc_hd__tapvpwrvgnd_1
XFILLER_0_44_7 VGND VGND VPWR VPWR sky130_fd_sc_hd__fill_1
XFILLER_0_79_626 VGND VGND VPWR VPWR sky130_fd_sc_hd__decap_6
X_07762_ _02520_ _02522_ _02519_ VGND VGND VPWR VPWR _02564_ sky130_fd_sc_hd__a21oi_2
X_09501_ _04228_ _04230_ VGND VGND VPWR VPWR _04231_ sky130_fd_sc_hd__xnor2_2
X_07693_ _02442_ _02444_ _02494_ VGND VGND VPWR VPWR _02496_ sky130_fd_sc_hd__o21ai_2
XFILLER_0_2_65 VPWR VGND VPWR VGND sky130_ef_sc_hd__decap_12
X_06713_ _01615_ _01616_ VGND VGND VPWR VPWR _01617_ sky130_fd_sc_hd__and2b_2
X_06644_ _01480_ _01485_ VGND VGND VPWR VPWR _01555_ sky130_fd_sc_hd__nand2_2
XPHY_EDGE_ROW_56_Left_178 VGND VGND VPWR VPWR sky130_fd_sc_hd__decap_3
X_09432_ tanh_inst.z_\[7\] _04163_ VGND VGND VPWR VPWR _04164_ sky130_fd_sc_hd__nor2_2
X_09363_ _04090_ _04095_ VGND VGND VPWR VPWR _04097_ sky130_fd_sc_hd__xnor2_2
X_06575_ tanh_inst.z_\[-3\] tanh_inst.z_\[-4\] tanh_inst.z_\[-1\] tanh_inst.z_\[-2\]
+ VGND VGND VPWR VPWR _01490_ sky130_fd_sc_hd__or4_2
XFILLER_0_19_225 VPWR VGND VPWR VGND sky130_ef_sc_hd__decap_12
X_08314_ _03084_ _03101_ VGND VGND VPWR VPWR _03103_ sky130_fd_sc_hd__nor2_2
X_05526_ _04883_ _04911_ VGND VGND VPWR VPWR _00521_ sky130_fd_sc_hd__nand2_2
XTAP_TAPCELL_ROW_35_698 VGND VPWR sky130_fd_sc_hd__tapvpwrvgnd_1
X_09294_ _03962_ _04000_ _04001_ VGND VGND VPWR VPWR _04030_ sky130_fd_sc_hd__o21ai_2
XTAP_TAPCELL_ROW_82_1284 VGND VPWR sky130_fd_sc_hd__tapvpwrvgnd_1
XFILLER_0_117_466 VGND VGND VPWR VPWR sky130_fd_sc_hd__decap_8
XFILLER_0_6_141 VPWR VGND VPWR VGND sky130_ef_sc_hd__decap_12
X_05457_ mac_inst.y\[10\] _00456_ VGND VGND VPWR VPWR _00458_ sky130_fd_sc_hd__nor2_2
X_08245_ tanh_inst.divider.y\[-5\] _03010_ _03008_ VGND VGND VPWR VPWR _03035_ sky130_fd_sc_hd__o21a_2
XFILLER_0_15_442 VGND VGND VPWR VPWR sky130_fd_sc_hd__decap_6
X_05388_ _00392_ _00393_ VGND VGND VPWR VPWR _00394_ sky130_fd_sc_hd__xnor2_2
X_08176_ _02964_ _02967_ _02962_ VGND VGND VPWR VPWR _02968_ sky130_fd_sc_hd__a21oi_2
X_07127_ tanh_inst.divider.z_\[-2\] _01949_ VGND VGND VPWR VPWR _01951_ sky130_fd_sc_hd__nor2_2
XFILLER_0_15_475 VGND VGND VPWR VPWR sky130_fd_sc_hd__decap_3
XFILLER_0_88_70 VGND VGND VPWR VPWR sky130_fd_sc_hd__decap_4
XPHY_EDGE_ROW_65_Left_187 VGND VGND VPWR VPWR sky130_fd_sc_hd__decap_3
X_07058_ _01864_ _01871_ _01873_ _01880_ _01870_ VGND VGND VPWR VPWR _01890_ sky130_fd_sc_hd__a311o_2
XFILLER_0_11_670 VGND VGND VPWR VPWR sky130_fd_sc_hd__fill_2
XFILLER_0_100_377 VPWR VGND VPWR VGND sky130_ef_sc_hd__decap_12
XTAP_TAPCELL_ROW_7_346 VGND VPWR sky130_fd_sc_hd__tapvpwrvgnd_1
X_06009_ mac_inst.i\[16\] mac_inst.i\[21\] mac_inst.i\[20\] _04953_ VGND VGND VPWR
+ VPWR _00963_ sky130_fd_sc_hd__and4_2
XPHY_EDGE_ROW_74_Left_196 VGND VGND VPWR VPWR sky130_fd_sc_hd__decap_3
XFILLER_0_97_467 VPWR VGND VPWR VGND sky130_ef_sc_hd__decap_12
XFILLER_0_69_169 VGND VGND VPWR VPWR sky130_fd_sc_hd__decap_4
XFILLER_0_69_147 VGND VGND VPWR VPWR sky130_fd_sc_hd__decap_8
XTAP_TAPCELL_ROW_54_941 VGND VPWR sky130_fd_sc_hd__tapvpwrvgnd_1
XFILLER_0_77_180 VGND VGND VPWR VPWR sky130_fd_sc_hd__fill_1
XFILLER_0_93_684 VGND VGND VPWR VPWR sky130_fd_sc_hd__decap_3
XFILLER_0_80_301 VGND VGND VPWR VPWR sky130_fd_sc_hd__decap_6
XFILLER_0_38_567 VGND VGND VPWR VPWR sky130_fd_sc_hd__decap_3
XFILLER_0_108_477 VGND VGND VPWR VPWR sky130_fd_sc_hd__decap_4
XFILLER_0_25_217 VGND VGND VPWR VPWR sky130_fd_sc_hd__decap_6
X_10405_ clknet_leaf_2_clk _00262_ VGND VGND VPWR VPWR tanh_inst.divider.x\[5\] sky130_fd_sc_hd__dfxtp_2
XFILLER_0_68_29 VPWR VGND VPWR VGND sky130_ef_sc_hd__decap_12
X_10336_ clknet_leaf_16_clk _00193_ VGND VGND VPWR VPWR tanh_out[28] sky130_fd_sc_hd__dfxtp_2
X_10267_ clknet_leaf_31_clk mac_inst.x\[29\] _00000_ VGND VGND VPWR VPWR mac_x_out[29]
+ sky130_fd_sc_hd__dfrtp_2
X_10198_ x_in[24] _00000_ VGND VGND VPWR VPWR mac_inst.x\[24\] sky130_fd_sc_hd__dlxtn_1
XTAP_TAPCELL_ROW_109_1630 VGND VPWR sky130_fd_sc_hd__tapvpwrvgnd_1
XFILLER_0_17_55 VGND VGND VPWR VPWR sky130_fd_sc_hd__fill_1
XFILLER_0_88_412 VGND VGND VPWR VPWR sky130_fd_sc_hd__decap_3
XFILLER_0_33_43 VPWR VGND VPWR VGND sky130_ef_sc_hd__decap_12
X_06360_ _01290_ _01291_ VGND VGND VPWR VPWR _01292_ sky130_fd_sc_hd__xor2_2
XFILLER_0_56_353 VGND VGND VPWR VPWR sky130_fd_sc_hd__decap_8
XTAP_TAPCELL_ROW_32_657 VGND VPWR sky130_fd_sc_hd__tapvpwrvgnd_1
XFILLER_0_44_515 VGND VGND VPWR VPWR sky130_fd_sc_hd__decap_8
X_06291_ tanh_inst.divider.i\[4\] _01226_ _01227_ VGND VGND VPWR VPWR _01228_ sky130_fd_sc_hd__a21bo_2
XTAP_TAPCELL_ROW_32_668 VGND VPWR sky130_fd_sc_hd__tapvpwrvgnd_1
X_05311_ _04794_ _05010_ VGND VGND VPWR VPWR _05011_ sky130_fd_sc_hd__nor2_2
X_08030_ tanh_inst.divider.x\[-12\] _02738_ _02777_ tanh_inst.divider.x\[-11\] VGND
+ VGND VPWR VPWR _02826_ sky130_fd_sc_hd__a22o_2
XFILLER_0_3_111 VGND VGND VPWR VPWR sky130_fd_sc_hd__fill_1
X_05242_ mac_inst.i\[4\] _04935_ _04937_ VGND VGND VPWR VPWR _04943_ sky130_fd_sc_hd__o21a_2
XFILLER_0_101_119 VGND VGND VPWR VPWR sky130_fd_sc_hd__fill_1
X_05173_ mac_inst.x\[28\] _04852_ _04853_ mac_inst.i\[0\] VGND VGND VPWR VPWR _04877_
+ sky130_fd_sc_hd__a211o_2
X_09981_ _04696_ _04697_ VGND VGND VPWR VPWR _04698_ sky130_fd_sc_hd__xnor2_2
X_08932_ _02027_ _03540_ _03600_ _02024_ VGND VGND VPWR VPWR _03676_ sky130_fd_sc_hd__o211a_2
X_08863_ _03550_ _03560_ _03562_ _03564_ _04761_ _04760_ VGND VGND VPWR VPWR _03608_
+ sky130_fd_sc_hd__mux4_2
XTAP_TAPCELL_ROW_4_316 VGND VPWR sky130_fd_sc_hd__tapvpwrvgnd_1
XFILLER_0_35_3 VPWR VGND VPWR VGND sky130_ef_sc_hd__decap_12
X_07814_ _04772_ _02613_ VGND VGND VPWR VPWR _02614_ sky130_fd_sc_hd__or2_2
X_08794_ tanh_inst.divider.x\[7\] _03539_ _04761_ VGND VGND VPWR VPWR _03540_ sky130_fd_sc_hd__mux2_1
X_07745_ _02501_ _02502_ _02499_ VGND VGND VPWR VPWR _02547_ sky130_fd_sc_hd__o21ai_2
XTAP_TAPCELL_ROW_84_1313 VGND VPWR sky130_fd_sc_hd__tapvpwrvgnd_1
X_09415_ _02018_ _04147_ VGND VGND VPWR VPWR _04148_ sky130_fd_sc_hd__nor2_2
X_07676_ _02429_ _02478_ _02479_ VGND VGND VPWR VPWR _02480_ sky130_fd_sc_hd__and3_2
X_06627_ _01489_ _01508_ _01507_ VGND VGND VPWR VPWR _01540_ sky130_fd_sc_hd__o21a_2
XTAP_TAPCELL_ROW_51_900 VGND VPWR sky130_fd_sc_hd__tapvpwrvgnd_1
X_09346_ tanh_inst.divider.y\[-13\] _04080_ VGND VGND VPWR VPWR _04081_ sky130_fd_sc_hd__nand2_2
XFILLER_0_75_673 VGND VGND VPWR VPWR sky130_fd_sc_hd__decap_6
X_06558_ tanh_inst.LOOKUP.index\[4\] tanh_inst.LOOKUP.index\[3\] tanh_inst.LOOKUP.index\[2\]
+ tanh_inst.LOOKUP.index\[1\] VGND VGND VPWR VPWR _01473_ sky130_fd_sc_hd__and4_2
XFILLER_0_117_230 VGND VGND VPWR VPWR sky130_fd_sc_hd__fill_2
X_06489_ _04776_ _01226_ _01289_ VGND VGND VPWR VPWR _01410_ sky130_fd_sc_hd__a21boi_2
X_09277_ _04011_ _04013_ VGND VGND VPWR VPWR _04014_ sky130_fd_sc_hd__nand2_2
X_05509_ mac_inst.y\[13\] _00491_ _00505_ VGND VGND VPWR VPWR _00506_ sky130_fd_sc_hd__o21ai_2
XFILLER_0_7_483 VGND VGND VPWR VPWR sky130_fd_sc_hd__decap_3
X_08228_ _02986_ _02987_ VGND VGND VPWR VPWR _03019_ sky130_fd_sc_hd__and2b_2
XFILLER_0_50_507 VGND VGND VPWR VPWR sky130_fd_sc_hd__decap_3
XFILLER_0_15_261 VPWR VGND VPWR VGND sky130_ef_sc_hd__decap_12
XFILLER_0_22_209 VPWR VGND VPWR VGND sky130_ef_sc_hd__decap_12
XFILLER_0_43_581 VGND VGND VPWR VPWR sky130_fd_sc_hd__decap_4
XTAP_TAPCELL_ROW_95_1453 VGND VPWR sky130_fd_sc_hd__tapvpwrvgnd_1
XFILLER_0_30_220 VGND VGND VPWR VPWR sky130_fd_sc_hd__fill_1
X_08159_ _02917_ _02920_ _02950_ _02019_ VGND VGND VPWR VPWR _02952_ sky130_fd_sc_hd__a31o_2
XFILLER_0_30_253 VGND VGND VPWR VPWR sky130_fd_sc_hd__fill_1
XFILLER_0_100_141 VPWR VGND VPWR VGND sky130_ef_sc_hd__decap_12
X_10052_ rst VGND VGND VPWR VPWR _00071_ sky130_fd_sc_hd__inv_2
XPHY_EDGE_ROW_82_Left_204 VGND VGND VPWR VPWR sky130_fd_sc_hd__decap_3
XTAP_TAPCELL_ROW_104_1560 VGND VPWR sky130_fd_sc_hd__tapvpwrvgnd_1
XPHY_EDGE_ROW_91_Left_213 VGND VGND VPWR VPWR sky130_fd_sc_hd__decap_3
XFILLER_0_65_161 VGND VGND VPWR VPWR sky130_fd_sc_hd__decap_6
XFILLER_0_80_131 VGND VGND VPWR VPWR sky130_fd_sc_hd__decap_8
XFILLER_0_80_197 VGND VGND VPWR VPWR sky130_fd_sc_hd__decap_8
XFILLER_0_0_125 VPWR VGND VPWR VGND sky130_ef_sc_hd__decap_12
XFILLER_0_95_27 VPWR VGND VPWR VGND sky130_ef_sc_hd__decap_12
X_10319_ clknet_leaf_21_clk _00176_ VGND VGND VPWR VPWR tanh_out[11] sky130_fd_sc_hd__dfxtp_2
XFILLER_0_0_169 VPWR VGND VPWR VGND sky130_ef_sc_hd__decap_12
XFILLER_0_28_65 VGND VGND VPWR VPWR sky130_fd_sc_hd__fill_2
X_05860_ _00773_ _00784_ _00813_ _00824_ VGND VGND VPWR VPWR _00825_ sky130_fd_sc_hd__and4_2
X_05791_ _04944_ _00665_ _00760_ VGND VGND VPWR VPWR _00761_ sky130_fd_sc_hd__or3_2
X_07530_ _02224_ _02226_ _02292_ _02228_ _02227_ VGND VGND VPWR VPWR _02336_ sky130_fd_sc_hd__o311a_2
XTAP_TAPCELL_ROW_37_727 VGND VPWR sky130_fd_sc_hd__tapvpwrvgnd_1
X_07461_ _02268_ _02015_ _02244_ VGND VGND VPWR VPWR _02269_ sky130_fd_sc_hd__or3b_2
XTAP_TAPCELL_ROW_66_1087 VGND VPWR sky130_fd_sc_hd__tapvpwrvgnd_1
XTAP_TAPCELL_ROW_17_473 VGND VPWR sky130_fd_sc_hd__tapvpwrvgnd_1
X_06412_ _01324_ _01329_ _01338_ VGND VGND VPWR VPWR _01340_ sky130_fd_sc_hd__or3b_2
X_07392_ _02019_ _02200_ _02177_ _02014_ VGND VGND VPWR VPWR _02201_ sky130_fd_sc_hd__o211a_2
XFILLER_0_57_651 VGND VGND VPWR VPWR sky130_fd_sc_hd__fill_2
X_09200_ _03758_ _03761_ tanh_inst.LOOKUP.index\[2\] VGND VGND VPWR VPWR _03939_ sky130_fd_sc_hd__mux2_1
X_06343_ tanh_inst.divider.y\[-11\] tanh_inst.div_en tanh_inst.divider.y_\[-11\] _01092_
+ _01276_ VGND VGND VPWR VPWR _00099_ sky130_fd_sc_hd__a221o_2
X_09131_ _02025_ _03667_ _03870_ _02023_ VGND VGND VPWR VPWR _03871_ sky130_fd_sc_hd__o211a_2
XFILLER_0_84_492 VGND VGND VPWR VPWR sky130_fd_sc_hd__fill_1
XFILLER_0_56_183 VPWR VGND VPWR VGND sky130_ef_sc_hd__decap_12
X_09062_ _03749_ _03754_ _03803_ VGND VGND VPWR VPWR _03804_ sky130_fd_sc_hd__and3_2
XFILLER_0_60_85 VGND VGND VPWR VPWR sky130_fd_sc_hd__decap_3
X_06274_ _01211_ _01212_ VGND VGND VPWR VPWR _01213_ sky130_fd_sc_hd__xor2_2
X_08013_ _02807_ _02808_ VGND VGND VPWR VPWR _02809_ sky130_fd_sc_hd__nand2_2
XFILLER_0_8_53 VPWR VGND VPWR VGND sky130_ef_sc_hd__decap_12
X_05225_ mac_inst.y\[0\] _04927_ VGND VGND VPWR VPWR _04929_ sky130_fd_sc_hd__nand2_2
XFILLER_0_12_253 VPWR VGND VPWR VGND sky130_ef_sc_hd__decap_12
XFILLER_0_8_97 VPWR VGND VPWR VGND sky130_ef_sc_hd__decap_12
X_05156_ mac_inst.x\[18\] _04852_ _04853_ VGND VGND VPWR VPWR _04860_ sky130_fd_sc_hd__a21o_2
X_09964_ _03409_ _04678_ VGND VGND VPWR VPWR _04681_ sky130_fd_sc_hd__nand2_2
X_05087_ _04809_ VGND VGND VPWR VPWR _00000_ sky130_fd_sc_hd__inv_2
XTAP_TAPCELL_ROW_90_1383 VGND VPWR sky130_fd_sc_hd__tapvpwrvgnd_1
X_08915_ _03646_ _03659_ VGND VGND VPWR VPWR _03660_ sky130_fd_sc_hd__xnor2_2
X_09895_ _04612_ _04613_ VGND VGND VPWR VPWR _04614_ sky130_fd_sc_hd__xnor2_2
X_08846_ _02026_ _03508_ _03590_ VGND VGND VPWR VPWR _03591_ sky130_fd_sc_hd__and3_2
XFILLER_0_99_529 VPWR VGND VPWR VGND sky130_ef_sc_hd__decap_12
X_08777_ _04757_ _02020_ tanh_inst.divider.x\[-18\] VGND VGND VPWR VPWR _03523_ sky130_fd_sc_hd__a21o_2
X_05989_ mac_inst.z\[23\] _00933_ _00924_ VGND VGND VPWR VPWR _00944_ sky130_fd_sc_hd__o21ba_2
X_07728_ _02529_ _02530_ _01469_ VGND VGND VPWR VPWR _00240_ sky130_fd_sc_hd__a21oi_2
XFILLER_0_79_264 VGND VGND VPWR VPWR sky130_fd_sc_hd__fill_2
XFILLER_0_67_426 VGND VGND VPWR VPWR sky130_fd_sc_hd__decap_4
XFILLER_0_67_415 VGND VGND VPWR VPWR sky130_fd_sc_hd__decap_3
XFILLER_0_94_234 VGND VGND VPWR VPWR sky130_fd_sc_hd__decap_3
XFILLER_0_94_223 VGND VGND VPWR VPWR sky130_fd_sc_hd__fill_2
X_07659_ _02360_ _02363_ _02412_ _02410_ VGND VGND VPWR VPWR _02463_ sky130_fd_sc_hd__a31o_2
XFILLER_0_67_459 VPWR VGND VPWR VGND sky130_ef_sc_hd__decap_12
X_09329_ tanh_inst.divider.y\[-13\] _04059_ VGND VGND VPWR VPWR _04064_ sky130_fd_sc_hd__and2_2
XFILLER_0_75_481 VPWR VGND VPWR VGND sky130_ef_sc_hd__decap_12
XFILLER_0_35_301 VPWR VGND VPWR VGND sky130_ef_sc_hd__decap_12
XFILLER_0_47_161 VGND VGND VPWR VPWR sky130_fd_sc_hd__fill_2
XFILLER_0_106_701 VGND VGND VPWR VPWR sky130_fd_sc_hd__decap_6
XFILLER_0_62_120 VGND VGND VPWR VPWR sky130_fd_sc_hd__fill_1
XFILLER_0_105_222 VGND VGND VPWR VPWR sky130_fd_sc_hd__fill_2
XFILLER_0_35_389 VGND VGND VPWR VPWR sky130_fd_sc_hd__decap_3
XFILLER_0_50_304 VGND VGND VPWR VPWR sky130_fd_sc_hd__decap_4
XFILLER_0_31_573 VPWR VGND VPWR VGND sky130_ef_sc_hd__decap_12
X_10104_ clknet_leaf_32_clk _00121_ _00071_ VGND VGND VPWR VPWR mac_counter\[3\] sky130_fd_sc_hd__dfrtp_2
X_10035_ tanh_inst.IS_FIRST4 _01570_ _04748_ VGND VGND VPWR VPWR _04749_ sky130_fd_sc_hd__a21bo_2
XFILLER_0_105_69 VPWR VGND VPWR VGND sky130_ef_sc_hd__decap_12
XFILLER_0_85_245 VGND VGND VPWR VPWR sky130_fd_sc_hd__fill_2
XFILLER_0_54_621 VGND VGND VPWR VPWR sky130_fd_sc_hd__decap_8
XTAP_TAPCELL_ROW_14_432 VGND VPWR sky130_fd_sc_hd__tapvpwrvgnd_1
XTAP_TAPCELL_ROW_14_443 VGND VPWR sky130_fd_sc_hd__tapvpwrvgnd_1
XFILLER_0_26_301 VGND VGND VPWR VPWR sky130_fd_sc_hd__decap_6
XFILLER_0_39_673 VGND VGND VPWR VPWR sky130_fd_sc_hd__decap_3
XFILLER_0_109_561 VGND VGND VPWR VPWR sky130_fd_sc_hd__decap_4
XFILLER_0_5_217 VGND VGND VPWR VPWR sky130_fd_sc_hd__decap_6
XTAP_TAPCELL_ROW_42_785 VGND VPWR sky130_fd_sc_hd__tapvpwrvgnd_1
XFILLER_0_121_57 VPWR VGND VPWR VGND sky130_ef_sc_hd__decap_12
XFILLER_0_14_507 VGND VGND VPWR VPWR sky130_fd_sc_hd__fill_2
XFILLER_0_41_337 VPWR VGND VPWR VGND sky130_ef_sc_hd__decap_12
X_06961_ _01802_ VGND VGND VPWR VPWR _01803_ sky130_fd_sc_hd__inv_2
X_08700_ tanh_inst.z_\[7\] _03477_ _03478_ VGND VGND VPWR VPWR _03479_ sky130_fd_sc_hd__and3_2
X_05912_ _00871_ _00872_ VGND VGND VPWR VPWR _00874_ sky130_fd_sc_hd__and2b_2
X_09680_ tanh_inst.divider.y\[-4\] _02014_ _04405_ _01470_ VGND VGND VPWR VPWR _00317_
+ sky130_fd_sc_hd__o211a_2
X_06892_ tanh_inst.divider.i\[3\] _01768_ _01771_ VGND VGND VPWR VPWR _00163_ sky130_fd_sc_hd__o21a_2
X_08631_ _03404_ _03409_ VGND VGND VPWR VPWR _03412_ sky130_fd_sc_hd__nor2_2
XTAP_TAPCELL_ROW_68_1116 VGND VPWR sky130_fd_sc_hd__tapvpwrvgnd_1
X_05843_ _04801_ _00788_ _00805_ _00782_ _00809_ VGND VGND VPWR VPWR _00810_ sky130_fd_sc_hd__o221a_2
X_05774_ _00744_ _00745_ VGND VGND VPWR VPWR _00746_ sky130_fd_sc_hd__nand2b_2
X_08562_ _03343_ _03344_ VGND VGND VPWR VPWR _03345_ sky130_fd_sc_hd__xnor2_2
X_07513_ tanh_inst.divider.y\[-13\] tanh_inst.divider.y\[-12\] tanh_inst.divider.y\[-11\]
+ tanh_inst.divider.y\[-10\] tanh_inst.LOOKUP.index\[0\] tanh_inst.LOOKUP.index\[1\]
+ VGND VGND VPWR VPWR _02320_ sky130_fd_sc_hd__mux4_2
X_08493_ tanh_inst.divider.x\[1\] _03277_ VGND VGND VPWR VPWR _03278_ sky130_fd_sc_hd__xnor2_2
X_07444_ tanh_inst.divider.y\[-18\] tanh_inst.divider.y\[-17\] tanh_inst.divider.y\[-16\]
+ tanh_inst.divider.y\[-15\] tanh_inst.LOOKUP.index\[0\] tanh_inst.LOOKUP.index\[1\]
+ VGND VGND VPWR VPWR _02252_ sky130_fd_sc_hd__mux4_2
XFILLER_0_9_545 VGND VGND VPWR VPWR sky130_fd_sc_hd__decap_3
XFILLER_0_45_621 VGND VGND VPWR VPWR sky130_fd_sc_hd__fill_1
X_07375_ _02181_ _02183_ tanh_inst.LOOKUP.index\[2\] VGND VGND VPWR VPWR _02184_ sky130_fd_sc_hd__mux2_1
X_06326_ _01255_ _01260_ VGND VGND VPWR VPWR _01261_ sky130_fd_sc_hd__nand2_2
XFILLER_0_72_473 VGND VGND VPWR VPWR sky130_fd_sc_hd__decap_3
X_09114_ _03630_ _03642_ _04759_ VGND VGND VPWR VPWR _03855_ sky130_fd_sc_hd__mux2_1
XFILLER_0_17_389 VGND VGND VPWR VPWR sky130_fd_sc_hd__decap_3
XFILLER_0_32_304 VGND VGND VPWR VPWR sky130_fd_sc_hd__decap_4
X_06257_ _01194_ _01196_ VGND VGND VPWR VPWR _01197_ sky130_fd_sc_hd__xnor2_2
X_09045_ _03785_ _03786_ _02023_ VGND VGND VPWR VPWR _03787_ sky130_fd_sc_hd__mux2_1
XTAP_TAPCELL_ROW_79_1245 VGND VPWR sky130_fd_sc_hd__tapvpwrvgnd_1
XFILLER_0_60_657 VGND VGND VPWR VPWR sky130_fd_sc_hd__decap_6
XFILLER_0_44_197 VGND VGND VPWR VPWR sky130_fd_sc_hd__decap_4
XTAP_TAPCELL_ROW_92_1412 VGND VPWR sky130_fd_sc_hd__tapvpwrvgnd_1
X_05208_ mac_inst.i\[4\] mac_inst.i\[5\] VGND VGND VPWR VPWR _04912_ sky130_fd_sc_hd__or2_2
X_06188_ tanh_inst.divider.y_\[-21\] _01131_ VGND VGND VPWR VPWR _01132_ sky130_fd_sc_hd__and2_2
X_05139_ mac_inst.i\[7\] mac_inst.i\[6\] VGND VGND VPWR VPWR _04843_ sky130_fd_sc_hd__or2_2
XFILLER_0_110_280 VGND VGND VPWR VPWR sky130_fd_sc_hd__fill_1
X_09947_ _04587_ _04612_ VGND VGND VPWR VPWR _04665_ sky130_fd_sc_hd__nand2_2
X_09878_ _04552_ _04555_ _04597_ VGND VGND VPWR VPWR _04598_ sky130_fd_sc_hd__o21a_2
X_08829_ _03573_ _03574_ tanh_inst.LOOKUP.index\[2\] VGND VGND VPWR VPWR _03575_ sky130_fd_sc_hd__mux2_1
XFILLER_0_83_705 VGND VGND VPWR VPWR sky130_fd_sc_hd__fill_2
XTAP_TAPCELL_ROW_101_1530 VGND VPWR sky130_fd_sc_hd__tapvpwrvgnd_1
XFILLER_0_27_109 VGND VGND VPWR VPWR sky130_fd_sc_hd__decap_3
XTAP_TAPCELL_ROW_11_402 VGND VPWR sky130_fd_sc_hd__tapvpwrvgnd_1
XFILLER_0_36_632 VGND VGND VPWR VPWR sky130_fd_sc_hd__decap_4
XFILLER_0_63_473 VPWR VGND VPWR VGND sky130_ef_sc_hd__decap_12
XFILLER_0_2_209 VPWR VGND VPWR VGND sky130_ef_sc_hd__decap_12
XFILLER_0_23_337 VGND VGND VPWR VPWR sky130_fd_sc_hd__decap_3
Xclkload19 clknet_leaf_37_clk VGND VGND VPWR VPWR clkload19/Y sky130_fd_sc_hd__clkinv_8
XFILLER_0_50_134 VGND VGND VPWR VPWR sky130_fd_sc_hd__decap_6
XFILLER_0_121_545 VPWR VGND VPWR VGND sky130_ef_sc_hd__decap_12
XFILLER_0_50_189 VGND VGND VPWR VPWR sky130_fd_sc_hd__decap_6
XFILLER_0_121_589 VPWR VGND VPWR VGND sky130_ef_sc_hd__decap_12
XFILLER_0_76_29 VPWR VGND VPWR VGND sky130_ef_sc_hd__decap_12
X_10018_ tanh_inst.divider.y\[6\] _02014_ _04733_ _01470_ VGND VGND VPWR VPWR _00327_
+ sky130_fd_sc_hd__o211a_2
XTAP_TAPCELL_ROW_19_502 VGND VPWR sky130_fd_sc_hd__tapvpwrvgnd_1
XTAP_TAPCELL_ROW_47_844 VGND VPWR sky130_fd_sc_hd__tapvpwrvgnd_1
XTAP_TAPCELL_ROW_47_855 VGND VPWR sky130_fd_sc_hd__tapvpwrvgnd_1
XFILLER_0_25_55 VGND VGND VPWR VPWR sky130_fd_sc_hd__fill_1
XFILLER_0_74_716 VGND VGND VPWR VPWR sky130_fd_sc_hd__decap_8
XFILLER_0_74_705 VGND VGND VPWR VPWR sky130_fd_sc_hd__fill_1
XTAP_TAPCELL_ROW_63_1046 VGND VPWR sky130_fd_sc_hd__tapvpwrvgnd_1
XFILLER_0_18_109 VPWR VGND VPWR VGND sky130_ef_sc_hd__decap_12
X_05490_ mac_inst.i\[3\] _00385_ _00412_ VGND VGND VPWR VPWR _00488_ sky130_fd_sc_hd__o21ai_2
XFILLER_0_46_418 VGND VGND VPWR VPWR sky130_fd_sc_hd__fill_2
XFILLER_0_116_339 VGND VGND VPWR VPWR sky130_fd_sc_hd__fill_2
X_07160_ tanh_inst.divider.z_\[2\] _01975_ VGND VGND VPWR VPWR _01980_ sky130_fd_sc_hd__or2_2
XFILLER_0_109_391 VGND VGND VPWR VPWR sky130_fd_sc_hd__fill_1
XFILLER_0_26_153 VPWR VGND VPWR VGND sky130_ef_sc_hd__decap_12
X_06111_ tanh_inst.divider.i\[4\] tanh_inst.divider.i\[3\] VGND VGND VPWR VPWR _01058_
+ sky130_fd_sc_hd__nand2_2
X_07091_ _01897_ _01900_ _01905_ _01912_ VGND VGND VPWR VPWR _01919_ sky130_fd_sc_hd__a211o_2
XFILLER_0_81_281 VGND VGND VPWR VPWR sky130_fd_sc_hd__decap_4
XFILLER_0_26_197 VPWR VGND VPWR VGND sky130_ef_sc_hd__decap_12
XFILLER_0_112_512 VGND VGND VPWR VPWR sky130_fd_sc_hd__fill_2
X_06042_ _00992_ _00993_ VGND VGND VPWR VPWR _06042_/X sky130_fd_sc_hd__xor2_2
XFILLER_0_10_510 VGND VGND VPWR VPWR sky130_fd_sc_hd__decap_4
XFILLER_0_112_589 VGND VGND VPWR VPWR sky130_fd_sc_hd__decap_6
XFILLER_0_112_578 VGND VGND VPWR VPWR sky130_fd_sc_hd__decap_8
XTAP_TAPCELL_ROW_74_1186 VGND VPWR sky130_fd_sc_hd__tapvpwrvgnd_1
XFILLER_0_10_587 VGND VGND VPWR VPWR sky130_fd_sc_hd__fill_1
X_09801_ _04480_ _04483_ _04522_ VGND VGND VPWR VPWR _04523_ sky130_fd_sc_hd__o21ai_2
X_07993_ _02787_ _02788_ VGND VGND VPWR VPWR _02789_ sky130_fd_sc_hd__or2_2
X_09732_ _04454_ _04455_ VGND VGND VPWR VPWR _04456_ sky130_fd_sc_hd__or2_2
X_06944_ _01780_ _01782_ _01779_ VGND VGND VPWR VPWR _01788_ sky130_fd_sc_hd__o21ba_2
X_06875_ _01758_ _01759_ VGND VGND VPWR VPWR _01760_ sky130_fd_sc_hd__nand2_2
X_09663_ tanh_inst.divider.y\[-4\] _04378_ VGND VGND VPWR VPWR _04389_ sky130_fd_sc_hd__nor2_2
X_09594_ _04275_ _04278_ _04321_ VGND VGND VPWR VPWR _04322_ sky130_fd_sc_hd__o21ai_2
X_05826_ _00792_ _00793_ VGND VGND VPWR VPWR _05826_/Y sky130_fd_sc_hd__xnor2_2
X_08614_ _03394_ _03395_ VGND VGND VPWR VPWR _03396_ sky130_fd_sc_hd__nand2_2
XFILLER_0_89_370 VGND VGND VPWR VPWR sky130_fd_sc_hd__decap_3
X_08545_ tanh_inst.divider.x\[3\] _03326_ VGND VGND VPWR VPWR _03328_ sky130_fd_sc_hd__nor2_2
XFILLER_0_49_212 VPWR VGND VPWR VGND sky130_ef_sc_hd__decap_12
XFILLER_0_119_111 VGND VGND VPWR VPWR sky130_fd_sc_hd__fill_1
XFILLER_0_77_565 VGND VGND VPWR VPWR sky130_fd_sc_hd__fill_1
X_05757_ mac_inst.i\[2\] _00680_ VGND VGND VPWR VPWR _00730_ sky130_fd_sc_hd__or2_2
XFILLER_0_37_407 VGND VGND VPWR VPWR sky130_fd_sc_hd__decap_4
X_05688_ _04923_ _04955_ _04975_ _00664_ VGND VGND VPWR VPWR _00666_ sky130_fd_sc_hd__or4_2
XFILLER_0_37_429 VPWR VGND VPWR VGND sky130_ef_sc_hd__decap_12
X_08476_ _03229_ _03232_ VGND VGND VPWR VPWR _03261_ sky130_fd_sc_hd__nor2_2
XFILLER_0_92_568 VGND VGND VPWR VPWR sky130_fd_sc_hd__decap_6
X_07427_ _02233_ _02234_ VGND VGND VPWR VPWR _02235_ sky130_fd_sc_hd__nand2_2
X_07358_ tanh_inst.divider.y\[-24\] tanh_inst.divider.x\[-24\] VGND VGND VPWR VPWR
+ _02167_ sky130_fd_sc_hd__nand2_2
X_06309_ _01243_ _01244_ _01089_ VGND VGND VPWR VPWR _01245_ sky130_fd_sc_hd__a21oi_2
XFILLER_0_60_421 VGND VGND VPWR VPWR sky130_fd_sc_hd__fill_2
X_07289_ _02053_ _02098_ _02065_ VGND VGND VPWR VPWR _02099_ sky130_fd_sc_hd__a21oi_2
XFILLER_0_103_545 VGND VGND VPWR VPWR sky130_fd_sc_hd__decap_3
X_09028_ _04757_ _03763_ _03770_ VGND VGND VPWR VPWR _03771_ sky130_fd_sc_hd__o21ai_2
XFILLER_0_20_307 VGND VGND VPWR VPWR sky130_fd_sc_hd__fill_1
XFILLER_0_32_167 VGND VGND VPWR VPWR sky130_fd_sc_hd__fill_1
XFILLER_0_103_578 VGND VGND VPWR VPWR sky130_fd_sc_hd__decap_8
XFILLER_0_87_329 VGND VGND VPWR VPWR sky130_fd_sc_hd__decap_6
XTAP_TAPCELL_ROW_44_814 VGND VPWR sky130_fd_sc_hd__tapvpwrvgnd_1
XFILLER_0_68_565 VGND VGND VPWR VPWR sky130_fd_sc_hd__decap_8
XFILLER_0_28_429 VGND VGND VPWR VPWR sky130_fd_sc_hd__fill_2
XFILLER_0_83_568 VGND VGND VPWR VPWR sky130_fd_sc_hd__fill_2
XFILLER_0_71_708 VPWR VGND VPWR VGND sky130_ef_sc_hd__decap_12
XTAP_TAPCELL_ROW_24_560 VGND VPWR sky130_fd_sc_hd__tapvpwrvgnd_1
XFILLER_0_102_15 VPWR VGND VPWR VGND sky130_ef_sc_hd__decap_12
XFILLER_0_11_57 VPWR VGND VPWR VGND sky130_ef_sc_hd__decap_12
XFILLER_0_23_145 VGND VGND VPWR VPWR sky130_fd_sc_hd__fill_1
XFILLER_0_11_329 VGND VGND VPWR VPWR sky130_fd_sc_hd__decap_6
XFILLER_0_23_167 VGND VGND VPWR VPWR sky130_fd_sc_hd__fill_1
X_06660_ _01502_ _01568_ _01569_ _01469_ mac_y_out[5] VGND VGND VPWR VPWR _00133_
+ sky130_fd_sc_hd__a32o_2
XFILLER_0_59_532 VGND VGND VPWR VPWR sky130_fd_sc_hd__decap_8
X_05611_ _00530_ _00567_ _00584_ _00594_ _00597_ VGND VGND VPWR VPWR _00598_ sky130_fd_sc_hd__o41a_2
X_06591_ tanh_inst.LOOKUP.index\[0\] _01476_ _01478_ VGND VGND VPWR VPWR _01505_ sky130_fd_sc_hd__and3_2
XFILLER_0_86_362 VGND VGND VPWR VPWR sky130_fd_sc_hd__fill_2
XFILLER_0_59_576 VGND VGND VPWR VPWR sky130_fd_sc_hd__decap_6
X_08330_ tanh_inst.divider.x\[-3\] _02014_ _03118_ _01470_ VGND VGND VPWR VPWR _00254_
+ sky130_fd_sc_hd__o211a_2
X_05542_ _00534_ _00535_ VGND VGND VPWR VPWR _00536_ sky130_fd_sc_hd__or2_2
XTAP_TAPCELL_ROW_121_1769 VGND VPWR sky130_fd_sc_hd__tapvpwrvgnd_1
XFILLER_0_117_626 VGND VGND VPWR VPWR sky130_fd_sc_hd__decap_8
XFILLER_0_74_568 VGND VGND VPWR VPWR sky130_fd_sc_hd__decap_8
XFILLER_0_6_301 VGND VGND VPWR VPWR sky130_fd_sc_hd__decap_6
X_05473_ _00458_ _00461_ _00457_ VGND VGND VPWR VPWR _00473_ sky130_fd_sc_hd__o21bai_2
X_08261_ _02972_ _03000_ VGND VGND VPWR VPWR _03051_ sky130_fd_sc_hd__nand2b_2
XFILLER_0_52_97 VGND VGND VPWR VPWR sky130_fd_sc_hd__fill_1
X_07212_ _04758_ _02021_ _02020_ VGND VGND VPWR VPWR _02022_ sky130_fd_sc_hd__o21a_2
XFILLER_0_104_309 VGND VGND VPWR VPWR sky130_fd_sc_hd__fill_2
XFILLER_0_6_345 VPWR VGND VPWR VGND sky130_ef_sc_hd__decap_12
X_08192_ _02978_ _02982_ _02983_ VGND VGND VPWR VPWR _02984_ sky130_fd_sc_hd__a21bo_2
X_07143_ _01031_ _01057_ _01959_ VGND VGND VPWR VPWR _01965_ sky130_fd_sc_hd__o21a_2
XTAP_TAPCELL_ROW_76_1215 VGND VPWR sky130_fd_sc_hd__tapvpwrvgnd_1
X_07074_ _01895_ _01902_ tanh_inst.divider.z_\[-8\] VGND VGND VPWR VPWR _01904_ sky130_fd_sc_hd__a21oi_2
XFILLER_0_14_189 VGND VGND VPWR VPWR sky130_fd_sc_hd__decap_6
XFILLER_0_65_3 VGND VGND VPWR VPWR sky130_fd_sc_hd__decap_6
X_06025_ mac_inst.z\[26\] _00977_ VGND VGND VPWR VPWR _00978_ sky130_fd_sc_hd__or2_2
X_07976_ tanh_inst.LOOKUP.index\[3\] _02418_ _02509_ VGND VGND VPWR VPWR _02773_ sky130_fd_sc_hd__o21a_2
X_06927_ _01057_ _01058_ VGND VGND VPWR VPWR _01773_ sky130_fd_sc_hd__or2_2
X_09715_ tanh_inst.divider.y\[-2\] _04438_ VGND VGND VPWR VPWR _04439_ sky130_fd_sc_hd__and2_2
XTAP_TAPCELL_ROW_87_1344 VGND VPWR sky130_fd_sc_hd__tapvpwrvgnd_1
X_09646_ _04293_ _04370_ VGND VGND VPWR VPWR _04372_ sky130_fd_sc_hd__nor2_2
XTAP_TAPCELL_ROW_87_1355 VGND VPWR sky130_fd_sc_hd__tapvpwrvgnd_1
X_06858_ _01743_ _01744_ VGND VGND VPWR VPWR _01745_ sky130_fd_sc_hd__nor2_2
XTAP_TAPCELL_ROW_2_288 VGND VPWR sky130_fd_sc_hd__tapvpwrvgnd_1
X_06789_ _01676_ _01679_ _01674_ VGND VGND VPWR VPWR _01685_ sky130_fd_sc_hd__o21ba_2
X_05809_ mac_inst.z\[10\] _00774_ VGND VGND VPWR VPWR _00778_ sky130_fd_sc_hd__nand2_2
X_09577_ _04302_ _04304_ VGND VGND VPWR VPWR _04305_ sky130_fd_sc_hd__or2_2
XFILLER_0_77_362 VPWR VGND VPWR VGND sky130_ef_sc_hd__decap_12
XFILLER_0_65_502 VGND VGND VPWR VPWR sky130_fd_sc_hd__fill_2
X_08528_ tanh_inst.divider.y\[2\] _03311_ VGND VGND VPWR VPWR _03312_ sky130_fd_sc_hd__nor2_2
XFILLER_0_65_557 VGND VGND VPWR VPWR sky130_fd_sc_hd__decap_3
XFILLER_0_9_161 VGND VGND VPWR VPWR sky130_fd_sc_hd__decap_6
X_08459_ tanh_inst.divider.x\[0\] _03243_ VGND VGND VPWR VPWR _03245_ sky130_fd_sc_hd__xnor2_2
XFILLER_0_107_125 VGND VGND VPWR VPWR sky130_fd_sc_hd__fill_2
XFILLER_0_92_365 VGND VGND VPWR VPWR sky130_fd_sc_hd__decap_3
XPHY_EDGE_ROW_14_Right_14 VGND VGND VPWR VPWR sky130_fd_sc_hd__decap_3
XTAP_TAPCELL_ROW_21_530 VGND VPWR sky130_fd_sc_hd__tapvpwrvgnd_1
XFILLER_0_73_590 VGND VGND VPWR VPWR sky130_fd_sc_hd__decap_4
X_10421_ clknet_leaf_37_clk _00278_ _00000_ VGND VGND VPWR VPWR mac_inst.i\[13\] sky130_fd_sc_hd__dfrtp_2
XTAP_TAPCELL_ROW_98_1484 VGND VPWR sky130_fd_sc_hd__tapvpwrvgnd_1
X_10352_ clknet_leaf_20_clk _00209_ VGND VGND VPWR VPWR tanh_inst.divider.z_\[-12\]
+ sky130_fd_sc_hd__dfxtp_2
XFILLER_0_21_649 VGND VGND VPWR VPWR sky130_fd_sc_hd__fill_1
X_10283_ clknet_leaf_29_clk _00140_ VGND VGND VPWR VPWR tanh_inst.z_\[-12\] sky130_fd_sc_hd__dfxtp_2
XPHY_EDGE_ROW_23_Right_23 VGND VGND VPWR VPWR sky130_fd_sc_hd__decap_3
XFILLER_0_73_19 VPWR VGND VPWR VGND sky130_ef_sc_hd__decap_12
XFILLER_0_88_627 VGND VGND VPWR VPWR sky130_fd_sc_hd__decap_8
XTAP_TAPCELL_ROW_29_630 VGND VPWR sky130_fd_sc_hd__tapvpwrvgnd_1
XTAP_TAPCELL_ROW_57_972 VGND VPWR sky130_fd_sc_hd__tapvpwrvgnd_1
XFILLER_0_28_204 VGND VGND VPWR VPWR sky130_fd_sc_hd__fill_2
XPHY_EDGE_ROW_32_Right_32 VGND VGND VPWR VPWR sky130_fd_sc_hd__decap_3
XFILLER_0_95_181 VPWR VGND VPWR VGND sky130_ef_sc_hd__decap_12
XTAP_TAPCELL_ROW_60_1016 VGND VPWR sky130_fd_sc_hd__tapvpwrvgnd_1
XFILLER_0_113_69 VPWR VGND VPWR VGND sky130_ef_sc_hd__decap_12
XFILLER_0_71_505 VGND VGND VPWR VPWR sky130_fd_sc_hd__decap_4
XFILLER_0_43_207 VGND VGND VPWR VPWR sky130_fd_sc_hd__decap_4
XFILLER_0_98_27 VGND VGND VPWR VPWR sky130_fd_sc_hd__fill_1
XFILLER_0_3_337 VPWR VGND VPWR VGND sky130_ef_sc_hd__decap_12
XFILLER_0_11_137 VPWR VGND VPWR VGND sky130_ef_sc_hd__decap_12
XPHY_EDGE_ROW_41_Right_41 VGND VGND VPWR VPWR sky130_fd_sc_hd__decap_3
XPHY_EDGE_ROW_102_Left_224 VGND VGND VPWR VPWR sky130_fd_sc_hd__decap_3
XTAP_TAPCELL_ROW_71_1145 VGND VPWR sky130_fd_sc_hd__tapvpwrvgnd_1
X_07830_ _02581_ _02627_ _02629_ VGND VGND VPWR VPWR _02630_ sky130_fd_sc_hd__nand3_2
X_07761_ _02561_ _02562_ _02019_ _02546_ VGND VGND VPWR VPWR _02563_ sky130_fd_sc_hd__o211ai_2
X_06712_ tanh_inst.z_\[-13\] _01614_ VGND VGND VPWR VPWR _01616_ sky130_fd_sc_hd__or2_2
X_09500_ _04163_ _04229_ tanh_inst.z_\[7\] VGND VGND VPWR VPWR _04230_ sky130_fd_sc_hd__a21o_2
X_07692_ _02442_ _02444_ _02494_ VGND VGND VPWR VPWR _02495_ sky130_fd_sc_hd__nor3_2
XFILLER_0_79_638 VGND VGND VPWR VPWR sky130_fd_sc_hd__decap_3
X_06643_ _01502_ _01553_ _01554_ _01469_ mac_y_out[3] VGND VGND VPWR VPWR _00131_
+ sky130_fd_sc_hd__a32o_2
X_09431_ _04047_ _04116_ _04117_ _04151_ VGND VGND VPWR VPWR _04163_ sky130_fd_sc_hd__and4_2
XFILLER_0_2_77 VGND VGND VPWR VPWR sky130_fd_sc_hd__decap_6
XPHY_EDGE_ROW_50_Right_50 VGND VGND VPWR VPWR sky130_fd_sc_hd__decap_3
XPHY_EDGE_ROW_111_Left_233 VGND VGND VPWR VPWR sky130_fd_sc_hd__decap_3
X_09362_ _04090_ _04095_ VGND VGND VPWR VPWR _04096_ sky130_fd_sc_hd__nor2_2
X_06574_ tanh_inst.z_\[-24\] _01487_ VGND VGND VPWR VPWR _01489_ sky130_fd_sc_hd__nand2_2
XFILLER_0_47_502 VGND VGND VPWR VPWR sky130_fd_sc_hd__fill_2
XFILLER_0_74_321 VGND VGND VPWR VPWR sky130_fd_sc_hd__decap_3
XFILLER_0_19_237 VPWR VGND VPWR VGND sky130_ef_sc_hd__decap_12
X_08313_ _03084_ _03101_ VGND VGND VPWR VPWR _03102_ sky130_fd_sc_hd__and2_2
XTAP_TAPCELL_ROW_35_699 VGND VPWR sky130_fd_sc_hd__tapvpwrvgnd_1
X_05525_ _00519_ _00520_ VGND VGND VPWR VPWR _05525_/Y sky130_fd_sc_hd__xnor2_2
X_09293_ _04026_ _04027_ VGND VGND VPWR VPWR _04029_ sky130_fd_sc_hd__xnor2_2
XTAP_TAPCELL_ROW_82_1285 VGND VPWR sky130_fd_sc_hd__tapvpwrvgnd_1
XFILLER_0_74_354 VGND VGND VPWR VPWR sky130_fd_sc_hd__decap_8
XFILLER_0_47_579 VPWR VGND VPWR VGND sky130_ef_sc_hd__decap_12
XFILLER_0_6_153 VPWR VGND VPWR VGND sky130_ef_sc_hd__decap_12
XFILLER_0_27_270 VGND VGND VPWR VPWR sky130_fd_sc_hd__decap_8
XFILLER_0_27_281 VPWR VGND VPWR VGND sky130_ef_sc_hd__decap_12
X_05456_ mac_inst.y\[10\] _00456_ VGND VGND VPWR VPWR _00457_ sky130_fd_sc_hd__and2_2
X_08244_ _03032_ _03033_ VGND VGND VPWR VPWR _03034_ sky130_fd_sc_hd__nor2_2
X_05387_ _00376_ _00377_ mac_inst.z\[31\] VGND VGND VPWR VPWR _00393_ sky130_fd_sc_hd__a21o_2
X_08175_ _02879_ _02966_ VGND VGND VPWR VPWR _02967_ sky130_fd_sc_hd__nand2_2
X_07126_ tanh_inst.divider.z_\[-2\] _01949_ VGND VGND VPWR VPWR _01950_ sky130_fd_sc_hd__and2_2
XFILLER_0_6_197 VPWR VGND VPWR VGND sky130_ef_sc_hd__decap_12
XPHY_EDGE_ROW_120_Left_242 VGND VGND VPWR VPWR sky130_fd_sc_hd__decap_3
XFILLER_0_88_82 VGND VGND VPWR VPWR sky130_fd_sc_hd__fill_2
X_07057_ _01886_ _01888_ VGND VGND VPWR VPWR _01889_ sky130_fd_sc_hd__nor2_2
XTAP_TAPCELL_ROW_7_347 VGND VPWR sky130_fd_sc_hd__tapvpwrvgnd_1
X_06008_ mac_inst.i\[11\] mac_inst.i\[13\] mac_inst.i\[12\] _00960_ VGND VGND VPWR
+ VPWR _00962_ sky130_fd_sc_hd__and4_2
XFILLER_0_100_389 VGND VGND VPWR VPWR sky130_fd_sc_hd__decap_6
X_07959_ tanh_inst.divider.y\[-11\] _02755_ VGND VGND VPWR VPWR _02756_ sky130_fd_sc_hd__xor2_2
XFILLER_0_85_608 VGND VGND VPWR VPWR sky130_fd_sc_hd__decap_8
XTAP_TAPCELL_ROW_54_931 VGND VPWR sky130_fd_sc_hd__tapvpwrvgnd_1
X_09629_ _04353_ _04355_ VGND VGND VPWR VPWR _04356_ sky130_fd_sc_hd__xor2_2
XFILLER_0_97_479 VPWR VGND VPWR VGND sky130_ef_sc_hd__decap_12
XTAP_TAPCELL_ROW_54_942 VGND VPWR sky130_fd_sc_hd__tapvpwrvgnd_1
XFILLER_0_38_546 VGND VGND VPWR VPWR sky130_fd_sc_hd__decap_4
XFILLER_0_108_434 VGND VGND VPWR VPWR sky130_fd_sc_hd__decap_3
XFILLER_0_38_579 VGND VGND VPWR VPWR sky130_fd_sc_hd__fill_1
XFILLER_0_53_505 VPWR VGND VPWR VGND sky130_ef_sc_hd__decap_12
XFILLER_0_108_489 VPWR VGND VPWR VGND sky130_ef_sc_hd__decap_12
X_10404_ clknet_leaf_44_clk _00261_ VGND VGND VPWR VPWR tanh_inst.divider.x\[4\] sky130_fd_sc_hd__dfxtp_2
XFILLER_0_33_273 VGND VGND VPWR VPWR sky130_fd_sc_hd__decap_6
XFILLER_0_110_109 VPWR VGND VPWR VGND sky130_ef_sc_hd__decap_12
XFILLER_0_61_593 VGND VGND VPWR VPWR sky130_fd_sc_hd__decap_4
X_10335_ clknet_leaf_16_clk _00192_ VGND VGND VPWR VPWR tanh_out[27] sky130_fd_sc_hd__dfxtp_2
X_10266_ clknet_leaf_31_clk mac_inst.x\[28\] _00000_ VGND VGND VPWR VPWR mac_x_out[28]
+ sky130_fd_sc_hd__dfrtp_2
XFILLER_0_84_29 VGND VGND VPWR VPWR sky130_fd_sc_hd__decap_4
X_10197_ x_in[23] _00000_ VGND VGND VPWR VPWR mac_inst.x\[23\] sky130_fd_sc_hd__dlxtn_1
XTAP_TAPCELL_ROW_109_1620 VGND VPWR sky130_fd_sc_hd__tapvpwrvgnd_1
XFILLER_0_29_513 VGND VGND VPWR VPWR sky130_fd_sc_hd__decap_8
XFILLER_0_84_641 VGND VGND VPWR VPWR sky130_fd_sc_hd__decap_3
XFILLER_0_33_55 VGND VGND VPWR VPWR sky130_fd_sc_hd__fill_1
Xclkbuf_leaf_41_clk clknet_2_0__leaf_clk VGND VGND VPWR VPWR clknet_leaf_41_clk sky130_fd_sc_hd__clkbuf_8
XFILLER_0_29_557 VGND VGND VPWR VPWR sky130_fd_sc_hd__decap_3
XFILLER_0_29_579 VGND VGND VPWR VPWR sky130_fd_sc_hd__decap_3
X_06290_ _01039_ _01095_ _01105_ _01031_ VGND VGND VPWR VPWR _01227_ sky130_fd_sc_hd__o22a_2
XTAP_TAPCELL_ROW_32_658 VGND VPWR sky130_fd_sc_hd__tapvpwrvgnd_1
X_05310_ _05008_ _05009_ VGND VGND VPWR VPWR _05010_ sky130_fd_sc_hd__xnor2_2
XFILLER_0_71_335 VGND VGND VPWR VPWR sky130_fd_sc_hd__fill_1
X_05241_ mac_inst.i\[31\] _04941_ VGND VGND VPWR VPWR _04942_ sky130_fd_sc_hd__nor2_2
X_05172_ mac_inst.x\[28\] _04852_ _04853_ VGND VGND VPWR VPWR _04876_ sky130_fd_sc_hd__a21o_2
XFILLER_0_40_722 VGND VGND VPWR VPWR sky130_fd_sc_hd__fill_2
XFILLER_0_12_435 VGND VGND VPWR VPWR sky130_fd_sc_hd__fill_2
XFILLER_0_3_167 VGND VGND VPWR VPWR sky130_fd_sc_hd__fill_1
XFILLER_0_110_610 VGND VGND VPWR VPWR sky130_fd_sc_hd__fill_1
X_09980_ _04631_ _04640_ _04791_ VGND VGND VPWR VPWR _04697_ sky130_fd_sc_hd__o21a_2
X_08931_ _02027_ _03540_ _03600_ VGND VGND VPWR VPWR _03675_ sky130_fd_sc_hd__o21a_2
X_08862_ _03544_ _03552_ _03554_ _03556_ _04761_ _04760_ VGND VGND VPWR VPWR _03607_
+ sky130_fd_sc_hd__mux4_2
XFILLER_0_58_85 VPWR VGND VPWR VGND sky130_ef_sc_hd__decap_12
XTAP_TAPCELL_ROW_4_306 VGND VPWR sky130_fd_sc_hd__tapvpwrvgnd_1
X_07813_ _04762_ _02216_ _02221_ _02206_ _02023_ _02052_ VGND VGND VPWR VPWR _02613_
+ sky130_fd_sc_hd__mux4_2
XTAP_TAPCELL_ROW_4_317 VGND VPWR sky130_fd_sc_hd__tapvpwrvgnd_1
X_08793_ tanh_inst.divider.x\[6\] _02028_ _03508_ VGND VGND VPWR VPWR _03539_ sky130_fd_sc_hd__o21a_2
X_07744_ _02542_ _02544_ _02545_ VGND VGND VPWR VPWR _02546_ sky130_fd_sc_hd__a21o_2
XFILLER_0_79_402 VGND VGND VPWR VPWR sky130_fd_sc_hd__decap_8
XFILLER_0_28_3 VPWR VGND VPWR VGND sky130_ef_sc_hd__decap_12
XTAP_TAPCELL_ROW_84_1314 VGND VPWR sky130_fd_sc_hd__tapvpwrvgnd_1
X_07675_ _02380_ _02381_ _02427_ _02378_ VGND VGND VPWR VPWR _02479_ sky130_fd_sc_hd__a211o_2
X_09414_ _04140_ _04141_ _04146_ tanh_inst.z_\[7\] VGND VGND VPWR VPWR _04147_ sky130_fd_sc_hd__o22a_2
XFILLER_0_94_427 VGND VGND VPWR VPWR sky130_fd_sc_hd__fill_1
X_06626_ tanh_inst.z_\[-22\] _01537_ VGND VGND VPWR VPWR _01539_ sky130_fd_sc_hd__xnor2_2
XFILLER_0_109_209 VPWR VGND VPWR VGND sky130_ef_sc_hd__decap_12
XFILLER_0_90_61 VGND VGND VPWR VPWR sky130_fd_sc_hd__decap_8
XTAP_TAPCELL_ROW_51_901 VGND VPWR sky130_fd_sc_hd__tapvpwrvgnd_1
XFILLER_0_90_600 VPWR VGND VPWR VGND sky130_ef_sc_hd__decap_12
XFILLER_0_90_94 VGND VGND VPWR VPWR sky130_fd_sc_hd__decap_4
X_06557_ tanh_inst.LOOKUP.index\[1\] _04761_ VGND VGND VPWR VPWR _01472_ sky130_fd_sc_hd__nand2_2
X_09345_ _04078_ _04079_ VGND VGND VPWR VPWR _04080_ sky130_fd_sc_hd__xnor2_2
Xclkbuf_leaf_32_clk clknet_2_1__leaf_clk VGND VGND VPWR VPWR clknet_leaf_32_clk sky130_fd_sc_hd__clkbuf_8
X_06488_ tanh_inst.divider.y\[1\] tanh_inst.div_en tanh_inst.divider.y_\[1\] _01092_
+ _01409_ VGND VGND VPWR VPWR _00111_ sky130_fd_sc_hd__a221o_2
X_09276_ _04012_ VGND VGND VPWR VPWR _04013_ sky130_fd_sc_hd__inv_2
XFILLER_0_74_184 VPWR VGND VPWR VGND sky130_ef_sc_hd__decap_12
X_05508_ mac_inst.y\[12\] _00484_ _00491_ mac_inst.y\[13\] VGND VGND VPWR VPWR _00505_
+ sky130_fd_sc_hd__a22o_2
XFILLER_0_105_404 VGND VGND VPWR VPWR sky130_fd_sc_hd__fill_1
X_05439_ mac_inst.i\[3\] _04993_ _00412_ VGND VGND VPWR VPWR _00441_ sky130_fd_sc_hd__o21a_2
X_08227_ tanh_inst.LOOKUP.index\[4\] _02316_ _02859_ VGND VGND VPWR VPWR _03018_ sky130_fd_sc_hd__o21ai_2
XFILLER_0_90_699 VGND VGND VPWR VPWR sky130_fd_sc_hd__fill_1
XTAP_TAPCELL_ROW_95_1454 VGND VPWR sky130_fd_sc_hd__tapvpwrvgnd_1
XFILLER_0_15_273 VGND VGND VPWR VPWR sky130_fd_sc_hd__decap_6
X_08158_ _02917_ _02920_ _02950_ VGND VGND VPWR VPWR _02951_ sky130_fd_sc_hd__a21oi_2
X_08089_ _02802_ _02850_ VGND VGND VPWR VPWR _02883_ sky130_fd_sc_hd__or2_2
XFILLER_0_101_610 VGND VGND VPWR VPWR sky130_fd_sc_hd__decap_6
X_07109_ _01933_ _01934_ VGND VGND VPWR VPWR _01935_ sky130_fd_sc_hd__nand2_2
XFILLER_0_3_690 VGND VGND VPWR VPWR sky130_fd_sc_hd__fill_2
XFILLER_0_30_232 VGND VGND VPWR VPWR sky130_fd_sc_hd__fill_1
XFILLER_0_101_643 VGND VGND VPWR VPWR sky130_fd_sc_hd__fill_2
XFILLER_0_100_153 VGND VGND VPWR VPWR sky130_fd_sc_hd__decap_8
X_10051_ rst VGND VGND VPWR VPWR _00070_ sky130_fd_sc_hd__inv_2
XFILLER_0_100_197 VGND VGND VPWR VPWR sky130_fd_sc_hd__decap_3
XFILLER_0_97_210 VGND VGND VPWR VPWR sky130_fd_sc_hd__decap_8
XFILLER_0_58_619 VGND VGND VPWR VPWR sky130_fd_sc_hd__decap_8
XFILLER_0_57_118 VGND VGND VPWR VPWR sky130_fd_sc_hd__fill_2
XTAP_TAPCELL_ROW_104_1561 VGND VPWR sky130_fd_sc_hd__tapvpwrvgnd_1
XFILLER_0_85_449 VPWR VGND VPWR VGND sky130_ef_sc_hd__decap_12
XFILLER_0_78_490 VGND VGND VPWR VPWR sky130_fd_sc_hd__decap_3
XFILLER_0_38_321 VPWR VGND VPWR VGND sky130_ef_sc_hd__decap_12
Xclkbuf_leaf_23_clk clknet_2_3__leaf_clk VGND VGND VPWR VPWR clknet_leaf_23_clk sky130_fd_sc_hd__clkbuf_8
XFILLER_0_38_365 VPWR VGND VPWR VGND sky130_ef_sc_hd__decap_12
XFILLER_0_93_460 VGND VGND VPWR VPWR sky130_fd_sc_hd__fill_1
XFILLER_0_81_644 VGND VGND VPWR VPWR sky130_fd_sc_hd__decap_6
XFILLER_0_53_346 VGND VGND VPWR VPWR sky130_fd_sc_hd__decap_4
XFILLER_0_110_15 VPWR VGND VPWR VGND sky130_ef_sc_hd__decap_12
XFILLER_0_22_722 VGND VGND VPWR VPWR sky130_fd_sc_hd__fill_2
XFILLER_0_1_638 VGND VGND VPWR VPWR sky130_fd_sc_hd__fill_1
XFILLER_0_95_39 VPWR VGND VPWR VGND sky130_ef_sc_hd__decap_12
X_10318_ clknet_leaf_21_clk _00175_ VGND VGND VPWR VPWR tanh_out[10] sky130_fd_sc_hd__dfxtp_2
XFILLER_0_0_137 VGND VGND VPWR VPWR sky130_fd_sc_hd__decap_3
XFILLER_0_119_57 VPWR VGND VPWR VGND sky130_ef_sc_hd__decap_12
X_10249_ clknet_leaf_32_clk mac_inst.x\[11\] _00000_ VGND VGND VPWR VPWR mac_x_out[11]
+ sky130_fd_sc_hd__dfrtp_2
XFILLER_0_28_99 VGND VGND VPWR VPWR sky130_fd_sc_hd__decap_3
X_05790_ mac_inst.i\[3\] mac_inst.i\[2\] VGND VGND VPWR VPWR _00760_ sky130_fd_sc_hd__nand2_2
XTAP_TAPCELL_ROW_37_728 VGND VPWR sky130_fd_sc_hd__tapvpwrvgnd_1
XFILLER_0_44_21 VGND VGND VPWR VPWR sky130_fd_sc_hd__decap_6
XFILLER_0_88_276 VPWR VGND VPWR VGND sky130_ef_sc_hd__decap_12
X_07460_ _02266_ _02267_ _02018_ VGND VGND VPWR VPWR _02268_ sky130_fd_sc_hd__o21a_2
XFILLER_0_76_427 VGND VGND VPWR VPWR sky130_fd_sc_hd__fill_1
XFILLER_0_9_716 VGND VGND VPWR VPWR sky130_fd_sc_hd__decap_8
XFILLER_0_48_118 VGND VGND VPWR VPWR sky130_fd_sc_hd__decap_3
X_06411_ _01325_ _01330_ _01338_ VGND VGND VPWR VPWR _01339_ sky130_fd_sc_hd__a21o_2
X_07391_ _02198_ _02199_ VGND VGND VPWR VPWR _02200_ sky130_fd_sc_hd__xnor2_2
XTAP_TAPCELL_ROW_66_1088 VGND VPWR sky130_fd_sc_hd__tapvpwrvgnd_1
XTAP_TAPCELL_ROW_17_474 VGND VPWR sky130_fd_sc_hd__tapvpwrvgnd_1
XFILLER_0_17_505 VGND VGND VPWR VPWR sky130_fd_sc_hd__decap_3
Xclkbuf_leaf_14_clk clknet_2_3__leaf_clk VGND VGND VPWR VPWR clknet_leaf_14_clk sky130_fd_sc_hd__clkbuf_8
X_06342_ _01274_ _01275_ _01088_ VGND VGND VPWR VPWR _01276_ sky130_fd_sc_hd__o21a_2
X_09130_ _02025_ _03669_ VGND VGND VPWR VPWR _03870_ sky130_fd_sc_hd__nand2_2
X_09061_ _03801_ _03802_ VGND VGND VPWR VPWR _03803_ sky130_fd_sc_hd__nand2_2
XFILLER_0_56_195 VGND VGND VPWR VPWR sky130_fd_sc_hd__fill_1
X_06273_ _01199_ _01201_ _01198_ VGND VGND VPWR VPWR _01212_ sky130_fd_sc_hd__a21o_2
XFILLER_0_114_234 VPWR VGND VPWR VGND sky130_ef_sc_hd__decap_12
X_08012_ _02802_ _02805_ _02806_ VGND VGND VPWR VPWR _02808_ sky130_fd_sc_hd__nand3_2
XFILLER_0_4_443 VGND VGND VPWR VPWR sky130_fd_sc_hd__fill_2
XFILLER_0_32_519 VGND VGND VPWR VPWR sky130_fd_sc_hd__fill_1
XFILLER_0_12_221 VPWR VGND VPWR VGND sky130_ef_sc_hd__decap_12
XFILLER_0_8_65 VPWR VGND VPWR VGND sky130_ef_sc_hd__decap_12
X_05224_ mac_inst.y\[0\] _04927_ VGND VGND VPWR VPWR _04928_ sky130_fd_sc_hd__or2_2
X_05155_ mac_inst.x\[18\] _04852_ _04853_ VGND VGND VPWR VPWR _04859_ sky130_fd_sc_hd__a21oi_2
XFILLER_0_40_541 VGND VGND VPWR VPWR sky130_fd_sc_hd__fill_1
X_09963_ _04669_ _04672_ _04670_ VGND VGND VPWR VPWR _04680_ sky130_fd_sc_hd__a21oi_2
XFILLER_0_12_265 VPWR VGND VPWR VGND sky130_ef_sc_hd__decap_12
X_05086_ current_state\[1\] current_state\[0\] VGND VGND VPWR VPWR _04809_ sky130_fd_sc_hd__nor2_2
XPHY_EDGE_ROW_4_Right_4 VGND VGND VPWR VPWR sky130_fd_sc_hd__decap_3
XFILLER_0_110_473 VGND VGND VPWR VPWR sky130_fd_sc_hd__decap_3
X_08914_ _03580_ _03657_ _04791_ VGND VGND VPWR VPWR _03659_ sky130_fd_sc_hd__o21ai_2
XFILLER_0_0_671 VGND VGND VPWR VPWR sky130_fd_sc_hd__fill_1
XTAP_TAPCELL_ROW_90_1384 VGND VPWR sky130_fd_sc_hd__tapvpwrvgnd_1
XFILLER_0_0_693 VGND VGND VPWR VPWR sky130_fd_sc_hd__decap_6
X_09894_ _04588_ _04590_ _04586_ VGND VGND VPWR VPWR _04613_ sky130_fd_sc_hd__o21bai_2
X_08845_ _03523_ _03528_ _04761_ VGND VGND VPWR VPWR _03590_ sky130_fd_sc_hd__mux2_1
X_08776_ _03514_ _03521_ _02025_ VGND VGND VPWR VPWR _03522_ sky130_fd_sc_hd__mux2_1
X_07727_ tanh_inst.divider.x\[-17\] _02015_ VGND VGND VPWR VPWR _02530_ sky130_fd_sc_hd__nand2_2
X_05988_ _00942_ VGND VGND VPWR VPWR _00943_ sky130_fd_sc_hd__inv_2
X_07658_ _02460_ _02461_ VGND VGND VPWR VPWR _02462_ sky130_fd_sc_hd__or2_2
XFILLER_0_67_449 VGND VGND VPWR VPWR sky130_fd_sc_hd__fill_2
XFILLER_0_67_438 VGND VGND VPWR VPWR sky130_fd_sc_hd__decap_8
X_07589_ tanh_inst.divider.x\[-19\] _02392_ VGND VGND VPWR VPWR _02394_ sky130_fd_sc_hd__xnor2_2
XFILLER_0_82_408 VGND VGND VPWR VPWR sky130_fd_sc_hd__decap_3
X_06609_ tanh_inst.LOOKUP.index\[1\] tanh_inst.LOOKUP.index\[0\] VGND VGND VPWR VPWR
+ _01522_ sky130_fd_sc_hd__nor2_2
X_09328_ _04035_ _04041_ _04061_ VGND VGND VPWR VPWR _04063_ sky130_fd_sc_hd__a21o_2
XFILLER_0_35_313 VGND VGND VPWR VPWR sky130_fd_sc_hd__fill_2
XFILLER_0_75_493 VGND VGND VPWR VPWR sky130_fd_sc_hd__decap_4
X_09259_ tanh_inst.divider.y\[-15\] _03990_ VGND VGND VPWR VPWR _03996_ sky130_fd_sc_hd__nand2_2
XFILLER_0_63_677 VGND VGND VPWR VPWR sky130_fd_sc_hd__fill_1
XFILLER_0_7_281 VPWR VGND VPWR VGND sky130_ef_sc_hd__decap_12
XFILLER_0_31_530 VGND VGND VPWR VPWR sky130_fd_sc_hd__fill_1
XFILLER_0_31_585 VPWR VGND VPWR VGND sky130_ef_sc_hd__decap_12
X_10103_ clknet_leaf_32_clk _00120_ _00070_ VGND VGND VPWR VPWR mac_counter\[2\] sky130_fd_sc_hd__dfrtp_2
X_10034_ tanh_inst.IS_FIRST13 _01529_ _02013_ VGND VGND VPWR VPWR _04748_ sky130_fd_sc_hd__a21oi_2
XFILLER_0_98_530 VGND VGND VPWR VPWR sky130_fd_sc_hd__fill_2
XFILLER_0_105_15 VPWR VGND VPWR VGND sky130_ef_sc_hd__decap_12
XFILLER_0_98_596 VGND VGND VPWR VPWR sky130_fd_sc_hd__decap_8
XFILLER_0_85_279 VGND VGND VPWR VPWR sky130_fd_sc_hd__fill_1
XTAP_TAPCELL_ROW_14_433 VGND VPWR sky130_fd_sc_hd__tapvpwrvgnd_1
XFILLER_0_66_493 VGND VGND VPWR VPWR sky130_fd_sc_hd__fill_1
XTAP_TAPCELL_ROW_42_786 VGND VPWR sky130_fd_sc_hd__tapvpwrvgnd_1
XFILLER_0_53_110 VGND VGND VPWR VPWR sky130_fd_sc_hd__fill_2
XFILLER_0_121_69 VPWR VGND VPWR VGND sky130_ef_sc_hd__decap_12
XFILLER_0_30_56 VGND VGND VPWR VPWR sky130_fd_sc_hd__decap_8
XTAP_TAPCELL_ROW_117_1730 VGND VPWR sky130_fd_sc_hd__tapvpwrvgnd_1
XFILLER_0_41_349 VPWR VGND VPWR VGND sky130_ef_sc_hd__decap_12
XFILLER_0_22_585 VGND VGND VPWR VPWR sky130_fd_sc_hd__decap_3
XFILLER_0_39_43 VPWR VGND VPWR VGND sky130_ef_sc_hd__decap_12
X_06960_ tanh_inst.divider.z_\[-20\] _01800_ VGND VGND VPWR VPWR _01802_ sky130_fd_sc_hd__xnor2_2
Xclkbuf_leaf_3_clk clknet_2_2__leaf_clk VGND VGND VPWR VPWR clknet_leaf_3_clk sky130_fd_sc_hd__clkbuf_8
XFILLER_0_39_98 VGND VGND VPWR VPWR sky130_fd_sc_hd__decap_3
X_06891_ tanh_inst.div_en _01770_ VGND VGND VPWR VPWR _01771_ sky130_fd_sc_hd__nor2_2
X_05911_ _00865_ _00870_ mac_inst.z\[17\] VGND VGND VPWR VPWR _00873_ sky130_fd_sc_hd__a21bo_2
X_08630_ _03410_ VGND VGND VPWR VPWR _03411_ sky130_fd_sc_hd__inv_2
X_05842_ _00771_ _00777_ _00789_ _04800_ VGND VGND VPWR VPWR _00809_ sky130_fd_sc_hd__a211o_2
XTAP_TAPCELL_ROW_68_1117 VGND VPWR sky130_fd_sc_hd__tapvpwrvgnd_1
XTAP_TAPCELL_ROW_68_1106 VGND VPWR sky130_fd_sc_hd__tapvpwrvgnd_1
XFILLER_0_55_64 VGND VGND VPWR VPWR sky130_fd_sc_hd__fill_1
X_05773_ mac_inst.z\[31\] _00740_ _00741_ _04799_ VGND VGND VPWR VPWR _00745_ sky130_fd_sc_hd__a211o_2
X_08561_ _03305_ _03307_ _03303_ VGND VGND VPWR VPWR _03344_ sky130_fd_sc_hd__a21oi_2
XFILLER_0_76_235 VGND VGND VPWR VPWR sky130_fd_sc_hd__decap_4
XFILLER_0_76_213 VPWR VGND VPWR VGND sky130_ef_sc_hd__decap_12
X_07512_ _01478_ _02150_ _02317_ _04759_ VGND VGND VPWR VPWR _02319_ sky130_fd_sc_hd__o22a_2
X_08492_ _03274_ _03276_ VGND VGND VPWR VPWR _03277_ sky130_fd_sc_hd__xnor2_2
XFILLER_0_49_449 VPWR VGND VPWR VGND sky130_ef_sc_hd__decap_12
XFILLER_0_119_315 VGND VGND VPWR VPWR sky130_fd_sc_hd__decap_3
XFILLER_0_76_268 VGND VGND VPWR VPWR sky130_fd_sc_hd__decap_3
XFILLER_0_9_513 VGND VGND VPWR VPWR sky130_fd_sc_hd__fill_1
X_07443_ _02245_ _02246_ _02249_ _02248_ tanh_inst.LOOKUP.index\[2\] tanh_inst.LOOKUP.index\[3\]
+ VGND VGND VPWR VPWR _02251_ sky130_fd_sc_hd__mux4_2
XFILLER_0_29_151 VGND VGND VPWR VPWR sky130_fd_sc_hd__decap_4
XFILLER_0_91_238 VPWR VGND VPWR VGND sky130_ef_sc_hd__decap_12
XFILLER_0_72_441 VGND VGND VPWR VPWR sky130_fd_sc_hd__decap_6
X_09113_ _01480_ _03639_ _03641_ _01486_ VGND VGND VPWR VPWR _03854_ sky130_fd_sc_hd__o22a_2
X_07374_ tanh_inst.divider.y\[7\] _02182_ _04760_ VGND VGND VPWR VPWR _02183_ sky130_fd_sc_hd__mux2_1
XFILLER_0_17_335 VGND VGND VPWR VPWR sky130_fd_sc_hd__fill_1
X_06325_ _01212_ _01259_ _01258_ _01257_ VGND VGND VPWR VPWR _01260_ sky130_fd_sc_hd__a211o_2
XFILLER_0_95_3 VPWR VGND VPWR VGND sky130_ef_sc_hd__decap_12
XFILLER_0_60_603 VGND VGND VPWR VPWR sky130_fd_sc_hd__fill_1
X_06256_ tanh_inst.divider.y_\[7\] _01195_ VGND VGND VPWR VPWR _01196_ sky130_fd_sc_hd__nor2_2
XFILLER_0_103_705 VGND VGND VPWR VPWR sky130_fd_sc_hd__fill_2
X_09044_ _03548_ _03557_ _02025_ VGND VGND VPWR VPWR _03786_ sky130_fd_sc_hd__mux2_1
XTAP_TAPCELL_ROW_79_1246 VGND VPWR sky130_fd_sc_hd__tapvpwrvgnd_1
XFILLER_0_4_251 VGND VGND VPWR VPWR sky130_fd_sc_hd__fill_1
XFILLER_0_102_226 VPWR VGND VPWR VGND sky130_ef_sc_hd__decap_12
XFILLER_0_102_215 VGND VGND VPWR VPWR sky130_fd_sc_hd__decap_8
X_05207_ mac_inst.i\[4\] mac_inst.i\[5\] VGND VGND VPWR VPWR _04911_ sky130_fd_sc_hd__nor2_2
X_06187_ _01129_ _01130_ VGND VGND VPWR VPWR _01131_ sky130_fd_sc_hd__xor2_2
XTAP_TAPCELL_ROW_92_1413 VGND VPWR sky130_fd_sc_hd__tapvpwrvgnd_1
X_05138_ mac_inst.i\[21\] mac_inst.i\[20\] VGND VGND VPWR VPWR _04842_ sky130_fd_sc_hd__or2_2
X_05069_ tanh_inst.divider.y_\[7\] VGND VGND VPWR VPWR _04793_ sky130_fd_sc_hd__inv_2
XFILLER_0_110_292 VGND VGND VPWR VPWR sky130_fd_sc_hd__fill_2
X_09946_ _04663_ _04662_ VGND VGND VPWR VPWR _04664_ sky130_fd_sc_hd__and2b_2
XFILLER_0_99_305 VPWR VGND VPWR VGND sky130_ef_sc_hd__decap_12
X_09877_ _04595_ _04596_ VGND VGND VPWR VPWR _04597_ sky130_fd_sc_hd__nor2_2
XPHY_EDGE_ROW_79_Right_79 VGND VGND VPWR VPWR sky130_fd_sc_hd__decap_3
X_08828_ tanh_inst.divider.x\[-12\] tanh_inst.divider.x\[-11\] tanh_inst.divider.x\[-10\]
+ tanh_inst.divider.x\[-9\] tanh_inst.LOOKUP.index\[0\] tanh_inst.LOOKUP.index\[1\]
+ VGND VGND VPWR VPWR _03574_ sky130_fd_sc_hd__mux4_2
XFILLER_0_68_714 VGND VGND VPWR VPWR sky130_fd_sc_hd__fill_1
X_08759_ _00970_ _03507_ VGND VGND VPWR VPWR _00294_ sky130_fd_sc_hd__nor2_2
XFILLER_0_95_511 VGND VGND VPWR VPWR sky130_fd_sc_hd__fill_1
XFILLER_0_95_577 VGND VGND VPWR VPWR sky130_fd_sc_hd__fill_1
XFILLER_0_95_555 VGND VGND VPWR VPWR sky130_fd_sc_hd__decap_4
XTAP_TAPCELL_ROW_101_1520 VGND VPWR sky130_fd_sc_hd__tapvpwrvgnd_1
XFILLER_0_82_249 VGND VGND VPWR VPWR sky130_fd_sc_hd__decap_3
XTAP_TAPCELL_ROW_11_403 VGND VPWR sky130_fd_sc_hd__tapvpwrvgnd_1
XFILLER_0_23_305 VPWR VGND VPWR VGND sky130_ef_sc_hd__decap_12
XFILLER_0_51_614 VGND VGND VPWR VPWR sky130_fd_sc_hd__fill_2
XFILLER_0_106_565 VGND VGND VPWR VPWR sky130_fd_sc_hd__decap_6
XPHY_EDGE_ROW_88_Right_88 VGND VGND VPWR VPWR sky130_fd_sc_hd__decap_3
XFILLER_0_63_485 VPWR VGND VPWR VGND sky130_ef_sc_hd__decap_12
XFILLER_0_35_187 VGND VGND VPWR VPWR sky130_fd_sc_hd__fill_2
XFILLER_0_50_113 VGND VGND VPWR VPWR sky130_fd_sc_hd__decap_4
XFILLER_0_121_502 VGND VGND VPWR VPWR sky130_fd_sc_hd__fill_2
XFILLER_0_121_557 VGND VGND VPWR VPWR sky130_fd_sc_hd__decap_3
XTAP_TAPCELL_ROW_112_1660 VGND VPWR sky130_fd_sc_hd__tapvpwrvgnd_1
XPHY_EDGE_ROW_97_Right_97 VGND VGND VPWR VPWR sky130_fd_sc_hd__decap_3
X_10017_ _02019_ _04731_ _04732_ _02015_ VGND VGND VPWR VPWR _04733_ sky130_fd_sc_hd__a211o_2
XFILLER_0_92_29 VPWR VGND VPWR VGND sky130_ef_sc_hd__decap_12
XTAP_TAPCELL_ROW_19_503 VGND VPWR sky130_fd_sc_hd__tapvpwrvgnd_1
XTAP_TAPCELL_ROW_47_845 VGND VPWR sky130_fd_sc_hd__tapvpwrvgnd_1
XFILLER_0_98_382 VPWR VGND VPWR VGND sky130_ef_sc_hd__decap_12
XFILLER_0_86_544 VGND VGND VPWR VPWR sky130_fd_sc_hd__fill_1
XTAP_TAPCELL_ROW_63_1047 VGND VPWR sky130_fd_sc_hd__tapvpwrvgnd_1
XFILLER_0_116_307 VGND VGND VPWR VPWR sky130_fd_sc_hd__fill_1
XFILLER_0_54_474 VGND VGND VPWR VPWR sky130_fd_sc_hd__fill_2
XFILLER_0_26_165 VGND VGND VPWR VPWR sky130_fd_sc_hd__fill_2
XFILLER_0_42_603 VGND VGND VPWR VPWR sky130_fd_sc_hd__decap_4
X_06110_ tanh_inst.divider.i\[2\] tanh_inst.divider.i\[1\] tanh_inst.divider.i\[0\]
+ VGND VGND VPWR VPWR _01057_ sky130_fd_sc_hd__or3_2
X_07090_ _01916_ _01917_ VGND VGND VPWR VPWR _01918_ sky130_fd_sc_hd__nor2_2
XFILLER_0_41_113 VPWR VGND VPWR VGND sky130_ef_sc_hd__decap_12
X_06041_ _00978_ _00985_ _00979_ VGND VGND VPWR VPWR _00993_ sky130_fd_sc_hd__a21oi_2
XFILLER_0_100_708 VPWR VGND VPWR VGND sky130_ef_sc_hd__decap_12
XFILLER_0_22_371 VGND VGND VPWR VPWR sky130_fd_sc_hd__decap_3
XFILLER_0_50_680 VGND VGND VPWR VPWR sky130_fd_sc_hd__fill_1
XFILLER_0_10_533 VGND VGND VPWR VPWR sky130_fd_sc_hd__decap_4
XFILLER_0_10_522 VGND VGND VPWR VPWR sky130_fd_sc_hd__decap_8
X_07992_ tanh_inst.divider.x\[-10\] _02786_ VGND VGND VPWR VPWR _02788_ sky130_fd_sc_hd__nor2_2
XTAP_TAPCELL_ROW_74_1187 VGND VPWR sky130_fd_sc_hd__tapvpwrvgnd_1
X_09800_ _04520_ _04521_ VGND VGND VPWR VPWR _04522_ sky130_fd_sc_hd__nor2_2
X_06943_ tanh_inst.divider.z_\[-22\] _01785_ VGND VGND VPWR VPWR _01787_ sky130_fd_sc_hd__xnor2_2
XFILLER_0_10_599 VGND VGND VPWR VPWR sky130_fd_sc_hd__fill_2
XFILLER_0_5_55 VGND VGND VPWR VPWR sky130_fd_sc_hd__fill_1
X_09731_ tanh_inst.divider.y\[-2\] _04447_ VGND VGND VPWR VPWR _04455_ sky130_fd_sc_hd__nor2_2
X_06874_ tanh_inst.z_\[6\] _01667_ VGND VGND VPWR VPWR _01759_ sky130_fd_sc_hd__xnor2_2
X_09662_ tanh_inst.divider.y\[-4\] _04378_ VGND VGND VPWR VPWR _04388_ sky130_fd_sc_hd__and2_2
XFILLER_0_96_319 VGND VGND VPWR VPWR sky130_fd_sc_hd__decap_8
X_09593_ _04319_ _04320_ VGND VGND VPWR VPWR _04321_ sky130_fd_sc_hd__nor2_2
X_05825_ _00779_ _00781_ _00778_ VGND VGND VPWR VPWR _00793_ sky130_fd_sc_hd__a21bo_2
X_08613_ tanh_inst.divider.x\[4\] _03393_ VGND VGND VPWR VPWR _03395_ sky130_fd_sc_hd__nand2_2
XFILLER_0_89_393 VGND VGND VPWR VPWR sky130_fd_sc_hd__decap_4
X_08544_ tanh_inst.divider.x\[3\] _03326_ VGND VGND VPWR VPWR _03327_ sky130_fd_sc_hd__and2_2
XFILLER_0_10_3 VPWR VGND VPWR VGND sky130_ef_sc_hd__decap_12
X_05756_ mac_inst.i\[2\] _04944_ _00676_ _00717_ VGND VGND VPWR VPWR _00729_ sky130_fd_sc_hd__or4_2
XFILLER_0_49_202 VGND VGND VPWR VPWR sky130_fd_sc_hd__fill_1
XFILLER_0_49_246 VGND VGND VPWR VPWR sky130_fd_sc_hd__decap_8
X_05687_ _04955_ _04975_ _00664_ VGND VGND VPWR VPWR _00665_ sky130_fd_sc_hd__or3_2
X_08475_ _03257_ _03259_ VGND VGND VPWR VPWR _03260_ sky130_fd_sc_hd__nor2_2
XFILLER_0_49_279 VGND VGND VPWR VPWR sky130_fd_sc_hd__fill_1
XFILLER_0_119_167 VGND VGND VPWR VPWR sky130_fd_sc_hd__fill_1
X_07426_ tanh_inst.divider.y\[-22\] tanh_inst.divider.x\[-22\] VGND VGND VPWR VPWR
+ _02234_ sky130_fd_sc_hd__or2_2
XFILLER_0_18_622 VGND VGND VPWR VPWR sky130_fd_sc_hd__fill_2
XFILLER_0_18_633 VGND VGND VPWR VPWR sky130_fd_sc_hd__decap_4
X_07357_ tanh_inst.divider.y\[-23\] tanh_inst.divider.x\[-23\] VGND VGND VPWR VPWR
+ _02166_ sky130_fd_sc_hd__xor2_2
X_06308_ tanh_inst.divider.y_\[-14\] _01232_ _01233_ _01235_ VGND VGND VPWR VPWR _01244_
+ sky130_fd_sc_hd__a22o_2
XFILLER_0_72_260 VPWR VGND VPWR VGND sky130_ef_sc_hd__decap_12
XFILLER_0_32_102 VGND VGND VPWR VPWR sky130_fd_sc_hd__fill_1
XFILLER_0_103_502 VGND VGND VPWR VPWR sky130_fd_sc_hd__fill_2
X_07288_ _02078_ _02097_ _02023_ VGND VGND VPWR VPWR _02098_ sky130_fd_sc_hd__mux2_1
X_09027_ _01525_ _03769_ _03766_ _03765_ VGND VGND VPWR VPWR _03770_ sky130_fd_sc_hd__o211a_2
X_06239_ _01146_ _01147_ _01163_ _04793_ VGND VGND VPWR VPWR _01180_ sky130_fd_sc_hd__o31a_2
XFILLER_0_103_557 VGND VGND VPWR VPWR sky130_fd_sc_hd__decap_3
XFILLER_0_60_477 VPWR VGND VPWR VGND sky130_ef_sc_hd__decap_12
XFILLER_0_32_179 VGND VGND VPWR VPWR sky130_fd_sc_hd__fill_1
XFILLER_0_40_190 VGND VGND VPWR VPWR sky130_fd_sc_hd__fill_1
X_09929_ _04633_ _04645_ _04646_ VGND VGND VPWR VPWR _04647_ sky130_fd_sc_hd__nor3_2
XFILLER_0_68_533 VPWR VGND VPWR VGND sky130_ef_sc_hd__decap_12
XTAP_TAPCELL_ROW_44_815 VGND VPWR sky130_fd_sc_hd__tapvpwrvgnd_1
XFILLER_0_55_216 VGND VGND VPWR VPWR sky130_fd_sc_hd__fill_1
XFILLER_0_83_558 VGND VGND VPWR VPWR sky130_fd_sc_hd__fill_2
XTAP_TAPCELL_ROW_24_561 VGND VPWR sky130_fd_sc_hd__tapvpwrvgnd_1
XFILLER_0_102_27 VGND VGND VPWR VPWR sky130_fd_sc_hd__fill_1
XFILLER_0_23_113 VPWR VGND VPWR VGND sky130_ef_sc_hd__decap_12
XFILLER_0_51_400 VGND VGND VPWR VPWR sky130_fd_sc_hd__decap_8
XFILLER_0_11_69 VPWR VGND VPWR VGND sky130_ef_sc_hd__decap_12
XFILLER_0_121_321 VPWR VGND VPWR VGND sky130_ef_sc_hd__decap_12
XFILLER_0_121_365 VPWR VGND VPWR VGND sky130_ef_sc_hd__decap_12
XFILLER_0_59_522 VGND VGND VPWR VPWR sky130_fd_sc_hd__fill_1
X_05610_ _00591_ _00596_ _00595_ _00594_ VGND VGND VPWR VPWR _00597_ sky130_fd_sc_hd__o2bb2a_2
X_06590_ _01483_ _01485_ _01486_ tanh_inst.z_\[7\] VGND VGND VPWR VPWR _01504_ sky130_fd_sc_hd__a31o_2
X_05541_ mac_inst.z\[31\] _00521_ _00525_ _00533_ VGND VGND VPWR VPWR _00535_ sky130_fd_sc_hd__o211a_2
X_05472_ _00469_ _00471_ VGND VGND VPWR VPWR _00472_ sky130_fd_sc_hd__nor2_2
X_08260_ tanh_inst.divider.y\[-5\] tanh_inst.divider.x\[-5\] _03049_ VGND VGND VPWR
+ VPWR _03050_ sky130_fd_sc_hd__a21oi_2
XFILLER_0_46_238 VPWR VGND VPWR VGND sky130_ef_sc_hd__decap_12
X_07211_ tanh_inst.LOOKUP.index\[2\] _01512_ VGND VGND VPWR VPWR _02021_ sky130_fd_sc_hd__nor2_2
X_08191_ _02978_ _02982_ _04791_ VGND VGND VPWR VPWR _02983_ sky130_fd_sc_hd__o21a_2
X_07142_ _01088_ _00188_ _01964_ _01059_ VGND VGND VPWR VPWR _00220_ sky130_fd_sc_hd__o22a_2
XFILLER_0_6_357 VGND VGND VPWR VPWR sky130_fd_sc_hd__decap_6
X_07073_ tanh_inst.divider.z_\[-8\] _01895_ _01902_ VGND VGND VPWR VPWR _01903_ sky130_fd_sc_hd__and3_2
XTAP_TAPCELL_ROW_76_1216 VGND VPWR sky130_fd_sc_hd__tapvpwrvgnd_1
XFILLER_0_42_477 VPWR VGND VPWR VGND sky130_ef_sc_hd__decap_12
XFILLER_0_112_365 VGND VGND VPWR VPWR sky130_fd_sc_hd__decap_4
X_06024_ _00772_ _00846_ _00971_ _04795_ VGND VGND VPWR VPWR _00977_ sky130_fd_sc_hd__a22o_2
XFILLER_0_77_62 VPWR VGND VPWR VGND sky130_ef_sc_hd__decap_12
XFILLER_0_58_3 VGND VGND VPWR VPWR sky130_fd_sc_hd__fill_1
XFILLER_0_10_363 VGND VGND VPWR VPWR sky130_fd_sc_hd__fill_1
X_07975_ _02760_ _02761_ _02771_ tanh_inst.z_\[7\] VGND VGND VPWR VPWR _02772_ sky130_fd_sc_hd__o2bb2a_2
X_06926_ _01057_ _01058_ VGND VGND VPWR VPWR _01772_ sky130_fd_sc_hd__nor2_2
X_09714_ _04436_ _04437_ VGND VGND VPWR VPWR _04438_ sky130_fd_sc_hd__xnor2_2
X_06857_ tanh_inst.z_\[4\] _01667_ VGND VGND VPWR VPWR _01744_ sky130_fd_sc_hd__and2_2
X_09645_ _04370_ VGND VGND VPWR VPWR _04371_ sky130_fd_sc_hd__inv_2
XTAP_TAPCELL_ROW_87_1345 VGND VPWR sky130_fd_sc_hd__tapvpwrvgnd_1
X_05808_ mac_inst.z\[31\] _00776_ VGND VGND VPWR VPWR _00777_ sky130_fd_sc_hd__or2_2
XTAP_TAPCELL_ROW_2_289 VGND VPWR sky130_fd_sc_hd__tapvpwrvgnd_1
X_06788_ tanh_inst.z_\[-5\] _01683_ VGND VGND VPWR VPWR _01684_ sky130_fd_sc_hd__xnor2_2
X_09576_ _04236_ _04303_ _04292_ VGND VGND VPWR VPWR _04304_ sky130_fd_sc_hd__o21a_2
XFILLER_0_92_300 VGND VGND VPWR VPWR sky130_fd_sc_hd__fill_2
XFILLER_0_77_374 VPWR VGND VPWR VGND sky130_ef_sc_hd__decap_12
X_05739_ _00712_ _00713_ VGND VGND VPWR VPWR _00714_ sky130_fd_sc_hd__and2_2
X_08527_ _03309_ _03310_ VGND VGND VPWR VPWR _03311_ sky130_fd_sc_hd__or2_2
XFILLER_0_92_333 VGND VGND VPWR VPWR sky130_fd_sc_hd__decap_6
X_08458_ tanh_inst.divider.x\[0\] _03243_ VGND VGND VPWR VPWR _03244_ sky130_fd_sc_hd__nand2_2
X_07409_ _02025_ _02213_ _02215_ _02022_ VGND VGND VPWR VPWR _02217_ sky130_fd_sc_hd__o211ai_2
XFILLER_0_65_569 VGND VGND VPWR VPWR sky130_fd_sc_hd__fill_1
XTAP_TAPCELL_ROW_21_520 VGND VPWR sky130_fd_sc_hd__tapvpwrvgnd_1
XFILLER_0_52_208 VGND VGND VPWR VPWR sky130_fd_sc_hd__fill_1
X_08389_ _03174_ _03175_ VGND VGND VPWR VPWR _03176_ sky130_fd_sc_hd__or2_2
X_10420_ clknet_leaf_37_clk _00277_ _00000_ VGND VGND VPWR VPWR mac_inst.i\[12\] sky130_fd_sc_hd__dfrtp_2
XFILLER_0_60_230 VGND VGND VPWR VPWR sky130_fd_sc_hd__decap_3
XFILLER_0_115_181 VGND VGND VPWR VPWR sky130_fd_sc_hd__fill_2
XTAP_TAPCELL_ROW_98_1485 VGND VPWR sky130_fd_sc_hd__tapvpwrvgnd_1
X_10351_ clknet_leaf_20_clk _00208_ VGND VGND VPWR VPWR tanh_inst.divider.z_\[-13\]
+ sky130_fd_sc_hd__dfxtp_2
XFILLER_0_21_617 VGND VGND VPWR VPWR sky130_fd_sc_hd__decap_4
XFILLER_0_103_365 VGND VGND VPWR VPWR sky130_fd_sc_hd__fill_2
XFILLER_0_103_354 VGND VGND VPWR VPWR sky130_fd_sc_hd__decap_4
XFILLER_0_14_680 VGND VGND VPWR VPWR sky130_fd_sc_hd__decap_6
XFILLER_0_33_499 VGND VGND VPWR VPWR sky130_fd_sc_hd__decap_4
X_10282_ clknet_leaf_30_clk _00139_ VGND VGND VPWR VPWR tanh_inst.z_\[-13\] sky130_fd_sc_hd__dfxtp_2
XTAP_TAPCELL_ROW_29_620 VGND VPWR sky130_fd_sc_hd__tapvpwrvgnd_1
XTAP_TAPCELL_ROW_57_973 VGND VPWR sky130_fd_sc_hd__tapvpwrvgnd_1
XFILLER_0_68_363 VGND VGND VPWR VPWR sky130_fd_sc_hd__fill_1
XFILLER_0_113_15 VPWR VGND VPWR VGND sky130_ef_sc_hd__decap_12
XFILLER_0_95_193 VGND VGND VPWR VPWR sky130_fd_sc_hd__decap_4
XFILLER_0_83_322 VPWR VGND VPWR VGND sky130_ef_sc_hd__decap_12
XTAP_TAPCELL_ROW_60_1006 VGND VPWR sky130_fd_sc_hd__tapvpwrvgnd_1
XTAP_TAPCELL_ROW_60_1017 VGND VPWR sky130_fd_sc_hd__tapvpwrvgnd_1
XFILLER_0_24_400 VGND VGND VPWR VPWR sky130_fd_sc_hd__fill_1
XFILLER_0_36_260 VGND VGND VPWR VPWR sky130_fd_sc_hd__decap_8
XFILLER_0_3_305 VPWR VGND VPWR VGND sky130_ef_sc_hd__decap_12
XFILLER_0_11_105 VGND VGND VPWR VPWR sky130_fd_sc_hd__decap_6
XFILLER_0_3_349 VPWR VGND VPWR VGND sky130_ef_sc_hd__decap_12
XFILLER_0_11_149 VPWR VGND VPWR VGND sky130_ef_sc_hd__decap_12
XFILLER_0_20_694 VGND VGND VPWR VPWR sky130_fd_sc_hd__decap_6
XTAP_TAPCELL_ROW_71_1146 VGND VPWR sky130_fd_sc_hd__tapvpwrvgnd_1
X_07760_ _02555_ _02558_ _02559_ tanh_inst.z_\[7\] VGND VGND VPWR VPWR _02562_ sky130_fd_sc_hd__a31o_2
X_06711_ tanh_inst.z_\[-13\] _01614_ VGND VGND VPWR VPWR _01615_ sky130_fd_sc_hd__and2_2
X_07691_ tanh_inst.divider.y\[-17\] _02493_ VGND VGND VPWR VPWR _02494_ sky130_fd_sc_hd__xnor2_2
X_09430_ _04161_ VGND VGND VPWR VPWR _04162_ sky130_fd_sc_hd__inv_2
XFILLER_0_78_138 VGND VGND VPWR VPWR sky130_fd_sc_hd__fill_2
X_06642_ _01551_ _01552_ VGND VGND VPWR VPWR _01554_ sky130_fd_sc_hd__or2_2
X_09361_ _04093_ _04094_ VGND VGND VPWR VPWR _04095_ sky130_fd_sc_hd__and2b_2
XFILLER_0_87_683 VPWR VGND VPWR VGND sky130_ef_sc_hd__decap_12
X_06573_ tanh_inst.z_\[-24\] _01487_ VGND VGND VPWR VPWR _01488_ sky130_fd_sc_hd__or2_2
XFILLER_0_19_205 VPWR VGND VPWR VGND sky130_ef_sc_hd__decap_12
X_09292_ _04027_ _04026_ VGND VGND VPWR VPWR _04028_ sky130_fd_sc_hd__and2b_2
XFILLER_0_74_333 VGND VGND VPWR VPWR sky130_fd_sc_hd__decap_3
X_08312_ _03099_ _03100_ VGND VGND VPWR VPWR _03101_ sky130_fd_sc_hd__nand2_2
X_05524_ _00501_ _00507_ VGND VGND VPWR VPWR _00520_ sky130_fd_sc_hd__nand2_2
XFILLER_0_117_402 VPWR VGND VPWR VGND sky130_ef_sc_hd__decap_12
XTAP_TAPCELL_ROW_82_1286 VGND VPWR sky130_fd_sc_hd__tapvpwrvgnd_1
XFILLER_0_19_249 VPWR VGND VPWR VGND sky130_ef_sc_hd__decap_12
X_08243_ tanh_inst.divider.y\[-4\] _03031_ VGND VGND VPWR VPWR _03033_ sky130_fd_sc_hd__and2_2
XFILLER_0_6_121 VPWR VGND VPWR VGND sky130_ef_sc_hd__decap_12
XFILLER_0_15_411 VPWR VGND VPWR VGND sky130_ef_sc_hd__decap_12
X_05455_ _00453_ _00455_ VGND VGND VPWR VPWR _00456_ sky130_fd_sc_hd__xnor2_2
XFILLER_0_6_165 VPWR VGND VPWR VGND sky130_ef_sc_hd__decap_12
XFILLER_0_27_293 VGND VGND VPWR VPWR sky130_fd_sc_hd__decap_6
X_05386_ _04911_ _00391_ _00387_ _05020_ VGND VGND VPWR VPWR _00392_ sky130_fd_sc_hd__a211o_2
X_08174_ _02965_ VGND VGND VPWR VPWR _02966_ sky130_fd_sc_hd__inv_2
X_07125_ _01031_ _01818_ _01942_ VGND VGND VPWR VPWR _01949_ sky130_fd_sc_hd__o21a_2
X_07056_ _01879_ _01885_ tanh_inst.divider.z_\[-10\] VGND VGND VPWR VPWR _01888_ sky130_fd_sc_hd__a21oi_2
XFILLER_0_113_685 VGND VGND VPWR VPWR sky130_fd_sc_hd__fill_2
X_06007_ mac_inst.i\[11\] _00960_ VGND VGND VPWR VPWR _00961_ sky130_fd_sc_hd__nand2_2
XTAP_TAPCELL_ROW_7_348 VGND VPWR sky130_fd_sc_hd__tapvpwrvgnd_1
X_07958_ _02753_ _02754_ VGND VGND VPWR VPWR _02755_ sky130_fd_sc_hd__nand2_2
X_06909_ tanh_inst.div_en tanh_inst.divider.z_\[-9\] VGND VGND VPWR VPWR _00180_ sky130_fd_sc_hd__and2b_2
X_07889_ _02685_ _02686_ VGND VGND VPWR VPWR _02688_ sky130_fd_sc_hd__or2_2
X_09628_ _04163_ _04229_ _04354_ tanh_inst.z_\[7\] VGND VGND VPWR VPWR _04355_ sky130_fd_sc_hd__a31o_2
XTAP_TAPCELL_ROW_54_943 VGND VPWR sky130_fd_sc_hd__tapvpwrvgnd_1
XTAP_TAPCELL_ROW_54_932 VGND VPWR sky130_fd_sc_hd__tapvpwrvgnd_1
X_09559_ tanh_inst.LOOKUP.index\[4\] _03637_ _04213_ VGND VGND VPWR VPWR _04288_ sky130_fd_sc_hd__o21ai_2
XFILLER_0_93_642 VPWR VGND VPWR VGND sky130_ef_sc_hd__decap_12
XFILLER_0_78_694 VGND VGND VPWR VPWR sky130_fd_sc_hd__fill_1
XFILLER_0_65_311 VPWR VGND VPWR VGND sky130_ef_sc_hd__decap_12
XFILLER_0_108_446 VGND VGND VPWR VPWR sky130_fd_sc_hd__decap_6
XFILLER_0_80_325 VGND VGND VPWR VPWR sky130_fd_sc_hd__decap_8
XFILLER_0_53_517 VGND VGND VPWR VPWR sky130_fd_sc_hd__decap_4
XFILLER_0_104_641 VGND VGND VPWR VPWR sky130_fd_sc_hd__decap_3
X_10403_ clknet_leaf_43_clk _00260_ VGND VGND VPWR VPWR tanh_inst.divider.x\[3\] sky130_fd_sc_hd__dfxtp_2
X_10334_ clknet_leaf_17_clk _00191_ VGND VGND VPWR VPWR tanh_out[26] sky130_fd_sc_hd__dfxtp_2
XFILLER_0_103_151 VPWR VGND VPWR VGND sky130_ef_sc_hd__decap_12
XFILLER_0_21_447 VGND VGND VPWR VPWR sky130_fd_sc_hd__fill_1
XFILLER_0_103_195 VPWR VGND VPWR VGND sky130_ef_sc_hd__decap_12
X_10265_ clknet_leaf_31_clk mac_inst.x\[27\] _00000_ VGND VGND VPWR VPWR mac_x_out[27]
+ sky130_fd_sc_hd__dfrtp_2
X_10196_ x_in[22] _00000_ VGND VGND VPWR VPWR mac_inst.x\[22\] sky130_fd_sc_hd__dlxtn_1
XFILLER_0_108_15 VPWR VGND VPWR VGND sky130_ef_sc_hd__decap_12
XTAP_TAPCELL_ROW_109_1621 VGND VPWR sky130_fd_sc_hd__tapvpwrvgnd_1
XFILLER_0_17_57 VPWR VGND VPWR VGND sky130_ef_sc_hd__decap_12
XFILLER_0_69_694 VGND VGND VPWR VPWR sky130_fd_sc_hd__fill_2
XFILLER_0_8_419 VGND VGND VPWR VPWR sky130_fd_sc_hd__fill_1
XFILLER_0_83_141 VPWR VGND VPWR VGND sky130_ef_sc_hd__decap_12
XTAP_TAPCELL_ROW_32_659 VGND VPWR sky130_fd_sc_hd__tapvpwrvgnd_1
XFILLER_0_116_3 VPWR VGND VPWR VGND sky130_ef_sc_hd__decap_12
X_05240_ _04850_ _04939_ VGND VGND VPWR VPWR _04941_ sky130_fd_sc_hd__nor2_2
XFILLER_0_3_113 VPWR VGND VPWR VGND sky130_ef_sc_hd__decap_12
X_05171_ mac_inst.x\[29\] _04852_ _04853_ _04783_ VGND VGND VPWR VPWR _04875_ sky130_fd_sc_hd__a211o_2
X_08930_ _02023_ _03668_ _03670_ _03673_ _02052_ VGND VGND VPWR VPWR _03674_ sky130_fd_sc_hd__o221a_2
XFILLER_0_58_42 VGND VGND VPWR VPWR sky130_fd_sc_hd__decap_6
X_08861_ _02025_ _03605_ _03604_ VGND VGND VPWR VPWR _03606_ sky130_fd_sc_hd__a21o_2
XFILLER_0_58_97 VGND VGND VPWR VPWR sky130_fd_sc_hd__fill_1
X_07812_ _02023_ _02216_ _02488_ VGND VGND VPWR VPWR _02612_ sky130_fd_sc_hd__a21boi_2
XTAP_TAPCELL_ROW_4_318 VGND VPWR sky130_fd_sc_hd__tapvpwrvgnd_1
XTAP_TAPCELL_ROW_4_307 VGND VPWR sky130_fd_sc_hd__tapvpwrvgnd_1
X_08792_ _02025_ _03532_ _03537_ _02023_ VGND VGND VPWR VPWR _03538_ sky130_fd_sc_hd__o211a_2
X_07743_ _02542_ _02544_ tanh_inst.z_\[7\] VGND VGND VPWR VPWR _02545_ sky130_fd_sc_hd__o21ai_2
XTAP_TAPCELL_ROW_84_1315 VGND VPWR sky130_fd_sc_hd__tapvpwrvgnd_1
XFILLER_0_79_447 VGND VGND VPWR VPWR sky130_fd_sc_hd__fill_1
X_07674_ _02476_ _02477_ VGND VGND VPWR VPWR _02478_ sky130_fd_sc_hd__and2b_2
X_09413_ _04144_ _04145_ VGND VGND VPWR VPWR _04146_ sky130_fd_sc_hd__xnor2_2
X_06625_ tanh_inst.z_\[-22\] _01537_ VGND VGND VPWR VPWR _01538_ sky130_fd_sc_hd__nand2_2
XTAP_TAPCELL_ROW_51_902 VGND VPWR sky130_fd_sc_hd__tapvpwrvgnd_1
X_06556_ tanh_inst.LOOKUP.index\[4\] tanh_inst.LOOKUP.index\[3\] tanh_inst.LOOKUP.index\[2\]
+ VGND VGND VPWR VPWR _01471_ sky130_fd_sc_hd__nand3_2
X_09344_ _04046_ _04047_ tanh_inst.z_\[7\] VGND VGND VPWR VPWR _04079_ sky130_fd_sc_hd__a21o_2
X_06487_ _01089_ _01408_ VGND VGND VPWR VPWR _01409_ sky130_fd_sc_hd__nor2_2
XFILLER_0_90_623 VGND VGND VPWR VPWR sky130_fd_sc_hd__decap_8
XFILLER_0_90_612 VGND VGND VPWR VPWR sky130_fd_sc_hd__decap_4
X_09275_ tanh_inst.divider.y\[-15\] _04010_ VGND VGND VPWR VPWR _04012_ sky130_fd_sc_hd__nor2_2
XFILLER_0_35_517 VPWR VGND VPWR VGND sky130_ef_sc_hd__decap_12
X_05507_ _00461_ _00474_ _00475_ _00485_ _00492_ VGND VGND VPWR VPWR _00504_ sky130_fd_sc_hd__a2111o_2
XFILLER_0_117_276 VGND VGND VPWR VPWR sky130_fd_sc_hd__decap_4
XFILLER_0_62_358 VGND VGND VPWR VPWR sky130_fd_sc_hd__decap_6
X_05438_ mac_inst.i\[3\] _04986_ _00439_ _04912_ VGND VGND VPWR VPWR _00440_ sky130_fd_sc_hd__a211o_2
X_08226_ _04791_ _03007_ _03015_ _03016_ VGND VGND VPWR VPWR _03017_ sky130_fd_sc_hd__a22o_2
XFILLER_0_105_449 VGND VGND VPWR VPWR sky130_fd_sc_hd__fill_1
XFILLER_0_43_561 VGND VGND VPWR VPWR sky130_fd_sc_hd__decap_6
X_08157_ _02947_ _02949_ VGND VGND VPWR VPWR _02950_ sky130_fd_sc_hd__nand2_2
X_07108_ _01924_ _01932_ tanh_inst.divider.z_\[-4\] VGND VGND VPWR VPWR _01934_ sky130_fd_sc_hd__a21o_2
XTAP_TAPCELL_ROW_95_1455 VGND VPWR sky130_fd_sc_hd__tapvpwrvgnd_1
XTAP_TAPCELL_ROW_95_1444 VGND VPWR sky130_fd_sc_hd__tapvpwrvgnd_1
XFILLER_0_70_391 VGND VGND VPWR VPWR sky130_fd_sc_hd__decap_4
X_05369_ _04911_ _00375_ _00373_ _05020_ VGND VGND VPWR VPWR _00376_ sky130_fd_sc_hd__a211o_2
XFILLER_0_30_211 VGND VGND VPWR VPWR sky130_fd_sc_hd__decap_3
XFILLER_0_113_471 VPWR VGND VPWR VGND sky130_ef_sc_hd__decap_12
X_08088_ _02801_ _02849_ _02848_ VGND VGND VPWR VPWR _02882_ sky130_fd_sc_hd__a21bo_2
XFILLER_0_100_132 VGND VGND VPWR VPWR sky130_fd_sc_hd__decap_8
X_07039_ _01850_ _01856_ _01857_ _01865_ _01854_ VGND VGND VPWR VPWR _01873_ sky130_fd_sc_hd__a311o_2
X_10050_ rst VGND VGND VPWR VPWR _00069_ sky130_fd_sc_hd__inv_2
XFILLER_0_11_480 VGND VGND VPWR VPWR sky130_fd_sc_hd__decap_8
XFILLER_0_98_701 VGND VGND VPWR VPWR sky130_fd_sc_hd__decap_6
XFILLER_0_97_233 VGND VGND VPWR VPWR sky130_fd_sc_hd__fill_2
XFILLER_0_97_288 VGND VGND VPWR VPWR sky130_fd_sc_hd__decap_6
XTAP_TAPCELL_ROW_104_1562 VGND VPWR sky130_fd_sc_hd__tapvpwrvgnd_1
XFILLER_0_38_333 VPWR VGND VPWR VGND sky130_ef_sc_hd__decap_12
XFILLER_0_38_377 VPWR VGND VPWR VGND sky130_ef_sc_hd__decap_12
XFILLER_0_53_314 VGND VGND VPWR VPWR sky130_fd_sc_hd__decap_4
XFILLER_0_81_667 VGND VGND VPWR VPWR sky130_fd_sc_hd__decap_4
XFILLER_0_80_177 VGND VGND VPWR VPWR sky130_fd_sc_hd__fill_1
XFILLER_0_79_19 VPWR VGND VPWR VGND sky130_ef_sc_hd__decap_12
XFILLER_0_53_369 VGND VGND VPWR VPWR sky130_fd_sc_hd__decap_8
XFILLER_0_110_27 VGND VGND VPWR VPWR sky130_fd_sc_hd__fill_1
XFILLER_0_61_391 VGND VGND VPWR VPWR sky130_fd_sc_hd__fill_1
X_10317_ clknet_leaf_16_clk _00174_ VGND VGND VPWR VPWR tanh_out[9] sky130_fd_sc_hd__dfxtp_2
X_10248_ clknet_leaf_32_clk mac_inst.x\[10\] _00000_ VGND VGND VPWR VPWR mac_x_out[10]
+ sky130_fd_sc_hd__dfrtp_2
XFILLER_0_119_69 VPWR VGND VPWR VGND sky130_ef_sc_hd__decap_12
X_10179_ x_in[5] _00000_ VGND VGND VPWR VPWR mac_inst.x\[5\] sky130_fd_sc_hd__dlxtn_1
XTAP_TAPCELL_ROW_37_729 VGND VPWR sky130_fd_sc_hd__tapvpwrvgnd_1
X_06410_ _01336_ _01337_ VGND VGND VPWR VPWR _01338_ sky130_fd_sc_hd__nand2b_2
XFILLER_0_88_288 VGND VGND VPWR VPWR sky130_fd_sc_hd__decap_3
XFILLER_0_69_480 VPWR VGND VPWR VGND sky130_ef_sc_hd__decap_12
X_07390_ tanh_inst.divider.x\[-24\] _02123_ VGND VGND VPWR VPWR _02199_ sky130_fd_sc_hd__nor2_2
XTAP_TAPCELL_ROW_66_1089 VGND VPWR sky130_fd_sc_hd__tapvpwrvgnd_1
XFILLER_0_57_664 VGND VGND VPWR VPWR sky130_fd_sc_hd__fill_1
XFILLER_0_56_141 VPWR VGND VPWR VGND sky130_ef_sc_hd__decap_12
XTAP_TAPCELL_ROW_17_475 VGND VPWR sky130_fd_sc_hd__tapvpwrvgnd_1
X_06341_ _01253_ _01261_ _01273_ VGND VGND VPWR VPWR _01275_ sky130_fd_sc_hd__a21oi_2
XFILLER_0_72_623 VPWR VGND VPWR VGND sky130_ef_sc_hd__decap_12
X_06272_ _01209_ _01210_ VGND VGND VPWR VPWR _01211_ sky130_fd_sc_hd__and2_2
XFILLER_0_115_703 VGND VGND VPWR VPWR sky130_fd_sc_hd__decap_4
X_09060_ _02359_ _03788_ VGND VGND VPWR VPWR _03802_ sky130_fd_sc_hd__nand2_2
X_08011_ _02805_ _02806_ _02802_ VGND VGND VPWR VPWR _02807_ sky130_fd_sc_hd__a21o_2
XFILLER_0_25_561 VGND VGND VPWR VPWR sky130_fd_sc_hd__decap_6
X_05223_ _04925_ _04926_ VGND VGND VPWR VPWR _04927_ sky130_fd_sc_hd__and2_2
XFILLER_0_114_246 VGND VGND VPWR VPWR sky130_fd_sc_hd__decap_6
XFILLER_0_69_41 VGND VGND VPWR VPWR sky130_fd_sc_hd__decap_4
XFILLER_0_4_455 VGND VGND VPWR VPWR sky130_fd_sc_hd__fill_2
XFILLER_0_13_723 VGND VGND VPWR VPWR sky130_fd_sc_hd__fill_1
XFILLER_0_25_594 VGND VGND VPWR VPWR sky130_fd_sc_hd__decap_8
XFILLER_0_102_419 VGND VGND VPWR VPWR sky130_fd_sc_hd__fill_1
XFILLER_0_12_233 VPWR VGND VPWR VGND sky130_ef_sc_hd__decap_12
XFILLER_0_8_77 VGND VGND VPWR VPWR sky130_fd_sc_hd__decap_6
X_05154_ mac_inst.x\[19\] _04852_ _04853_ VGND VGND VPWR VPWR _04858_ sky130_fd_sc_hd__a21o_2
XFILLER_0_40_531 VGND VGND VPWR VPWR sky130_fd_sc_hd__fill_1
X_09962_ _03409_ _04678_ VGND VGND VPWR VPWR _04679_ sky130_fd_sc_hd__or2_2
XFILLER_0_12_277 VPWR VGND VPWR VGND sky130_ef_sc_hd__decap_12
X_05085_ tanh_counter\[6\] _04807_ VGND VGND VPWR VPWR _04808_ sky130_fd_sc_hd__and2_2
XFILLER_0_100_93 VGND VGND VPWR VPWR sky130_fd_sc_hd__decap_3
X_08913_ _03580_ _03657_ VGND VGND VPWR VPWR _03658_ sky130_fd_sc_hd__nor2_2
XTAP_TAPCELL_ROW_90_1385 VGND VPWR sky130_fd_sc_hd__tapvpwrvgnd_1
X_09893_ _03342_ _04611_ VGND VGND VPWR VPWR _04612_ sky130_fd_sc_hd__xor2_2
X_08844_ _03515_ _03526_ _04761_ VGND VGND VPWR VPWR _03589_ sky130_fd_sc_hd__mux2_1
X_08775_ _03515_ _03519_ _03520_ _03517_ _04760_ tanh_inst.LOOKUP.index\[0\] VGND
+ VGND VPWR VPWR _03521_ sky130_fd_sc_hd__mux4_2
X_05987_ _00926_ _00941_ VGND VGND VPWR VPWR _00942_ sky130_fd_sc_hd__and2_2
X_07726_ _02018_ _02523_ _02528_ _02015_ VGND VGND VPWR VPWR _02529_ sky130_fd_sc_hd__a211o_2
XFILLER_0_79_255 VGND VGND VPWR VPWR sky130_fd_sc_hd__fill_1
X_07657_ _02441_ _02459_ VGND VGND VPWR VPWR _02461_ sky130_fd_sc_hd__and2_2
X_07588_ tanh_inst.divider.x\[-19\] _02392_ VGND VGND VPWR VPWR _02393_ sky130_fd_sc_hd__and2_2
X_06608_ _01518_ _01520_ VGND VGND VPWR VPWR _01521_ sky130_fd_sc_hd__nand2_2
X_09327_ _04035_ _04041_ _04061_ VGND VGND VPWR VPWR _04062_ sky130_fd_sc_hd__nand3_2
X_06539_ _01455_ VGND VGND VPWR VPWR _01456_ sky130_fd_sc_hd__inv_2
XFILLER_0_118_563 VGND VGND VPWR VPWR sky130_fd_sc_hd__decap_3
XFILLER_0_90_442 VGND VGND VPWR VPWR sky130_fd_sc_hd__decap_6
X_09258_ _03969_ _03973_ _03993_ _04791_ VGND VGND VPWR VPWR _03995_ sky130_fd_sc_hd__o31a_2
XFILLER_0_105_202 VPWR VGND VPWR VGND sky130_ef_sc_hd__decap_12
XFILLER_0_90_475 VGND VGND VPWR VPWR sky130_fd_sc_hd__fill_1
XFILLER_0_62_166 VPWR VGND VPWR VGND sky130_ef_sc_hd__decap_12
XFILLER_0_7_293 VPWR VGND VPWR VGND sky130_ef_sc_hd__decap_12
XFILLER_0_16_550 VPWR VGND VPWR VGND sky130_ef_sc_hd__decap_12
X_09189_ _03882_ _03885_ VGND VGND VPWR VPWR _03928_ sky130_fd_sc_hd__nand2_2
XFILLER_0_31_520 VGND VGND VPWR VPWR sky130_fd_sc_hd__decap_3
X_08209_ tanh_inst.divider.y\[-5\] tanh_inst.divider.x\[-5\] VGND VGND VPWR VPWR _03000_
+ sky130_fd_sc_hd__xor2_2
XFILLER_0_50_317 VGND VGND VPWR VPWR sky130_fd_sc_hd__decap_6
XFILLER_0_43_391 VGND VGND VPWR VPWR sky130_fd_sc_hd__fill_1
XFILLER_0_31_597 VPWR VGND VPWR VGND sky130_ef_sc_hd__decap_12
X_10102_ clknet_leaf_32_clk _00119_ _00069_ VGND VGND VPWR VPWR mac_counter\[1\] sky130_fd_sc_hd__dfrtp_2
X_10033_ tanh_inst.divider.y\[7\] _02014_ _04742_ _04747_ _01470_ VGND VGND VPWR VPWR
+ _00328_ sky130_fd_sc_hd__o221a_2
XFILLER_0_58_406 VGND VGND VPWR VPWR sky130_fd_sc_hd__fill_1
XFILLER_0_105_27 VPWR VGND VPWR VGND sky130_ef_sc_hd__decap_12
XFILLER_0_85_225 VGND VGND VPWR VPWR sky130_fd_sc_hd__decap_3
XFILLER_0_85_203 VGND VGND VPWR VPWR sky130_fd_sc_hd__fill_1
XTAP_TAPCELL_ROW_14_434 VGND VPWR sky130_fd_sc_hd__tapvpwrvgnd_1
XFILLER_0_38_141 VGND VGND VPWR VPWR sky130_fd_sc_hd__fill_1
XFILLER_0_39_697 VGND VGND VPWR VPWR sky130_fd_sc_hd__fill_2
XFILLER_0_121_15 VPWR VGND VPWR VGND sky130_ef_sc_hd__decap_12
XTAP_TAPCELL_ROW_42_787 VGND VPWR sky130_fd_sc_hd__tapvpwrvgnd_1
XFILLER_0_53_133 VGND VGND VPWR VPWR sky130_fd_sc_hd__decap_3
XTAP_TAPCELL_ROW_117_1720 VGND VPWR sky130_fd_sc_hd__tapvpwrvgnd_1
XFILLER_0_41_328 VGND VGND VPWR VPWR sky130_fd_sc_hd__decap_8
XFILLER_0_53_177 VGND VGND VPWR VPWR sky130_fd_sc_hd__fill_1
XFILLER_0_39_11 VGND VGND VPWR VPWR sky130_fd_sc_hd__fill_1
XFILLER_0_22_597 VPWR VGND VPWR VGND sky130_ef_sc_hd__decap_12
XFILLER_0_39_55 VGND VGND VPWR VPWR sky130_fd_sc_hd__fill_1
X_06890_ tanh_inst.divider.i\[3\] _01060_ _01767_ VGND VGND VPWR VPWR _01770_ sky130_fd_sc_hd__and3_2
X_05910_ mac_inst.z\[17\] _00869_ VGND VGND VPWR VPWR _00872_ sky130_fd_sc_hd__nand2_2
X_05841_ _00755_ _00758_ _00769_ _00805_ VGND VGND VPWR VPWR _00808_ sky130_fd_sc_hd__or4_2
XTAP_TAPCELL_ROW_68_1118 VGND VPWR sky130_fd_sc_hd__tapvpwrvgnd_1
XTAP_TAPCELL_ROW_68_1107 VGND VPWR sky130_fd_sc_hd__tapvpwrvgnd_1
X_05772_ mac_inst.z\[7\] _00743_ VGND VGND VPWR VPWR _00744_ sky130_fd_sc_hd__nor2_2
X_08560_ _03326_ _03342_ VGND VGND VPWR VPWR _03343_ sky130_fd_sc_hd__xor2_2
XFILLER_0_76_225 VGND VGND VPWR VPWR sky130_fd_sc_hd__fill_1
X_07511_ _02109_ _02145_ _01476_ VGND VGND VPWR VPWR _02318_ sky130_fd_sc_hd__o21a_2
X_08491_ _04791_ _03190_ _03191_ _03275_ VGND VGND VPWR VPWR _03276_ sky130_fd_sc_hd__a211oi_2
XFILLER_0_49_417 VPWR VGND VPWR VGND sky130_ef_sc_hd__decap_12
XFILLER_0_119_305 VGND VGND VPWR VPWR sky130_fd_sc_hd__fill_2
XFILLER_0_71_53 VGND VGND VPWR VPWR sky130_fd_sc_hd__decap_3
X_07442_ _02248_ _02249_ _04759_ VGND VGND VPWR VPWR _02250_ sky130_fd_sc_hd__mux2_1
XFILLER_0_91_206 VGND VGND VPWR VPWR sky130_fd_sc_hd__fill_2
X_07373_ tanh_inst.divider.y\[5\] tanh_inst.divider.y\[6\] tanh_inst.LOOKUP.index\[0\]
+ VGND VGND VPWR VPWR _02182_ sky130_fd_sc_hd__mux2_1
XFILLER_0_45_612 VGND VGND VPWR VPWR sky130_fd_sc_hd__decap_4
X_06324_ _01211_ _01222_ _01233_ _01243_ VGND VGND VPWR VPWR _01259_ sky130_fd_sc_hd__and4_2
XFILLER_0_57_494 VGND VGND VPWR VPWR sky130_fd_sc_hd__decap_8
X_09112_ tanh_inst.divider.x\[7\] _03633_ _03635_ _03631_ _04758_ _04759_ VGND VGND
+ VPWR VPWR _03853_ sky130_fd_sc_hd__mux4_2
XFILLER_0_17_369 VGND VGND VPWR VPWR sky130_fd_sc_hd__fill_2
XFILLER_0_115_544 VGND VGND VPWR VPWR sky130_fd_sc_hd__decap_3
X_06255_ _01146_ _01147_ _01163_ _01179_ VGND VGND VPWR VPWR _01195_ sky130_fd_sc_hd__nor4_2
X_09043_ tanh_inst.divider.x\[7\] _03543_ _02025_ VGND VGND VPWR VPWR _03785_ sky130_fd_sc_hd__mux2_1
XFILLER_0_88_3 VPWR VGND VPWR VGND sky130_ef_sc_hd__decap_12
XTAP_TAPCELL_ROW_79_1247 VGND VPWR sky130_fd_sc_hd__tapvpwrvgnd_1
XFILLER_0_60_626 VPWR VGND VPWR VGND sky130_ef_sc_hd__decap_12
XFILLER_0_115_588 VGND VGND VPWR VPWR sky130_fd_sc_hd__fill_1
XPHY_EDGE_ROW_111_Right_111 VGND VGND VPWR VPWR sky130_fd_sc_hd__decap_3
XFILLER_0_111_81 VPWR VGND VPWR VGND sky130_ef_sc_hd__decap_12
X_06186_ _01044_ _01083_ _01107_ tanh_inst.divider.y_\[7\] VGND VGND VPWR VPWR _01130_
+ sky130_fd_sc_hd__a31o_2
XFILLER_0_102_205 VGND VGND VPWR VPWR sky130_fd_sc_hd__decap_3
X_05206_ _04905_ _04907_ _04909_ VGND VGND VPWR VPWR _04910_ sky130_fd_sc_hd__a21oi_2
XFILLER_0_102_238 VGND VGND VPWR VPWR sky130_fd_sc_hd__decap_6
XTAP_TAPCELL_ROW_92_1414 VGND VPWR sky130_fd_sc_hd__tapvpwrvgnd_1
X_05137_ mac_inst.i\[17\] mac_inst.i\[16\] mac_inst.i\[19\] mac_inst.i\[18\] VGND
+ VGND VPWR VPWR _04841_ sky130_fd_sc_hd__or4_2
X_05068_ tanh_inst.divider.y_\[-6\] VGND VGND VPWR VPWR _04792_ sky130_fd_sc_hd__inv_2
XFILLER_0_96_83 VGND VGND VPWR VPWR sky130_fd_sc_hd__fill_1
XFILLER_0_96_72 VGND VGND VPWR VPWR sky130_fd_sc_hd__fill_2
X_09945_ _04658_ _04660_ _04661_ _04791_ VGND VGND VPWR VPWR _04663_ sky130_fd_sc_hd__a31o_2
X_09876_ tanh_inst.divider.x\[2\] _04594_ VGND VGND VPWR VPWR _04596_ sky130_fd_sc_hd__and2_2
XFILLER_0_99_317 VGND VGND VPWR VPWR sky130_fd_sc_hd__decap_3
X_08827_ tanh_inst.divider.x\[-16\] tanh_inst.divider.x\[-15\] tanh_inst.divider.x\[-14\]
+ tanh_inst.divider.x\[-13\] tanh_inst.LOOKUP.index\[0\] tanh_inst.LOOKUP.index\[1\]
+ VGND VGND VPWR VPWR _03573_ sky130_fd_sc_hd__mux4_2
X_08758_ mac_inst.i\[29\] _00969_ VGND VGND VPWR VPWR _03507_ sky130_fd_sc_hd__nor2_2
X_08689_ tanh_inst.divider.x\[6\] _02014_ _03468_ _01470_ VGND VGND VPWR VPWR _00263_
+ sky130_fd_sc_hd__o211a_2
X_07709_ _01480_ _02317_ _02320_ _01486_ VGND VGND VPWR VPWR _02512_ sky130_fd_sc_hd__o22a_2
XFILLER_0_67_225 VPWR VGND VPWR VGND sky130_ef_sc_hd__decap_12
XFILLER_0_67_214 VGND VGND VPWR VPWR sky130_fd_sc_hd__decap_8
XTAP_TAPCELL_ROW_101_1521 VGND VPWR sky130_fd_sc_hd__tapvpwrvgnd_1
XFILLER_0_63_431 VGND VGND VPWR VPWR sky130_fd_sc_hd__decap_6
XTAP_TAPCELL_ROW_11_404 VGND VPWR sky130_fd_sc_hd__tapvpwrvgnd_1
XFILLER_0_35_111 VGND VGND VPWR VPWR sky130_fd_sc_hd__fill_1
XFILLER_0_106_533 VGND VGND VPWR VPWR sky130_fd_sc_hd__decap_4
XFILLER_0_90_250 VGND VGND VPWR VPWR sky130_fd_sc_hd__fill_2
XFILLER_0_63_497 VGND VGND VPWR VPWR sky130_fd_sc_hd__decap_6
XFILLER_0_23_317 VPWR VGND VPWR VGND sky130_ef_sc_hd__decap_12
XPHY_EDGE_ROW_79_Left_201 VGND VGND VPWR VPWR sky130_fd_sc_hd__decap_3
XTAP_TAPCELL_ROW_112_1661 VGND VPWR sky130_fd_sc_hd__tapvpwrvgnd_1
X_10016_ _02019_ _04712_ VGND VGND VPWR VPWR _04732_ sky130_fd_sc_hd__nor2_2
XFILLER_0_116_15 VPWR VGND VPWR VGND sky130_ef_sc_hd__decap_12
XTAP_TAPCELL_ROW_19_504 VGND VPWR sky130_fd_sc_hd__tapvpwrvgnd_1
XTAP_TAPCELL_ROW_47_846 VGND VPWR sky130_fd_sc_hd__tapvpwrvgnd_1
XFILLER_0_98_361 VGND VGND VPWR VPWR sky130_fd_sc_hd__decap_3
XPHY_EDGE_ROW_88_Left_210 VGND VGND VPWR VPWR sky130_fd_sc_hd__decap_3
XFILLER_0_86_512 VPWR VGND VPWR VGND sky130_ef_sc_hd__decap_12
XFILLER_0_25_57 VGND VGND VPWR VPWR sky130_fd_sc_hd__decap_8
XFILLER_0_86_589 VGND VGND VPWR VPWR sky130_fd_sc_hd__decap_4
XFILLER_0_73_206 VGND VGND VPWR VPWR sky130_fd_sc_hd__decap_3
XTAP_TAPCELL_ROW_63_1048 VGND VPWR sky130_fd_sc_hd__tapvpwrvgnd_1
XFILLER_0_58_269 VGND VGND VPWR VPWR sky130_fd_sc_hd__decap_3
XFILLER_0_39_461 VGND VGND VPWR VPWR sky130_fd_sc_hd__decap_4
XFILLER_0_27_634 VGND VGND VPWR VPWR sky130_fd_sc_hd__fill_1
XFILLER_0_39_483 VPWR VGND VPWR VGND sky130_ef_sc_hd__decap_12
XFILLER_0_41_34 VGND VGND VPWR VPWR sky130_fd_sc_hd__decap_3
XFILLER_0_41_45 VGND VGND VPWR VPWR sky130_fd_sc_hd__decap_8
XFILLER_0_27_678 VGND VGND VPWR VPWR sky130_fd_sc_hd__decap_3
XFILLER_0_109_393 VGND VGND VPWR VPWR sky130_fd_sc_hd__decap_4
XFILLER_0_81_261 VPWR VGND VPWR VGND sky130_ef_sc_hd__decap_12
XFILLER_0_42_626 VGND VGND VPWR VPWR sky130_fd_sc_hd__decap_3
XFILLER_0_112_503 VGND VGND VPWR VPWR sky130_fd_sc_hd__fill_1
XFILLER_0_81_294 VGND VGND VPWR VPWR sky130_fd_sc_hd__decap_3
XFILLER_0_2_701 VGND VGND VPWR VPWR sky130_fd_sc_hd__fill_2
X_06040_ _00989_ _00991_ VGND VGND VPWR VPWR _00992_ sky130_fd_sc_hd__nand2_2
XFILLER_0_41_125 VGND VGND VPWR VPWR sky130_fd_sc_hd__decap_6
XFILLER_0_42_659 VGND VGND VPWR VPWR sky130_fd_sc_hd__fill_1
XFILLER_0_41_169 VGND VGND VPWR VPWR sky130_fd_sc_hd__fill_2
X_07991_ tanh_inst.divider.x\[-10\] _02786_ VGND VGND VPWR VPWR _02787_ sky130_fd_sc_hd__and2_2
XTAP_TAPCELL_ROW_74_1188 VGND VPWR sky130_fd_sc_hd__tapvpwrvgnd_1
X_06942_ tanh_inst.divider.z_\[-22\] _01785_ VGND VGND VPWR VPWR _01786_ sky130_fd_sc_hd__nand2_2
XFILLER_0_10_589 VGND VGND VPWR VPWR sky130_fd_sc_hd__decap_4
X_09730_ tanh_inst.divider.y\[-2\] _04447_ VGND VGND VPWR VPWR _04454_ sky130_fd_sc_hd__and2_2
XFILLER_0_66_64 VGND VGND VPWR VPWR sky130_fd_sc_hd__decap_4
X_06873_ _01752_ _01754_ _01755_ VGND VGND VPWR VPWR _01758_ sky130_fd_sc_hd__a21o_2
X_09661_ _04380_ _04385_ VGND VGND VPWR VPWR _04387_ sky130_fd_sc_hd__xnor2_2
XFILLER_0_96_309 VGND VGND VPWR VPWR sky130_fd_sc_hd__decap_4
X_09592_ tanh_inst.divider.x\[-6\] _04318_ VGND VGND VPWR VPWR _04320_ sky130_fd_sc_hd__and2_2
X_05824_ _00790_ _00791_ VGND VGND VPWR VPWR _00792_ sky130_fd_sc_hd__nand2_2
X_08612_ tanh_inst.divider.x\[4\] _03393_ VGND VGND VPWR VPWR _03394_ sky130_fd_sc_hd__or2_2
X_08543_ _02052_ _02655_ _02833_ VGND VGND VPWR VPWR _03326_ sky130_fd_sc_hd__a21oi_2
X_05755_ _00727_ _00728_ VGND VGND VPWR VPWR _05755_/Y sky130_fd_sc_hd__xnor2_2
XFILLER_0_82_96 VGND VGND VPWR VPWR sky130_fd_sc_hd__fill_1
XFILLER_0_119_113 VPWR VGND VPWR VGND sky130_ef_sc_hd__decap_12
X_05686_ mac_inst.i\[0\] mac_inst.i\[1\] VGND VGND VPWR VPWR _00664_ sky130_fd_sc_hd__nand2_2
X_08474_ _03250_ _03256_ VGND VGND VPWR VPWR _03259_ sky130_fd_sc_hd__nor2_2
X_07425_ tanh_inst.divider.y\[-22\] tanh_inst.divider.x\[-22\] VGND VGND VPWR VPWR
+ _02233_ sky130_fd_sc_hd__nand2_2
XFILLER_0_17_111 VGND VGND VPWR VPWR sky130_fd_sc_hd__fill_1
XFILLER_0_18_645 VGND VGND VPWR VPWR sky130_fd_sc_hd__fill_1
X_07356_ tanh_inst.divider.y\[-23\] tanh_inst.divider.x\[-23\] VGND VGND VPWR VPWR
+ _02165_ sky130_fd_sc_hd__and2_2
XFILLER_0_72_250 VGND VGND VPWR VPWR sky130_fd_sc_hd__fill_2
X_06307_ tanh_inst.divider.y_\[-13\] _01242_ VGND VGND VPWR VPWR _01243_ sky130_fd_sc_hd__xor2_2
X_07287_ _02087_ _02096_ _02025_ VGND VGND VPWR VPWR _02097_ sky130_fd_sc_hd__mux2_1
XFILLER_0_72_272 VPWR VGND VPWR VGND sky130_ef_sc_hd__decap_12
XFILLER_0_18_689 VGND VGND VPWR VPWR sky130_fd_sc_hd__decap_8
XFILLER_0_33_615 VGND VGND VPWR VPWR sky130_fd_sc_hd__fill_1
X_06238_ _04776_ _01175_ _01176_ _01178_ VGND VGND VPWR VPWR _01179_ sky130_fd_sc_hd__o211a_2
XFILLER_0_103_514 VGND VGND VPWR VPWR sky130_fd_sc_hd__decap_4
X_09026_ _03767_ _03768_ tanh_inst.LOOKUP.index\[2\] VGND VGND VPWR VPWR _03769_ sky130_fd_sc_hd__mux2_1
XFILLER_0_60_489 VGND VGND VPWR VPWR sky130_fd_sc_hd__decap_4
XFILLER_0_13_361 VPWR VGND VPWR VGND sky130_ef_sc_hd__decap_12
XFILLER_0_5_594 VGND VGND VPWR VPWR sky130_fd_sc_hd__fill_1
XFILLER_0_20_309 VPWR VGND VPWR VGND sky130_ef_sc_hd__decap_12
X_06169_ tanh_inst.divider.y\[-22\] tanh_inst.div_en tanh_inst.divider.y_\[-22\] _01092_
+ VGND VGND VPWR VPWR _01114_ sky130_fd_sc_hd__a22o_2
X_09928_ _04578_ _04634_ VGND VGND VPWR VPWR _04646_ sky130_fd_sc_hd__and2_2
X_09859_ tanh_inst.divider.y\[1\] _04568_ _04510_ VGND VGND VPWR VPWR _04579_ sky130_fd_sc_hd__a21bo_2
XFILLER_0_99_169 VPWR VGND VPWR VGND sky130_ef_sc_hd__decap_12
XFILLER_0_87_309 VGND VGND VPWR VPWR sky130_fd_sc_hd__fill_1
XFILLER_0_68_545 VPWR VGND VPWR VGND sky130_ef_sc_hd__decap_12
XTAP_TAPCELL_ROW_44_816 VGND VPWR sky130_fd_sc_hd__tapvpwrvgnd_1
XTAP_TAPCELL_ROW_24_562 VGND VPWR sky130_fd_sc_hd__tapvpwrvgnd_1
XFILLER_0_70_209 VPWR VGND VPWR VGND sky130_ef_sc_hd__decap_12
XFILLER_0_11_15 VPWR VGND VPWR VGND sky130_ef_sc_hd__decap_12
XFILLER_0_23_125 VPWR VGND VPWR VGND sky130_ef_sc_hd__decap_12
XFILLER_0_24_659 VGND VGND VPWR VPWR sky130_fd_sc_hd__fill_1
XFILLER_0_121_333 VGND VGND VPWR VPWR sky130_fd_sc_hd__decap_3
XFILLER_0_23_169 VPWR VGND VPWR VGND sky130_ef_sc_hd__decap_12
XFILLER_0_32_670 VGND VGND VPWR VPWR sky130_fd_sc_hd__fill_1
XFILLER_0_121_377 VPWR VGND VPWR VGND sky130_ef_sc_hd__decap_12
XFILLER_0_121_344 VGND VGND VPWR VPWR sky130_fd_sc_hd__decap_8
XFILLER_0_78_309 VGND VGND VPWR VPWR sky130_fd_sc_hd__decap_6
XFILLER_0_59_545 VPWR VGND VPWR VGND sky130_ef_sc_hd__decap_12
X_05540_ _00521_ _00524_ _00533_ mac_inst.z\[31\] VGND VGND VPWR VPWR _00534_ sky130_fd_sc_hd__a211oi_2
XFILLER_0_52_22 VGND VGND VPWR VPWR sky130_fd_sc_hd__fill_1
XFILLER_0_86_353 VGND VGND VPWR VPWR sky130_fd_sc_hd__fill_2
XFILLER_0_117_606 VGND VGND VPWR VPWR sky130_fd_sc_hd__decap_8
XFILLER_0_86_386 VGND VGND VPWR VPWR sky130_fd_sc_hd__decap_3
XFILLER_0_74_537 VGND VGND VPWR VPWR sky130_fd_sc_hd__fill_1
X_05471_ _00470_ VGND VGND VPWR VPWR _00471_ sky130_fd_sc_hd__inv_2
X_07210_ tanh_inst.LOOKUP.index\[1\] tanh_inst.LOOKUP.index\[0\] tanh_inst.LOOKUP.index\[3\]
+ tanh_inst.LOOKUP.index\[2\] VGND VGND VPWR VPWR _02020_ sky130_fd_sc_hd__a211o_2
X_08190_ _02901_ _02981_ _02980_ VGND VGND VPWR VPWR _02982_ sky130_fd_sc_hd__a21o_2
XFILLER_0_116_149 VGND VGND VPWR VPWR sky130_fd_sc_hd__fill_1
X_07141_ _01962_ _01963_ VGND VGND VPWR VPWR _01964_ sky130_fd_sc_hd__xnor2_2
XFILLER_0_54_250 VGND VGND VPWR VPWR sky130_fd_sc_hd__fill_2
XFILLER_0_42_412 VGND VGND VPWR VPWR sky130_fd_sc_hd__fill_1
XTAP_TAPCELL_ROW_76_1206 VGND VPWR sky130_fd_sc_hd__tapvpwrvgnd_1
XFILLER_0_54_283 VGND VGND VPWR VPWR sky130_fd_sc_hd__decap_3
X_07072_ _01039_ _01057_ VGND VGND VPWR VPWR _01902_ sky130_fd_sc_hd__or2_2
XTAP_TAPCELL_ROW_76_1217 VGND VPWR sky130_fd_sc_hd__tapvpwrvgnd_1
XFILLER_0_42_489 VPWR VGND VPWR VGND sky130_ef_sc_hd__decap_12
X_06023_ _00975_ _00976_ VGND VGND VPWR VPWR _06023_/X sky130_fd_sc_hd__xor2_2
XFILLER_0_77_74 VPWR VGND VPWR VGND sky130_ef_sc_hd__decap_12
X_07974_ _02769_ _02770_ VGND VGND VPWR VPWR _02771_ sky130_fd_sc_hd__xnor2_2
X_06925_ tanh_inst.div_en tanh_inst.divider.z_\[7\] VGND VGND VPWR VPWR _00196_ sky130_fd_sc_hd__and2b_2
X_09713_ _04363_ _04364_ _04426_ _04791_ VGND VGND VPWR VPWR _04437_ sky130_fd_sc_hd__o31a_2
X_06856_ tanh_inst.z_\[4\] _01667_ VGND VGND VPWR VPWR _01743_ sky130_fd_sc_hd__nor2_2
X_09644_ _04357_ _04358_ _04302_ VGND VGND VPWR VPWR _04370_ sky130_fd_sc_hd__or3b_2
XFILLER_0_97_629 VGND VGND VPWR VPWR sky130_fd_sc_hd__decap_3
XTAP_TAPCELL_ROW_87_1346 VGND VPWR sky130_fd_sc_hd__tapvpwrvgnd_1
X_05807_ _00729_ _00733_ _00740_ _00775_ VGND VGND VPWR VPWR _00776_ sky130_fd_sc_hd__and4_2
XFILLER_0_96_139 VGND VGND VPWR VPWR sky130_fd_sc_hd__fill_1
X_06787_ tanh_inst.z_\[7\] _01667_ _01682_ VGND VGND VPWR VPWR _01683_ sky130_fd_sc_hd__mux2_1
X_09575_ _04233_ _04291_ VGND VGND VPWR VPWR _04303_ sky130_fd_sc_hd__nand2b_2
X_05738_ _00699_ _00700_ _00697_ VGND VGND VPWR VPWR _00713_ sky130_fd_sc_hd__o21a_2
X_08526_ tanh_inst.divider.x\[2\] _03296_ VGND VGND VPWR VPWR _03310_ sky130_fd_sc_hd__nor2_2
XFILLER_0_108_606 VPWR VGND VPWR VGND sky130_ef_sc_hd__decap_12
XFILLER_0_77_386 VGND VGND VPWR VPWR sky130_fd_sc_hd__decap_6
X_08457_ _03241_ _03242_ VGND VGND VPWR VPWR _03243_ sky130_fd_sc_hd__xnor2_2
X_05669_ _00639_ _00643_ _00637_ VGND VGND VPWR VPWR _00651_ sky130_fd_sc_hd__o21ai_2
XFILLER_0_107_105 VGND VGND VPWR VPWR sky130_fd_sc_hd__decap_6
XFILLER_0_80_507 VGND VGND VPWR VPWR sky130_fd_sc_hd__decap_4
X_07408_ _02025_ _02213_ _02215_ VGND VGND VPWR VPWR _02216_ sky130_fd_sc_hd__o21ai_2
XFILLER_0_18_442 VGND VGND VPWR VPWR sky130_fd_sc_hd__decap_4
XTAP_TAPCELL_ROW_21_521 VGND VPWR sky130_fd_sc_hd__tapvpwrvgnd_1
XFILLER_0_61_721 VGND VGND VPWR VPWR sky130_fd_sc_hd__decap_3
XFILLER_0_18_475 VGND VGND VPWR VPWR sky130_fd_sc_hd__fill_1
X_08388_ _03139_ _03144_ _03173_ tanh_inst.z_\[7\] VGND VGND VPWR VPWR _03175_ sky130_fd_sc_hd__a31o_2
X_07339_ _02028_ _02144_ _02029_ _02027_ VGND VGND VPWR VPWR _02148_ sky130_fd_sc_hd__o211a_2
XFILLER_0_33_434 VGND VGND VPWR VPWR sky130_fd_sc_hd__fill_1
XTAP_TAPCELL_ROW_98_1486 VGND VPWR sky130_fd_sc_hd__tapvpwrvgnd_1
X_10350_ clknet_leaf_19_clk _00207_ VGND VGND VPWR VPWR tanh_inst.divider.z_\[-14\]
+ sky130_fd_sc_hd__dfxtp_2
X_09009_ _03694_ _03695_ _03693_ VGND VGND VPWR VPWR _03752_ sky130_fd_sc_hd__a21o_2
X_10281_ clknet_leaf_29_clk _00138_ VGND VGND VPWR VPWR tanh_inst.z_\[-14\] sky130_fd_sc_hd__dfxtp_2
XFILLER_0_20_139 VGND VGND VPWR VPWR sky130_fd_sc_hd__fill_1
XTAP_TAPCELL_ROW_29_621 VGND VPWR sky130_fd_sc_hd__tapvpwrvgnd_1
XTAP_TAPCELL_ROW_57_974 VGND VPWR sky130_fd_sc_hd__tapvpwrvgnd_1
XFILLER_0_113_27 VPWR VGND VPWR VGND sky130_ef_sc_hd__decap_12
XFILLER_0_83_334 VGND VGND VPWR VPWR sky130_fd_sc_hd__fill_2
XFILLER_0_68_397 VGND VGND VPWR VPWR sky130_fd_sc_hd__decap_3
XTAP_TAPCELL_ROW_60_1007 VGND VPWR sky130_fd_sc_hd__tapvpwrvgnd_1
XTAP_TAPCELL_ROW_120_1760 VGND VPWR sky130_fd_sc_hd__tapvpwrvgnd_1
XFILLER_0_83_367 VPWR VGND VPWR VGND sky130_ef_sc_hd__decap_12
XFILLER_0_83_345 VPWR VGND VPWR VGND sky130_ef_sc_hd__decap_12
XTAP_TAPCELL_ROW_60_1018 VGND VPWR sky130_fd_sc_hd__tapvpwrvgnd_1
XFILLER_0_98_29 VPWR VGND VPWR VGND sky130_ef_sc_hd__decap_12
XFILLER_0_3_317 VPWR VGND VPWR VGND sky130_ef_sc_hd__decap_12
XFILLER_0_12_618 VGND VGND VPWR VPWR sky130_fd_sc_hd__decap_6
XFILLER_0_121_141 VPWR VGND VPWR VGND sky130_ef_sc_hd__decap_12
XFILLER_0_51_286 VGND VGND VPWR VPWR sky130_fd_sc_hd__fill_1
XFILLER_0_51_297 VPWR VGND VPWR VGND sky130_ef_sc_hd__decap_12
X_10479_ clknet_leaf_34_clk _00336_ _00080_ VGND VGND VPWR VPWR tanh_counter\[2\]
+ sky130_fd_sc_hd__dfrtp_2
XTAP_TAPCELL_ROW_71_1147 VGND VPWR sky130_fd_sc_hd__tapvpwrvgnd_1
XPHY_EDGE_ROW_16_Left_138 VGND VGND VPWR VPWR sky130_fd_sc_hd__decap_3
X_06710_ _01530_ _01547_ VGND VGND VPWR VPWR _01614_ sky130_fd_sc_hd__xor2_2
X_07690_ tanh_inst.divider.x\[-17\] _02491_ VGND VGND VPWR VPWR _02493_ sky130_fd_sc_hd__xnor2_2
X_06641_ _01551_ _01552_ VGND VGND VPWR VPWR _01553_ sky130_fd_sc_hd__nand2_2
X_09360_ _04038_ _04040_ _04061_ _04091_ _04060_ VGND VGND VPWR VPWR _04094_ sky130_fd_sc_hd__o311a_2
XFILLER_0_93_109 VGND VGND VPWR VPWR sky130_fd_sc_hd__decap_3
XFILLER_0_87_673 VGND VGND VPWR VPWR sky130_fd_sc_hd__fill_2
X_06572_ _01483_ _01485_ _01486_ VGND VGND VPWR VPWR _01487_ sky130_fd_sc_hd__nand3_2
XFILLER_0_59_364 VPWR VGND VPWR VGND sky130_ef_sc_hd__decap_12
X_09291_ tanh_inst.divider.x\[-15\] _03998_ _03996_ VGND VGND VPWR VPWR _04027_ sky130_fd_sc_hd__o21a_2
XFILLER_0_87_695 VGND VGND VPWR VPWR sky130_fd_sc_hd__decap_4
XFILLER_0_86_172 VGND VGND VPWR VPWR sky130_fd_sc_hd__decap_3
XFILLER_0_19_217 VGND VGND VPWR VPWR sky130_fd_sc_hd__decap_6
X_08311_ _03047_ _03056_ _03098_ VGND VGND VPWR VPWR _03100_ sky130_fd_sc_hd__a21o_2
X_05523_ _00516_ _00518_ VGND VGND VPWR VPWR _00519_ sky130_fd_sc_hd__nand2_2
XFILLER_0_86_194 VGND VGND VPWR VPWR sky130_fd_sc_hd__fill_2
XTAP_TAPCELL_ROW_82_1287 VGND VPWR sky130_fd_sc_hd__tapvpwrvgnd_1
X_05454_ _00419_ _00420_ _00454_ mac_inst.z\[31\] VGND VGND VPWR VPWR _00455_ sky130_fd_sc_hd__a31o_2
X_08242_ tanh_inst.divider.y\[-4\] _03031_ VGND VGND VPWR VPWR _03032_ sky130_fd_sc_hd__nor2_2
XFILLER_0_74_378 VPWR VGND VPWR VGND sky130_ef_sc_hd__decap_12
XFILLER_0_7_667 VGND VGND VPWR VPWR sky130_fd_sc_hd__decap_4
XFILLER_0_6_133 VGND VGND VPWR VPWR sky130_fd_sc_hd__decap_6
XPHY_EDGE_ROW_25_Left_147 VGND VGND VPWR VPWR sky130_fd_sc_hd__decap_3
X_08173_ _02876_ _02940_ VGND VGND VPWR VPWR _02965_ sky130_fd_sc_hd__nand2_2
XFILLER_0_6_177 VPWR VGND VPWR VGND sky130_ef_sc_hd__decap_12
XFILLER_0_15_423 VGND VGND VPWR VPWR sky130_fd_sc_hd__decap_3
X_05385_ _04923_ _04995_ _00389_ _04781_ _00390_ VGND VGND VPWR VPWR _00391_ sky130_fd_sc_hd__o221a_2
X_07124_ _01059_ _01947_ _01948_ _01088_ _00186_ VGND VGND VPWR VPWR _00218_ sky130_fd_sc_hd__o32a_2
XFILLER_0_42_253 VGND VGND VPWR VPWR sky130_fd_sc_hd__fill_2
XFILLER_0_113_664 VGND VGND VPWR VPWR sky130_fd_sc_hd__decap_8
XFILLER_0_88_62 VGND VGND VPWR VPWR sky130_fd_sc_hd__fill_1
X_07055_ _01886_ VGND VGND VPWR VPWR _01887_ sky130_fd_sc_hd__inv_2
XFILLER_0_70_3 VPWR VGND VPWR VGND sky130_ef_sc_hd__decap_12
XFILLER_0_100_325 VGND VGND VPWR VPWR sky130_fd_sc_hd__fill_1
X_06006_ mac_inst.i\[9\] mac_inst.i\[8\] mac_inst.i\[10\] _00958_ VGND VGND VPWR VPWR
+ _00960_ sky130_fd_sc_hd__and4_2
XFILLER_0_11_673 VGND VGND VPWR VPWR sky130_fd_sc_hd__fill_2
XTAP_TAPCELL_ROW_7_349 VGND VPWR sky130_fd_sc_hd__tapvpwrvgnd_1
XPHY_EDGE_ROW_34_Left_156 VGND VGND VPWR VPWR sky130_fd_sc_hd__decap_3
X_07957_ tanh_inst.divider.x\[-11\] _02752_ VGND VGND VPWR VPWR _02754_ sky130_fd_sc_hd__or2_2
X_06908_ tanh_inst.div_en tanh_inst.divider.z_\[-10\] VGND VGND VPWR VPWR _00179_
+ sky130_fd_sc_hd__and2b_2
X_07888_ _02685_ _02686_ VGND VGND VPWR VPWR _02687_ sky130_fd_sc_hd__nand2_2
X_06839_ tanh_inst.z_\[1\] _01728_ VGND VGND VPWR VPWR _01729_ sky130_fd_sc_hd__xnor2_2
X_09627_ _04297_ _04298_ VGND VGND VPWR VPWR _04354_ sky130_fd_sc_hd__and2b_2
XFILLER_0_78_651 VGND VGND VPWR VPWR sky130_fd_sc_hd__fill_2
X_09558_ _02018_ _04286_ VGND VGND VPWR VPWR _04287_ sky130_fd_sc_hd__nor2_2
XTAP_TAPCELL_ROW_54_933 VGND VPWR sky130_fd_sc_hd__tapvpwrvgnd_1
XFILLER_0_65_323 VPWR VGND VPWR VGND sky130_ef_sc_hd__decap_12
X_08509_ _03240_ _03290_ _03292_ VGND VGND VPWR VPWR _03293_ sky130_fd_sc_hd__o21a_2
XPHY_EDGE_ROW_43_Left_165 VGND VGND VPWR VPWR sky130_fd_sc_hd__decap_3
XFILLER_0_93_654 VGND VGND VPWR VPWR sky130_fd_sc_hd__fill_2
X_09489_ _02019_ _04211_ _04218_ _04219_ _02015_ VGND VGND VPWR VPWR _04220_ sky130_fd_sc_hd__a221o_2
XFILLER_0_92_153 VGND VGND VPWR VPWR sky130_fd_sc_hd__fill_1
XFILLER_0_80_315 VGND VGND VPWR VPWR sky130_fd_sc_hd__fill_1
XTAP_TAPCELL_ROW_34_690 VGND VPWR sky130_fd_sc_hd__tapvpwrvgnd_1
XFILLER_0_92_197 VGND VGND VPWR VPWR sky130_fd_sc_hd__decap_4
XFILLER_0_21_404 VGND VGND VPWR VPWR sky130_fd_sc_hd__fill_2
XFILLER_0_33_231 VGND VGND VPWR VPWR sky130_fd_sc_hd__decap_3
XFILLER_0_33_253 VGND VGND VPWR VPWR sky130_fd_sc_hd__fill_1
X_10402_ clknet_leaf_43_clk _00259_ VGND VGND VPWR VPWR tanh_inst.divider.x\[2\] sky130_fd_sc_hd__dfxtp_2
X_10333_ clknet_leaf_17_clk _00190_ VGND VGND VPWR VPWR tanh_out[25] sky130_fd_sc_hd__dfxtp_2
XFILLER_0_0_309 VPWR VGND VPWR VGND sky130_ef_sc_hd__decap_12
XFILLER_0_104_697 VGND VGND VPWR VPWR sky130_fd_sc_hd__decap_3
XFILLER_0_103_163 VGND VGND VPWR VPWR sky130_fd_sc_hd__decap_4
X_10264_ clknet_leaf_31_clk mac_inst.x\[26\] _00000_ VGND VGND VPWR VPWR mac_x_out[26]
+ sky130_fd_sc_hd__dfrtp_2
XPHY_EDGE_ROW_52_Left_174 VGND VGND VPWR VPWR sky130_fd_sc_hd__decap_3
X_10195_ x_in[21] _00000_ VGND VGND VPWR VPWR mac_inst.x\[21\] sky130_fd_sc_hd__dlxtn_1
XFILLER_0_108_27 VGND VGND VPWR VPWR sky130_fd_sc_hd__fill_1
XTAP_TAPCELL_ROW_109_1622 VGND VPWR sky130_fd_sc_hd__tapvpwrvgnd_1
XFILLER_0_17_69 VPWR VGND VPWR VGND sky130_ef_sc_hd__decap_12
XPHY_EDGE_ROW_61_Left_183 VGND VGND VPWR VPWR sky130_fd_sc_hd__decap_3
XFILLER_0_29_537 VGND VGND VPWR VPWR sky130_fd_sc_hd__decap_4
XFILLER_0_83_153 VGND VGND VPWR VPWR sky130_fd_sc_hd__decap_6
XFILLER_0_16_209 VPWR VGND VPWR VGND sky130_ef_sc_hd__decap_12
XFILLER_0_109_3 VPWR VGND VPWR VGND sky130_ef_sc_hd__decap_12
XFILLER_0_3_125 VPWR VGND VPWR VGND sky130_ef_sc_hd__decap_12
XFILLER_0_24_253 VPWR VGND VPWR VGND sky130_ef_sc_hd__decap_12
X_05170_ mac_inst.x\[29\] _04852_ _04853_ VGND VGND VPWR VPWR _04874_ sky130_fd_sc_hd__a21o_2
XFILLER_0_12_415 VGND VGND VPWR VPWR sky130_fd_sc_hd__decap_4
XFILLER_0_3_169 VPWR VGND VPWR VGND sky130_ef_sc_hd__decap_12
XPHY_EDGE_ROW_70_Left_192 VGND VGND VPWR VPWR sky130_fd_sc_hd__decap_3
XFILLER_0_110_689 VGND VGND VPWR VPWR sky130_fd_sc_hd__decap_4
X_08860_ _03541_ _03545_ _03546_ _03547_ _04761_ _04760_ VGND VGND VPWR VPWR _03605_
+ sky130_fd_sc_hd__mux4_2
X_07811_ tanh_inst.divider.x\[-15\] _02014_ _02611_ _01470_ VGND VGND VPWR VPWR _00242_
+ sky130_fd_sc_hd__o211a_2
XTAP_TAPCELL_ROW_4_308 VGND VPWR sky130_fd_sc_hd__tapvpwrvgnd_1
X_08791_ _02026_ _03534_ _03536_ _02025_ VGND VGND VPWR VPWR _03537_ sky130_fd_sc_hd__o211ai_2
X_07742_ _02449_ _02451_ _02497_ _02543_ VGND VGND VPWR VPWR _02544_ sky130_fd_sc_hd__a31o_2
XTAP_TAPCELL_ROW_84_1316 VGND VPWR sky130_fd_sc_hd__tapvpwrvgnd_1
XFILLER_0_79_459 VPWR VGND VPWR VGND sky130_ef_sc_hd__decap_12
X_07673_ tanh_inst.divider.x\[-18\] _02475_ VGND VGND VPWR VPWR _02477_ sky130_fd_sc_hd__or2_2
X_09412_ _04088_ _04096_ VGND VGND VPWR VPWR _04145_ sky130_fd_sc_hd__nor2_2
X_06624_ _01535_ _01536_ VGND VGND VPWR VPWR _01537_ sky130_fd_sc_hd__xnor2_2
XFILLER_0_59_183 VPWR VGND VPWR VGND sky130_ef_sc_hd__decap_12
X_09343_ tanh_inst.LOOKUP.index\[4\] _04076_ _04077_ VGND VGND VPWR VPWR _04078_ sky130_fd_sc_hd__a21bo_2
XTAP_TAPCELL_ROW_51_903 VGND VPWR sky130_fd_sc_hd__tapvpwrvgnd_1
XFILLER_0_90_85 VGND VGND VPWR VPWR sky130_fd_sc_hd__fill_1
X_06555_ current_state\[0\] _01467_ _01468_ current_state\[1\] VGND VGND VPWR VPWR
+ _01470_ sky130_fd_sc_hd__or4b_2
XFILLER_0_47_334 VGND VGND VPWR VPWR sky130_fd_sc_hd__fill_2
XFILLER_0_117_222 VGND VGND VPWR VPWR sky130_fd_sc_hd__fill_2
X_06486_ _01406_ _01407_ VGND VGND VPWR VPWR _01408_ sky130_fd_sc_hd__xnor2_2
X_09274_ tanh_inst.divider.y\[-15\] _04010_ VGND VGND VPWR VPWR _04011_ sky130_fd_sc_hd__nand2_2
X_05506_ _00501_ _00502_ VGND VGND VPWR VPWR _00503_ sky130_fd_sc_hd__nand2_2
XFILLER_0_74_197 VGND VGND VPWR VPWR sky130_fd_sc_hd__decap_4
XFILLER_0_7_475 VGND VGND VPWR VPWR sky130_fd_sc_hd__fill_1
X_05437_ mac_inst.i\[3\] _04997_ VGND VGND VPWR VPWR _00439_ sky130_fd_sc_hd__nor2_2
X_08225_ _02959_ _02968_ _03014_ tanh_inst.z_\[7\] VGND VGND VPWR VPWR _03016_ sky130_fd_sc_hd__o31a_2
X_05368_ _04862_ _04892_ _04901_ _04921_ _04781_ _04782_ VGND VGND VPWR VPWR _00375_
+ sky130_fd_sc_hd__mux4_2
X_08156_ _02948_ VGND VGND VPWR VPWR _02949_ sky130_fd_sc_hd__inv_2
X_07107_ tanh_inst.divider.z_\[-4\] _01924_ _01932_ VGND VGND VPWR VPWR _01933_ sky130_fd_sc_hd__nand3_2
XTAP_TAPCELL_ROW_95_1445 VGND VPWR sky130_fd_sc_hd__tapvpwrvgnd_1
XFILLER_0_70_381 VGND VGND VPWR VPWR sky130_fd_sc_hd__fill_1
XFILLER_0_113_483 VGND VGND VPWR VPWR sky130_fd_sc_hd__decap_8
X_08087_ _02876_ _02879_ _02880_ VGND VGND VPWR VPWR _02881_ sky130_fd_sc_hd__a21o_2
X_05299_ _04886_ _04917_ _04919_ _04915_ _04789_ _04783_ VGND VGND VPWR VPWR _04999_
+ sky130_fd_sc_hd__mux4_2
X_07038_ _01870_ _01871_ VGND VGND VPWR VPWR _01872_ sky130_fd_sc_hd__and2b_2
X_08989_ _03539_ _03541_ _03547_ _03542_ _04760_ _04761_ VGND VGND VPWR VPWR _03732_
+ sky130_fd_sc_hd__mux4_2
XFILLER_0_97_223 VGND VGND VPWR VPWR sky130_fd_sc_hd__fill_1
XFILLER_0_97_278 VGND VGND VPWR VPWR sky130_fd_sc_hd__fill_2
XTAP_TAPCELL_ROW_104_1563 VGND VPWR sky130_fd_sc_hd__tapvpwrvgnd_1
XFILLER_0_38_345 VPWR VGND VPWR VGND sky130_ef_sc_hd__decap_12
XFILLER_0_93_484 VPWR VGND VPWR VGND sky130_ef_sc_hd__decap_12
XFILLER_0_81_624 VGND VGND VPWR VPWR sky130_fd_sc_hd__decap_6
XFILLER_0_38_389 VGND VGND VPWR VPWR sky130_fd_sc_hd__decap_4
XFILLER_0_21_223 VGND VGND VPWR VPWR sky130_fd_sc_hd__fill_1
X_10316_ clknet_leaf_16_clk _00173_ VGND VGND VPWR VPWR tanh_out[8] sky130_fd_sc_hd__dfxtp_2
XFILLER_0_119_15 VPWR VGND VPWR VGND sky130_ef_sc_hd__decap_12
X_10247_ clknet_leaf_30_clk mac_inst.x\[9\] _00000_ VGND VGND VPWR VPWR mac_x_out[9]
+ sky130_fd_sc_hd__dfrtp_2
X_10178_ x_in[4] _00000_ VGND VGND VPWR VPWR mac_inst.x\[4\] sky130_fd_sc_hd__dlxtn_1
XTAP_TAPCELL_ROW_37_719 VGND VPWR sky130_fd_sc_hd__tapvpwrvgnd_1
XFILLER_0_69_492 VPWR VGND VPWR VGND sky130_ef_sc_hd__decap_12
XTAP_TAPCELL_ROW_17_476 VGND VPWR sky130_fd_sc_hd__tapvpwrvgnd_1
X_06340_ _01253_ _01261_ _01273_ VGND VGND VPWR VPWR _01274_ sky130_fd_sc_hd__and3_2
XFILLER_0_56_153 VGND VGND VPWR VPWR sky130_fd_sc_hd__fill_1
X_06271_ tanh_inst.divider.y_\[-16\] _01208_ VGND VGND VPWR VPWR _01210_ sky130_fd_sc_hd__or2_2
XFILLER_0_84_484 VGND VGND VPWR VPWR sky130_fd_sc_hd__decap_8
XFILLER_0_114_214 VGND VGND VPWR VPWR sky130_fd_sc_hd__decap_4
X_08010_ _02762_ _02803_ _02804_ _02717_ VGND VGND VPWR VPWR _02806_ sky130_fd_sc_hd__o22a_2
XFILLER_0_25_540 VPWR VGND VPWR VGND sky130_ef_sc_hd__decap_12
X_05222_ mac_inst.x\[31\] mac_inst.i\[5\] _04835_ _04883_ VGND VGND VPWR VPWR _04926_
+ sky130_fd_sc_hd__a22oi_2
XFILLER_0_12_245 VGND VGND VPWR VPWR sky130_fd_sc_hd__decap_6
X_05153_ mac_inst.x\[16\] _04852_ _04853_ VGND VGND VPWR VPWR _04857_ sky130_fd_sc_hd__a21o_2
X_09961_ _02053_ _04130_ _04193_ VGND VGND VPWR VPWR _04678_ sky130_fd_sc_hd__o21a_2
X_05084_ tanh_counter\[5\] tanh_counter\[4\] _04806_ VGND VGND VPWR VPWR _04807_ sky130_fd_sc_hd__and3_2
XFILLER_0_12_289 VPWR VGND VPWR VGND sky130_ef_sc_hd__decap_12
XFILLER_0_0_673 VPWR VGND VPWR VGND sky130_ef_sc_hd__decap_12
X_08912_ tanh_inst.LOOKUP.index\[4\] _03656_ VGND VGND VPWR VPWR _03657_ sky130_fd_sc_hd__and2_2
X_09892_ _02053_ _04058_ _04193_ VGND VGND VPWR VPWR _04611_ sky130_fd_sc_hd__o21a_2
X_08843_ _03586_ _03587_ _02025_ VGND VGND VPWR VPWR _03588_ sky130_fd_sc_hd__mux2_1
XTAP_TAPCELL_ROW_90_1386 VGND VPWR sky130_fd_sc_hd__tapvpwrvgnd_1
XFILLER_0_109_81 VPWR VGND VPWR VGND sky130_ef_sc_hd__decap_12
XPHY_EDGE_ROW_108_Left_230 VGND VGND VPWR VPWR sky130_fd_sc_hd__decap_3
X_08774_ tanh_inst.divider.x\[-13\] _02028_ _03508_ VGND VGND VPWR VPWR _03520_ sky130_fd_sc_hd__o21a_2
X_05986_ _00925_ _00934_ VGND VGND VPWR VPWR _00941_ sky130_fd_sc_hd__and2_2
XFILLER_0_33_3 VPWR VGND VPWR VGND sky130_ef_sc_hd__decap_12
X_07725_ tanh_inst.z_\[7\] _02524_ _02525_ _02527_ _02019_ VGND VGND VPWR VPWR _02528_
+ sky130_fd_sc_hd__o311a_2
XFILLER_0_79_223 VGND VGND VPWR VPWR sky130_fd_sc_hd__fill_1
X_07656_ _02441_ _02459_ VGND VGND VPWR VPWR _02460_ sky130_fd_sc_hd__nor2_2
X_07587_ _02052_ _02391_ _02388_ VGND VGND VPWR VPWR _02392_ sky130_fd_sc_hd__o21a_2
XFILLER_0_75_440 VGND VGND VPWR VPWR sky130_fd_sc_hd__decap_8
X_06607_ tanh_inst.LOOKUP.index\[4\] tanh_inst.LOOKUP.index\[2\] _01513_ _01515_ VGND
+ VGND VPWR VPWR _01520_ sky130_fd_sc_hd__o31a_2
XFILLER_0_47_120 VPWR VGND VPWR VGND sky130_ef_sc_hd__decap_12
XFILLER_0_48_643 VGND VGND VPWR VPWR sky130_fd_sc_hd__fill_1
X_09326_ _02671_ _04059_ VGND VGND VPWR VPWR _04061_ sky130_fd_sc_hd__xnor2_2
X_06538_ _01452_ _01454_ VGND VGND VPWR VPWR _01455_ sky130_fd_sc_hd__xnor2_2
XFILLER_0_48_687 VGND VGND VPWR VPWR sky130_fd_sc_hd__decap_6
XFILLER_0_48_698 VGND VGND VPWR VPWR sky130_fd_sc_hd__fill_2
XFILLER_0_118_553 VGND VGND VPWR VPWR sky130_fd_sc_hd__fill_1
X_09257_ _03969_ _03973_ _03993_ VGND VGND VPWR VPWR _03994_ sky130_fd_sc_hd__o21ai_2
XFILLER_0_35_348 VGND VGND VPWR VPWR sky130_fd_sc_hd__decap_3
X_06469_ _01390_ _01391_ VGND VGND VPWR VPWR _01392_ sky130_fd_sc_hd__and2_2
XFILLER_0_105_225 VPWR VGND VPWR VGND sky130_ef_sc_hd__decap_12
XFILLER_0_105_214 VGND VGND VPWR VPWR sky130_fd_sc_hd__decap_8
XFILLER_0_90_454 VGND VGND VPWR VPWR sky130_fd_sc_hd__decap_6
X_08208_ _02053_ _02286_ _02834_ VGND VGND VPWR VPWR _02999_ sky130_fd_sc_hd__o21a_2
XFILLER_0_63_668 VGND VGND VPWR VPWR sky130_fd_sc_hd__decap_4
XFILLER_0_62_156 VGND VGND VPWR VPWR sky130_fd_sc_hd__decap_3
XFILLER_0_7_261 VPWR VGND VPWR VGND sky130_ef_sc_hd__decap_12
XFILLER_0_16_540 VGND VGND VPWR VPWR sky130_fd_sc_hd__decap_4
X_09188_ _03925_ _03926_ VGND VGND VPWR VPWR _03927_ sky130_fd_sc_hd__and2b_2
XFILLER_0_62_178 VPWR VGND VPWR VGND sky130_ef_sc_hd__decap_12
XFILLER_0_16_562 VGND VGND VPWR VPWR sky130_fd_sc_hd__decap_6
X_08139_ _02893_ _02902_ _02930_ tanh_inst.z_\[7\] VGND VGND VPWR VPWR _02932_ sky130_fd_sc_hd__a31o_2
XFILLER_0_101_431 VPWR VGND VPWR VGND sky130_ef_sc_hd__decap_12
X_10101_ clknet_leaf_33_clk _00118_ _00068_ VGND VGND VPWR VPWR mac_counter\[0\] sky130_fd_sc_hd__dfrtp_2
X_10032_ _02019_ _04746_ _02014_ VGND VGND VPWR VPWR _04747_ sky130_fd_sc_hd__o21ai_2
XFILLER_0_105_39 VPWR VGND VPWR VGND sky130_ef_sc_hd__decap_12
XFILLER_0_58_429 VPWR VGND VPWR VGND sky130_ef_sc_hd__decap_12
XFILLER_0_14_15 VPWR VGND VPWR VGND sky130_ef_sc_hd__decap_12
XFILLER_0_85_237 VGND VGND VPWR VPWR sky130_fd_sc_hd__decap_8
XFILLER_0_66_473 VGND VGND VPWR VPWR sky130_fd_sc_hd__decap_3
XTAP_TAPCELL_ROW_14_435 VGND VPWR sky130_fd_sc_hd__tapvpwrvgnd_1
XFILLER_0_121_27 VGND VGND VPWR VPWR sky130_fd_sc_hd__fill_1
XFILLER_0_38_197 VGND VGND VPWR VPWR sky130_fd_sc_hd__decap_4
XTAP_TAPCELL_ROW_42_788 VGND VPWR sky130_fd_sc_hd__tapvpwrvgnd_1
XTAP_TAPCELL_ROW_117_1721 VGND VPWR sky130_fd_sc_hd__tapvpwrvgnd_1
X_05840_ _00779_ _00781_ _00790_ _00791_ _00806_ VGND VGND VPWR VPWR _00807_ sky130_fd_sc_hd__a41o_2
XTAP_TAPCELL_ROW_68_1108 VGND VPWR sky130_fd_sc_hd__tapvpwrvgnd_1
XFILLER_0_89_543 VGND VGND VPWR VPWR sky130_fd_sc_hd__fill_1
X_07510_ tanh_inst.divider.y\[-17\] tanh_inst.divider.y\[-16\] tanh_inst.divider.y\[-15\]
+ tanh_inst.divider.y\[-14\] tanh_inst.LOOKUP.index\[0\] tanh_inst.LOOKUP.index\[1\]
+ VGND VGND VPWR VPWR _02317_ sky130_fd_sc_hd__mux4_2
X_05771_ _00740_ _00742_ VGND VGND VPWR VPWR _00743_ sky130_fd_sc_hd__nand2_2
X_08490_ tanh_inst.z_\[7\] _03241_ VGND VGND VPWR VPWR _03275_ sky130_fd_sc_hd__nor2_2
XFILLER_0_49_429 VGND VGND VPWR VPWR sky130_fd_sc_hd__fill_2
XFILLER_0_76_248 VGND VGND VPWR VPWR sky130_fd_sc_hd__decap_4
X_07441_ tanh_inst.divider.y\[2\] tanh_inst.divider.y\[3\] tanh_inst.divider.y\[4\]
+ tanh_inst.divider.y\[5\] tanh_inst.LOOKUP.index\[0\] tanh_inst.LOOKUP.index\[1\]
+ VGND VGND VPWR VPWR _02249_ sky130_fd_sc_hd__mux4_2
XFILLER_0_71_87 VGND VGND VPWR VPWR sky130_fd_sc_hd__fill_1
X_07372_ tanh_inst.divider.y\[1\] tanh_inst.divider.y\[2\] tanh_inst.divider.y\[3\]
+ tanh_inst.divider.y\[4\] tanh_inst.LOOKUP.index\[0\] tanh_inst.LOOKUP.index\[1\]
+ VGND VGND VPWR VPWR _02181_ sky130_fd_sc_hd__mux4_2
X_06323_ tanh_inst.divider.y_\[-13\] _01242_ _01256_ VGND VGND VPWR VPWR _01258_ sky130_fd_sc_hd__o21a_2
XFILLER_0_84_292 VPWR VGND VPWR VGND sky130_ef_sc_hd__decap_12
XFILLER_0_72_421 VGND VGND VPWR VPWR sky130_fd_sc_hd__fill_2
XFILLER_0_17_337 VPWR VGND VPWR VGND sky130_ef_sc_hd__decap_12
XFILLER_0_45_635 VGND VGND VPWR VPWR sky130_fd_sc_hd__decap_3
X_09111_ tanh_inst.LOOKUP.index\[2\] _03635_ _03760_ VGND VGND VPWR VPWR _03852_ sky130_fd_sc_hd__o21a_2
X_06254_ _01039_ _01192_ _01191_ _01190_ VGND VGND VPWR VPWR _01194_ sky130_fd_sc_hd__o211ai_2
X_09042_ _03521_ _03532_ _02025_ VGND VGND VPWR VPWR _03784_ sky130_fd_sc_hd__mux2_1
XTAP_TAPCELL_ROW_79_1248 VGND VPWR sky130_fd_sc_hd__tapvpwrvgnd_1
XFILLER_0_72_498 VGND VGND VPWR VPWR sky130_fd_sc_hd__decap_4
XFILLER_0_60_638 VGND VGND VPWR VPWR sky130_fd_sc_hd__decap_6
XFILLER_0_32_318 VGND VGND VPWR VPWR sky130_fd_sc_hd__fill_1
XFILLER_0_44_178 VGND VGND VPWR VPWR sky130_fd_sc_hd__fill_1
X_06185_ _01039_ _01127_ _01128_ VGND VGND VPWR VPWR _01129_ sky130_fd_sc_hd__o21ai_2
XFILLER_0_4_253 VPWR VGND VPWR VGND sky130_ef_sc_hd__decap_12
X_05205_ mac_inst.i\[3\] mac_inst.i\[2\] VGND VGND VPWR VPWR _04909_ sky130_fd_sc_hd__or2_2
XFILLER_0_111_93 VPWR VGND VPWR VGND sky130_ef_sc_hd__decap_12
XTAP_TAPCELL_ROW_92_1415 VGND VPWR sky130_fd_sc_hd__tapvpwrvgnd_1
X_05136_ _04838_ _04839_ VGND VGND VPWR VPWR _04840_ sky130_fd_sc_hd__or2_2
XFILLER_0_40_351 VGND VGND VPWR VPWR sky130_fd_sc_hd__decap_3
XFILLER_0_110_272 VGND VGND VPWR VPWR sky130_fd_sc_hd__fill_2
X_09944_ _04660_ _04661_ _04658_ VGND VGND VPWR VPWR _04662_ sky130_fd_sc_hd__a21o_2
X_05067_ tanh_inst.z_\[7\] VGND VGND VPWR VPWR _04791_ sky130_fd_sc_hd__inv_2
X_09875_ tanh_inst.divider.x\[2\] _04594_ VGND VGND VPWR VPWR _04595_ sky130_fd_sc_hd__nor2_2
X_08826_ _04775_ _03570_ VGND VGND VPWR VPWR _03572_ sky130_fd_sc_hd__xnor2_2
X_05969_ _00903_ _00918_ VGND VGND VPWR VPWR _00926_ sky130_fd_sc_hd__and2_2
X_08757_ mac_inst.i\[28\] _03506_ _00969_ VGND VGND VPWR VPWR _00293_ sky130_fd_sc_hd__o21ba_2
X_08688_ _02019_ _03466_ _03467_ _02015_ VGND VGND VPWR VPWR _03468_ sky130_fd_sc_hd__a211o_2
X_07708_ tanh_inst.LOOKUP.index\[3\] _02510_ _02509_ VGND VGND VPWR VPWR _02511_ sky130_fd_sc_hd__o21a_2
X_07639_ tanh_inst.divider.x\[-18\] _02441_ VGND VGND VPWR VPWR _02443_ sky130_fd_sc_hd__xnor2_2
XFILLER_0_67_237 VPWR VGND VPWR VGND sky130_ef_sc_hd__decap_12
XTAP_TAPCELL_ROW_101_1522 VGND VPWR sky130_fd_sc_hd__tapvpwrvgnd_1
XFILLER_0_75_281 VGND VGND VPWR VPWR sky130_fd_sc_hd__decap_3
XTAP_TAPCELL_ROW_11_405 VGND VPWR sky130_fd_sc_hd__tapvpwrvgnd_1
X_09309_ _01525_ _03701_ _03711_ _01477_ VGND VGND VPWR VPWR _04045_ sky130_fd_sc_hd__o22a_2
XFILLER_0_106_545 VGND VGND VPWR VPWR sky130_fd_sc_hd__fill_2
XFILLER_0_23_329 VGND VGND VPWR VPWR sky130_fd_sc_hd__decap_6
XFILLER_0_50_148 VGND VGND VPWR VPWR sky130_fd_sc_hd__decap_4
XTAP_TAPCELL_ROW_112_1662 VGND VPWR sky130_fd_sc_hd__tapvpwrvgnd_1
X_10015_ _04791_ _04717_ _04718_ _04730_ VGND VGND VPWR VPWR _04731_ sky130_fd_sc_hd__a31o_2
XTAP_TAPCELL_ROW_19_505 VGND VPWR sky130_fd_sc_hd__tapvpwrvgnd_1
XFILLER_0_116_27 VGND VGND VPWR VPWR sky130_fd_sc_hd__fill_1
XFILLER_0_98_351 VGND VGND VPWR VPWR sky130_fd_sc_hd__decap_4
XTAP_TAPCELL_ROW_47_847 VGND VPWR sky130_fd_sc_hd__tapvpwrvgnd_1
XFILLER_0_86_524 VGND VGND VPWR VPWR sky130_fd_sc_hd__decap_8
XTAP_TAPCELL_ROW_63_1049 VGND VPWR sky130_fd_sc_hd__tapvpwrvgnd_1
XFILLER_0_54_421 VGND VGND VPWR VPWR sky130_fd_sc_hd__fill_2
XFILLER_0_26_112 VGND VGND VPWR VPWR sky130_fd_sc_hd__decap_6
XFILLER_0_39_495 VGND VGND VPWR VPWR sky130_fd_sc_hd__decap_8
XFILLER_0_109_383 VGND VGND VPWR VPWR sky130_fd_sc_hd__decap_8
XFILLER_0_54_465 VGND VGND VPWR VPWR sky130_fd_sc_hd__fill_1
XFILLER_0_6_529 VGND VGND VPWR VPWR sky130_fd_sc_hd__decap_3
XFILLER_0_81_273 VGND VGND VPWR VPWR sky130_fd_sc_hd__decap_6
XFILLER_0_14_307 VGND VGND VPWR VPWR sky130_fd_sc_hd__fill_1
XFILLER_0_112_559 VGND VGND VPWR VPWR sky130_fd_sc_hd__fill_2
XFILLER_0_1_223 VGND VGND VPWR VPWR sky130_fd_sc_hd__fill_1
X_07990_ tanh_inst.divider.y\[7\] _02438_ _02439_ _02434_ _02023_ _02052_ VGND VGND
+ VPWR VPWR _02786_ sky130_fd_sc_hd__mux4_2
XTAP_TAPCELL_ROW_74_1189 VGND VPWR sky130_fd_sc_hd__tapvpwrvgnd_1
X_06941_ tanh_inst.divider.y_\[7\] _01778_ _01784_ _01776_ VGND VGND VPWR VPWR _01785_
+ sky130_fd_sc_hd__o22a_2
XFILLER_0_5_57 VPWR VGND VPWR VGND sky130_ef_sc_hd__decap_12
X_09660_ _04380_ _04385_ VGND VGND VPWR VPWR _04386_ sky130_fd_sc_hd__nand2b_2
X_06872_ mac_y_out[29] _01469_ _01502_ _01757_ VGND VGND VPWR VPWR _00157_ sky130_fd_sc_hd__a22o_2
X_08611_ _03391_ _03392_ VGND VGND VPWR VPWR _03393_ sky130_fd_sc_hd__xnor2_2
X_09591_ tanh_inst.divider.x\[-6\] _04318_ VGND VGND VPWR VPWR _04319_ sky130_fd_sc_hd__nor2_2
X_05823_ mac_inst.z\[11\] _00787_ VGND VGND VPWR VPWR _00791_ sky130_fd_sc_hd__nand2_2
X_05754_ mac_inst.z\[4\] _00710_ _00715_ VGND VGND VPWR VPWR _00728_ sky130_fd_sc_hd__a21o_2
X_08542_ tanh_inst.divider.x\[2\] _02014_ _03324_ _03325_ _01470_ VGND VGND VPWR VPWR
+ _00259_ sky130_fd_sc_hd__o221a_2
X_08473_ _03257_ VGND VGND VPWR VPWR _03258_ sky130_fd_sc_hd__inv_2
XFILLER_0_49_237 VGND VGND VPWR VPWR sky130_fd_sc_hd__fill_1
XFILLER_0_119_125 VPWR VGND VPWR VGND sky130_ef_sc_hd__decap_12
X_07424_ _02229_ _02230_ tanh_inst.z_\[7\] VGND VGND VPWR VPWR _02232_ sky130_fd_sc_hd__o21ai_2
X_05685_ _00662_ _00663_ VGND VGND VPWR VPWR _05685_/Y sky130_fd_sc_hd__nor2_2
XFILLER_0_119_169 VPWR VGND VPWR VGND sky130_ef_sc_hd__decap_12
XFILLER_0_57_281 VGND VGND VPWR VPWR sky130_fd_sc_hd__decap_3
X_07355_ tanh_inst.divider.x\[-24\] _02103_ _02162_ VGND VGND VPWR VPWR _02164_ sky130_fd_sc_hd__nand3_2
XFILLER_0_9_389 VGND VGND VPWR VPWR sky130_fd_sc_hd__decap_3
XFILLER_0_18_679 VGND VGND VPWR VPWR sky130_fd_sc_hd__decap_3
X_06306_ _01240_ _01241_ VGND VGND VPWR VPWR _01242_ sky130_fd_sc_hd__xnor2_2
X_07286_ _02088_ _02092_ _02094_ _02090_ _04760_ _04761_ VGND VGND VPWR VPWR _02096_
+ sky130_fd_sc_hd__mux4_2
XFILLER_0_5_540 VGND VGND VPWR VPWR sky130_fd_sc_hd__decap_6
XFILLER_0_17_167 VGND VGND VPWR VPWR sky130_fd_sc_hd__fill_1
X_06237_ _01039_ _01177_ VGND VGND VPWR VPWR _01178_ sky130_fd_sc_hd__or2_2
XFILLER_0_72_284 VPWR VGND VPWR VGND sky130_ef_sc_hd__decap_12
X_09025_ tanh_inst.divider.x\[-9\] tanh_inst.divider.x\[-8\] tanh_inst.divider.x\[-7\]
+ tanh_inst.divider.x\[-6\] tanh_inst.LOOKUP.index\[0\] tanh_inst.LOOKUP.index\[1\]
+ VGND VGND VPWR VPWR _03768_ sky130_fd_sc_hd__mux4_2
XFILLER_0_32_137 VGND VGND VPWR VPWR sky130_fd_sc_hd__decap_3
XFILLER_0_103_537 VGND VGND VPWR VPWR sky130_fd_sc_hd__decap_8
X_06168_ _01111_ _01112_ VGND VGND VPWR VPWR _01113_ sky130_fd_sc_hd__xor2_2
XFILLER_0_13_373 VGND VGND VPWR VPWR sky130_fd_sc_hd__decap_4
X_06099_ tanh_inst.divider.y_\[-7\] tanh_inst.divider.y_\[-8\] tanh_inst.divider.y_\[-5\]
+ tanh_inst.divider.y_\[-6\] VGND VGND VPWR VPWR _01046_ sky130_fd_sc_hd__or4_2
XFILLER_0_111_581 VGND VGND VPWR VPWR sky130_fd_sc_hd__decap_8
X_05119_ mac_counter\[5\] _04825_ _00000_ VGND VGND VPWR VPWR _04829_ sky130_fd_sc_hd__o21ai_2
X_09927_ _04506_ _04580_ _04581_ _04644_ VGND VGND VPWR VPWR _04645_ sky130_fd_sc_hd__o211a_2
X_09858_ tanh_inst.divider.y\[2\] _04575_ VGND VGND VPWR VPWR _04578_ sky130_fd_sc_hd__nor2_2
X_08809_ tanh_inst.divider.x\[-2\] _02028_ _03508_ VGND VGND VPWR VPWR _03555_ sky130_fd_sc_hd__o21ai_2
X_09789_ tanh_inst.divider.y\[0\] _04509_ VGND VGND VPWR VPWR _04511_ sky130_fd_sc_hd__or2_2
XTAP_TAPCELL_ROW_44_806 VGND VPWR sky130_fd_sc_hd__tapvpwrvgnd_1
XFILLER_0_68_557 VGND VGND VPWR VPWR sky130_fd_sc_hd__fill_1
XTAP_TAPCELL_ROW_44_817 VGND VPWR sky130_fd_sc_hd__tapvpwrvgnd_1
XFILLER_0_83_505 VPWR VGND VPWR VGND sky130_ef_sc_hd__decap_12
XFILLER_0_83_527 VGND VGND VPWR VPWR sky130_fd_sc_hd__decap_8
XTAP_TAPCELL_ROW_24_563 VGND VPWR sky130_fd_sc_hd__tapvpwrvgnd_1
XFILLER_0_119_681 VGND VGND VPWR VPWR sky130_fd_sc_hd__fill_2
XFILLER_0_36_454 VGND VGND VPWR VPWR sky130_fd_sc_hd__fill_2
XFILLER_0_102_29 VPWR VGND VPWR VGND sky130_ef_sc_hd__decap_12
XFILLER_0_11_27 VPWR VGND VPWR VGND sky130_ef_sc_hd__decap_12
XFILLER_0_23_137 VGND VGND VPWR VPWR sky130_fd_sc_hd__decap_8
XFILLER_0_51_468 VGND VGND VPWR VPWR sky130_fd_sc_hd__decap_4
XFILLER_0_121_389 VGND VGND VPWR VPWR sky130_fd_sc_hd__decap_3
XFILLER_0_99_671 VGND VGND VPWR VPWR sky130_fd_sc_hd__fill_1
XFILLER_0_86_332 VGND VGND VPWR VPWR sky130_fd_sc_hd__decap_6
XFILLER_0_59_557 VGND VGND VPWR VPWR sky130_fd_sc_hd__decap_3
XFILLER_0_86_365 VGND VGND VPWR VPWR sky130_fd_sc_hd__decap_4
X_05470_ mac_inst.y\[11\] _00468_ VGND VGND VPWR VPWR _00470_ sky130_fd_sc_hd__nand2_2
XFILLER_0_46_218 VGND VGND VPWR VPWR sky130_fd_sc_hd__fill_1
XFILLER_0_39_281 VPWR VGND VPWR VGND sky130_ef_sc_hd__decap_12
XFILLER_0_116_139 VGND VGND VPWR VPWR sky130_fd_sc_hd__fill_1
X_07140_ _01950_ _01957_ VGND VGND VPWR VPWR _01963_ sky130_fd_sc_hd__nor2_2
XFILLER_0_82_560 VGND VGND VPWR VPWR sky130_fd_sc_hd__decap_4
XFILLER_0_27_465 VGND VGND VPWR VPWR sky130_fd_sc_hd__decap_4
X_07071_ _01088_ _01900_ _01901_ _01092_ tanh_inst.divider.z_\[-9\] VGND VGND VPWR
+ VPWR _00212_ sky130_fd_sc_hd__a32o_2
XTAP_TAPCELL_ROW_76_1218 VGND VPWR sky130_fd_sc_hd__tapvpwrvgnd_1
XTAP_TAPCELL_ROW_76_1207 VGND VPWR sky130_fd_sc_hd__tapvpwrvgnd_1
X_06022_ _00940_ _00946_ _00938_ VGND VGND VPWR VPWR _00976_ sky130_fd_sc_hd__a21bo_2
XFILLER_0_23_671 VGND VGND VPWR VPWR sky130_fd_sc_hd__fill_1
XFILLER_0_112_389 VGND VGND VPWR VPWR sky130_fd_sc_hd__fill_2
XFILLER_0_100_529 VGND VGND VPWR VPWR sky130_fd_sc_hd__decap_3
XFILLER_0_10_321 VPWR VGND VPWR VGND sky130_ef_sc_hd__decap_12
XFILLER_0_77_86 VPWR VGND VPWR VGND sky130_ef_sc_hd__decap_12
XFILLER_0_10_365 VGND VGND VPWR VPWR sky130_fd_sc_hd__decap_3
X_07973_ _02724_ _02729_ _02722_ VGND VGND VPWR VPWR _02770_ sky130_fd_sc_hd__a21o_2
X_09712_ tanh_inst.LOOKUP.index\[4\] _03896_ _04213_ VGND VGND VPWR VPWR _04436_ sky130_fd_sc_hd__o21a_2
X_06924_ tanh_inst.div_en tanh_inst.divider.z_\[6\] VGND VGND VPWR VPWR _00195_ sky130_fd_sc_hd__and2b_2
X_06855_ mac_y_out[27] _01469_ _01502_ _01742_ VGND VGND VPWR VPWR _00155_ sky130_fd_sc_hd__a22o_2
X_09643_ _04367_ _04368_ VGND VGND VPWR VPWR _04369_ sky130_fd_sc_hd__or2_2
XFILLER_0_117_81 VPWR VGND VPWR VGND sky130_ef_sc_hd__decap_12
XFILLER_0_93_85 VGND VGND VPWR VPWR sky130_fd_sc_hd__fill_1
XTAP_TAPCELL_ROW_87_1347 VGND VPWR sky130_fd_sc_hd__tapvpwrvgnd_1
X_05806_ _00748_ _00764_ VGND VGND VPWR VPWR _00775_ sky130_fd_sc_hd__and2_2
X_09574_ _04765_ _04300_ VGND VGND VPWR VPWR _04302_ sky130_fd_sc_hd__xnor2_2
X_06786_ _01516_ _01545_ VGND VGND VPWR VPWR _01682_ sky130_fd_sc_hd__nor2_2
X_08525_ tanh_inst.divider.x\[2\] _03296_ VGND VGND VPWR VPWR _03309_ sky130_fd_sc_hd__and2_2
XFILLER_0_65_505 VPWR VGND VPWR VGND sky130_ef_sc_hd__decap_12
X_05737_ mac_inst.z\[4\] _00710_ VGND VGND VPWR VPWR _00712_ sky130_fd_sc_hd__xnor2_2
XFILLER_0_77_398 VGND VGND VPWR VPWR sky130_fd_sc_hd__decap_8
XFILLER_0_65_549 VGND VGND VPWR VPWR sky130_fd_sc_hd__decap_8
X_08456_ _04791_ _03190_ _03191_ VGND VGND VPWR VPWR _03242_ sky130_fd_sc_hd__a21oi_2
X_05668_ _00647_ _00649_ VGND VGND VPWR VPWR _00650_ sky130_fd_sc_hd__nand2_2
XFILLER_0_108_618 VGND VGND VPWR VPWR sky130_fd_sc_hd__fill_1
X_07407_ _02024_ _02214_ VGND VGND VPWR VPWR _02215_ sky130_fd_sc_hd__or2_2
XFILLER_0_18_421 VGND VGND VPWR VPWR sky130_fd_sc_hd__fill_2
XFILLER_0_18_454 VGND VGND VPWR VPWR sky130_fd_sc_hd__decap_8
X_08387_ _03139_ _03144_ _03173_ VGND VGND VPWR VPWR _03174_ sky130_fd_sc_hd__a21oi_2
X_07338_ _02028_ _02145_ _02029_ _02026_ VGND VGND VPWR VPWR _02147_ sky130_fd_sc_hd__o211a_2
XFILLER_0_73_582 VGND VGND VPWR VPWR sky130_fd_sc_hd__fill_1
XTAP_TAPCELL_ROW_21_522 VGND VPWR sky130_fd_sc_hd__tapvpwrvgnd_1
X_05599_ _00586_ VGND VGND VPWR VPWR _00587_ sky130_fd_sc_hd__inv_2
XTAP_TAPCELL_ROW_98_1487 VGND VPWR sky130_fd_sc_hd__tapvpwrvgnd_1
X_07269_ tanh_inst.divider.y\[-1\] _02028_ _02029_ VGND VGND VPWR VPWR _02079_ sky130_fd_sc_hd__o21a_2
XFILLER_0_60_265 VGND VGND VPWR VPWR sky130_fd_sc_hd__fill_1
XFILLER_0_103_345 VGND VGND VPWR VPWR sky130_fd_sc_hd__fill_1
XFILLER_0_103_334 VGND VGND VPWR VPWR sky130_fd_sc_hd__fill_2
X_09008_ _03749_ _03750_ VGND VGND VPWR VPWR _03751_ sky130_fd_sc_hd__and2_2
X_10280_ clknet_leaf_22_clk _00137_ VGND VGND VPWR VPWR tanh_inst.z_\[-15\] sky130_fd_sc_hd__dfxtp_2
XFILLER_0_13_181 VPWR VGND VPWR VGND sky130_ef_sc_hd__decap_12
XTAP_TAPCELL_ROW_29_622 VGND VPWR sky130_fd_sc_hd__tapvpwrvgnd_1
XFILLER_0_68_321 VPWR VGND VPWR VGND sky130_ef_sc_hd__decap_12
XTAP_TAPCELL_ROW_57_975 VGND VPWR sky130_fd_sc_hd__tapvpwrvgnd_1
XTAP_TAPCELL_ROW_107_1594 VGND VPWR sky130_fd_sc_hd__tapvpwrvgnd_1
XFILLER_0_95_140 VPWR VGND VPWR VGND sky130_ef_sc_hd__decap_12
XFILLER_0_68_365 VGND VGND VPWR VPWR sky130_fd_sc_hd__decap_4
XTAP_TAPCELL_ROW_1_280 VGND VPWR sky130_fd_sc_hd__tapvpwrvgnd_1
XFILLER_0_83_313 VGND VGND VPWR VPWR sky130_fd_sc_hd__fill_2
XFILLER_0_22_15 VPWR VGND VPWR VGND sky130_ef_sc_hd__decap_12
XTAP_TAPCELL_ROW_120_1761 VGND VPWR sky130_fd_sc_hd__tapvpwrvgnd_1
XFILLER_0_113_39 VPWR VGND VPWR VGND sky130_ef_sc_hd__decap_12
XFILLER_0_83_357 VGND VGND VPWR VPWR sky130_fd_sc_hd__decap_3
XTAP_TAPCELL_ROW_60_1008 VGND VPWR sky130_fd_sc_hd__tapvpwrvgnd_1
XFILLER_0_83_379 VGND VGND VPWR VPWR sky130_fd_sc_hd__decap_3
XFILLER_0_107_673 VGND VGND VPWR VPWR sky130_fd_sc_hd__fill_2
XFILLER_0_3_329 VGND VGND VPWR VPWR sky130_fd_sc_hd__decap_6
X_10478_ clknet_leaf_34_clk _00335_ _00079_ VGND VGND VPWR VPWR tanh_counter\[1\]
+ sky130_fd_sc_hd__dfrtp_2
XFILLER_0_121_153 VPWR VGND VPWR VGND sky130_ef_sc_hd__decap_12
XFILLER_0_121_197 VPWR VGND VPWR VGND sky130_ef_sc_hd__decap_12
XTAP_TAPCELL_ROW_71_1148 VGND VPWR sky130_fd_sc_hd__tapvpwrvgnd_1
XTAP_TAPCELL_ROW_9_380 VGND VPWR sky130_fd_sc_hd__tapvpwrvgnd_1
XPHY_EDGE_ROW_10_Right_10 VGND VGND VPWR VPWR sky130_fd_sc_hd__decap_3
X_06640_ _01539_ _01540_ _01538_ VGND VGND VPWR VPWR _01552_ sky130_fd_sc_hd__o21ai_2
XFILLER_0_87_630 VGND VGND VPWR VPWR sky130_fd_sc_hd__decap_3
XFILLER_0_63_77 VGND VGND VPWR VPWR sky130_fd_sc_hd__decap_3
X_06571_ tanh_inst.LOOKUP.index\[4\] tanh_inst.LOOKUP.index\[3\] tanh_inst.LOOKUP.index\[2\]
+ VGND VGND VPWR VPWR _01486_ sky130_fd_sc_hd__or3b_2
Xclkbuf_leaf_44_clk clknet_2_0__leaf_clk VGND VGND VPWR VPWR clknet_leaf_44_clk sky130_fd_sc_hd__clkbuf_8
XFILLER_0_47_505 VPWR VGND VPWR VGND sky130_ef_sc_hd__decap_12
X_09290_ _04024_ _04025_ VGND VGND VPWR VPWR _04026_ sky130_fd_sc_hd__nor2_2
XFILLER_0_74_313 VGND VGND VPWR VPWR sky130_fd_sc_hd__fill_1
XFILLER_0_59_376 VPWR VGND VPWR VGND sky130_ef_sc_hd__decap_12
X_08310_ _03047_ _03056_ _03098_ VGND VGND VPWR VPWR _03099_ sky130_fd_sc_hd__nand3_2
X_05522_ mac_inst.y\[15\] _00515_ VGND VGND VPWR VPWR _00518_ sky130_fd_sc_hd__or2_2
XTAP_TAPCELL_ROW_82_1288 VGND VPWR sky130_fd_sc_hd__tapvpwrvgnd_1
X_05453_ _00431_ _00442_ VGND VGND VPWR VPWR _00454_ sky130_fd_sc_hd__and2_2
X_08241_ _03029_ _03030_ VGND VGND VPWR VPWR _03031_ sky130_fd_sc_hd__or2_2
XFILLER_0_27_240 VGND VGND VPWR VPWR sky130_fd_sc_hd__decap_8
X_08172_ _02938_ _02963_ VGND VGND VPWR VPWR _02964_ sky130_fd_sc_hd__or2_2
XFILLER_0_55_593 VGND VGND VPWR VPWR sky130_fd_sc_hd__fill_2
XFILLER_0_7_679 VGND VGND VPWR VPWR sky130_fd_sc_hd__fill_1
X_05384_ _04909_ _04999_ VGND VGND VPWR VPWR _00390_ sky130_fd_sc_hd__or2_2
X_07123_ _01933_ _01940_ _01946_ VGND VGND VPWR VPWR _01948_ sky130_fd_sc_hd__a21oi_2
XFILLER_0_6_189 VGND VGND VPWR VPWR sky130_fd_sc_hd__decap_6
X_07054_ tanh_inst.divider.z_\[-10\] _01879_ _01885_ VGND VGND VPWR VPWR _01886_ sky130_fd_sc_hd__and3_2
XFILLER_0_70_585 VGND VGND VPWR VPWR sky130_fd_sc_hd__decap_3
XFILLER_0_42_265 VPWR VGND VPWR VGND sky130_ef_sc_hd__decap_12
XFILLER_0_88_96 VGND VGND VPWR VPWR sky130_fd_sc_hd__fill_1
XFILLER_0_88_85 VGND VGND VPWR VPWR sky130_fd_sc_hd__decap_3
XFILLER_0_88_74 VGND VGND VPWR VPWR sky130_fd_sc_hd__fill_1
XFILLER_0_63_3 VPWR VGND VPWR VGND sky130_ef_sc_hd__decap_12
X_06005_ mac_inst.i\[8\] _00958_ VGND VGND VPWR VPWR _00959_ sky130_fd_sc_hd__nand2_2
XFILLER_0_11_696 VGND VGND VPWR VPWR sky130_fd_sc_hd__decap_6
XFILLER_0_10_195 VGND VGND VPWR VPWR sky130_fd_sc_hd__fill_1
X_07956_ tanh_inst.divider.x\[-11\] _02752_ VGND VGND VPWR VPWR _02753_ sky130_fd_sc_hd__nand2_2
X_06907_ tanh_inst.div_en tanh_inst.divider.z_\[-11\] VGND VGND VPWR VPWR _00178_
+ sky130_fd_sc_hd__and2b_2
XPHY_EDGE_ROW_106_Right_106 VGND VGND VPWR VPWR sky130_fd_sc_hd__decap_3
XFILLER_0_97_416 VGND VGND VPWR VPWR sky130_fd_sc_hd__decap_4
XFILLER_0_97_405 VGND VGND VPWR VPWR sky130_fd_sc_hd__decap_4
XFILLER_0_69_107 VGND VGND VPWR VPWR sky130_fd_sc_hd__decap_4
X_07887_ _02649_ _02651_ _02648_ VGND VGND VPWR VPWR _02686_ sky130_fd_sc_hd__o21a_2
X_06838_ tanh_inst.z_\[7\] _01667_ _01485_ VGND VGND VPWR VPWR _01728_ sky130_fd_sc_hd__mux2_1
X_09626_ tanh_inst.LOOKUP.index\[4\] _03763_ _04213_ VGND VGND VPWR VPWR _04353_ sky130_fd_sc_hd__o21a_2
X_06769_ tanh_inst.z_\[7\] _01666_ VGND VGND VPWR VPWR _01667_ sky130_fd_sc_hd__nor2_2
X_09557_ _04273_ _04274_ _04285_ _04791_ VGND VGND VPWR VPWR _04286_ sky130_fd_sc_hd__o22a_2
XTAP_TAPCELL_ROW_54_934 VGND VPWR sky130_fd_sc_hd__tapvpwrvgnd_1
X_09488_ _04166_ _04170_ _04217_ _02019_ VGND VGND VPWR VPWR _04219_ sky130_fd_sc_hd__a31oi_2
Xclkbuf_leaf_35_clk clknet_2_1__leaf_clk VGND VGND VPWR VPWR clknet_leaf_35_clk sky130_fd_sc_hd__clkbuf_8
X_08508_ tanh_inst.divider.x\[1\] _03277_ _03291_ VGND VGND VPWR VPWR _03292_ sky130_fd_sc_hd__a21oi_2
XFILLER_0_65_335 VGND VGND VPWR VPWR sky130_fd_sc_hd__fill_1
X_08439_ _03131_ _03164_ _03165_ VGND VGND VPWR VPWR _03225_ sky130_fd_sc_hd__a21o_2
XFILLER_0_18_251 VGND VGND VPWR VPWR sky130_fd_sc_hd__fill_1
XTAP_TAPCELL_ROW_34_691 VGND VPWR sky130_fd_sc_hd__tapvpwrvgnd_1
X_10401_ clknet_2_0__leaf_clk _00258_ VGND VGND VPWR VPWR tanh_inst.divider.x\[1\]
+ sky130_fd_sc_hd__dfxtp_2
XFILLER_0_103_131 VGND VGND VPWR VPWR sky130_fd_sc_hd__fill_2
X_10332_ clknet_leaf_17_clk _00189_ VGND VGND VPWR VPWR tanh_out[24] sky130_fd_sc_hd__dfxtp_2
XFILLER_0_61_585 VGND VGND VPWR VPWR sky130_fd_sc_hd__decap_3
XFILLER_0_33_287 VGND VGND VPWR VPWR sky130_fd_sc_hd__fill_1
XFILLER_0_33_298 VGND VGND VPWR VPWR sky130_fd_sc_hd__decap_4
X_10263_ clknet_leaf_31_clk mac_inst.x\[25\] _00000_ VGND VGND VPWR VPWR mac_x_out[25]
+ sky130_fd_sc_hd__dfrtp_2
X_10194_ x_in[20] _00000_ VGND VGND VPWR VPWR mac_inst.x\[20\] sky130_fd_sc_hd__dlxtn_1
XFILLER_0_17_15 VPWR VGND VPWR VGND sky130_ef_sc_hd__decap_12
XTAP_TAPCELL_ROW_109_1623 VGND VPWR sky130_fd_sc_hd__tapvpwrvgnd_1
XFILLER_0_88_405 VGND VGND VPWR VPWR sky130_fd_sc_hd__fill_1
XFILLER_0_88_438 VGND VGND VPWR VPWR sky130_fd_sc_hd__decap_4
XFILLER_0_69_641 VGND VGND VPWR VPWR sky130_fd_sc_hd__fill_1
Xclkbuf_leaf_26_clk clknet_2_3__leaf_clk VGND VGND VPWR VPWR clknet_leaf_26_clk sky130_fd_sc_hd__clkbuf_8
XFILLER_0_69_685 VGND VGND VPWR VPWR sky130_fd_sc_hd__fill_2
XFILLER_0_68_173 VPWR VGND VPWR VGND sky130_ef_sc_hd__decap_12
XFILLER_0_68_162 VGND VGND VPWR VPWR sky130_fd_sc_hd__decap_4
XFILLER_0_84_633 VGND VGND VPWR VPWR sky130_fd_sc_hd__fill_1
XFILLER_0_83_121 VGND VGND VPWR VPWR sky130_fd_sc_hd__fill_2
XFILLER_0_29_549 VGND VGND VPWR VPWR sky130_fd_sc_hd__decap_8
XFILLER_0_83_198 VGND VGND VPWR VPWR sky130_fd_sc_hd__decap_8
XFILLER_0_64_390 VGND VGND VPWR VPWR sky130_fd_sc_hd__decap_6
XFILLER_0_24_210 VPWR VGND VPWR VGND sky130_ef_sc_hd__decap_12
XFILLER_0_12_427 VGND VGND VPWR VPWR sky130_fd_sc_hd__decap_8
XFILLER_0_12_405 VGND VGND VPWR VPWR sky130_fd_sc_hd__decap_4
XFILLER_0_3_137 VPWR VGND VPWR VGND sky130_ef_sc_hd__decap_12
XFILLER_0_24_265 VPWR VGND VPWR VGND sky130_ef_sc_hd__decap_12
XFILLER_0_110_602 VGND VGND VPWR VPWR sky130_fd_sc_hd__decap_8
XFILLER_0_12_449 VGND VGND VPWR VPWR sky130_fd_sc_hd__decap_4
XFILLER_0_110_635 VGND VGND VPWR VPWR sky130_fd_sc_hd__decap_3
X_08790_ _02026_ _03535_ VGND VGND VPWR VPWR _03536_ sky130_fd_sc_hd__nand2_2
X_07810_ _02019_ _02599_ _02610_ VGND VGND VPWR VPWR _02611_ sky130_fd_sc_hd__a21bo_2
XTAP_TAPCELL_ROW_4_309 VGND VPWR sky130_fd_sc_hd__tapvpwrvgnd_1
X_07741_ _02447_ _02495_ _02496_ VGND VGND VPWR VPWR _02543_ sky130_fd_sc_hd__o21ai_2
XFILLER_0_74_76 VGND VGND VPWR VPWR sky130_fd_sc_hd__decap_8
XTAP_TAPCELL_ROW_84_1317 VGND VPWR sky130_fd_sc_hd__tapvpwrvgnd_1
XTAP_TAPCELL_ROW_84_1306 VGND VPWR sky130_fd_sc_hd__tapvpwrvgnd_1
X_07672_ tanh_inst.divider.x\[-18\] _02475_ VGND VGND VPWR VPWR _02476_ sky130_fd_sc_hd__and2_2
X_09411_ _04142_ _04143_ VGND VGND VPWR VPWR _04144_ sky130_fd_sc_hd__nand2_2
X_06623_ _01487_ _01505_ _04791_ VGND VGND VPWR VPWR _01536_ sky130_fd_sc_hd__o21ai_2
Xclkbuf_leaf_17_clk clknet_2_3__leaf_clk VGND VGND VPWR VPWR clknet_leaf_17_clk sky130_fd_sc_hd__clkbuf_8
XFILLER_0_94_419 VGND VGND VPWR VPWR sky130_fd_sc_hd__fill_1
XFILLER_0_90_53 VGND VGND VPWR VPWR sky130_fd_sc_hd__fill_1
X_06554_ current_state\[0\] _01467_ _01468_ current_state\[1\] VGND VGND VPWR VPWR
+ _01469_ sky130_fd_sc_hd__nor4b_2
X_09342_ _01525_ _03759_ _03769_ _01477_ VGND VGND VPWR VPWR _04077_ sky130_fd_sc_hd__o22a_2
XTAP_TAPCELL_ROW_51_904 VGND VPWR sky130_fd_sc_hd__tapvpwrvgnd_1
XFILLER_0_59_195 VGND VGND VPWR VPWR sky130_fd_sc_hd__decap_6
X_05505_ mac_inst.y\[14\] _00500_ VGND VGND VPWR VPWR _00502_ sky130_fd_sc_hd__or2_2
X_06485_ _01392_ _01398_ _01390_ VGND VGND VPWR VPWR _01407_ sky130_fd_sc_hd__a21bo_2
XFILLER_0_62_305 VGND VGND VPWR VPWR sky130_fd_sc_hd__decap_3
X_09273_ _04008_ _04009_ VGND VGND VPWR VPWR _04010_ sky130_fd_sc_hd__xnor2_2
XFILLER_0_117_256 VGND VGND VPWR VPWR sky130_fd_sc_hd__decap_6
XTAP_TAPCELL_ROW_31_650 VGND VPWR sky130_fd_sc_hd__tapvpwrvgnd_1
X_05436_ _00436_ _00438_ VGND VGND VPWR VPWR _05436_/X sky130_fd_sc_hd__xor2_2
X_08224_ _02959_ _02968_ _03014_ VGND VGND VPWR VPWR _03015_ sky130_fd_sc_hd__o21ai_2
XFILLER_0_99_51 VGND VGND VPWR VPWR sky130_fd_sc_hd__decap_4
X_05367_ _04782_ _04861_ VGND VGND VPWR VPWR _00374_ sky130_fd_sc_hd__nor2_2
XFILLER_0_43_541 VGND VGND VPWR VPWR sky130_fd_sc_hd__decap_8
X_08155_ tanh_inst.divider.x\[-7\] _02946_ VGND VGND VPWR VPWR _02948_ sky130_fd_sc_hd__nor2_2
X_07106_ _01034_ _01141_ VGND VGND VPWR VPWR _01932_ sky130_fd_sc_hd__or2_2
XTAP_TAPCELL_ROW_95_1446 VGND VPWR sky130_fd_sc_hd__tapvpwrvgnd_1
XFILLER_0_43_585 VGND VGND VPWR VPWR sky130_fd_sc_hd__fill_1
X_08086_ _02876_ _02879_ tanh_inst.z_\[7\] VGND VGND VPWR VPWR _02880_ sky130_fd_sc_hd__o21ai_2
X_05298_ _04915_ _04917_ mac_inst.i\[0\] VGND VGND VPWR VPWR _04998_ sky130_fd_sc_hd__mux2_1
XFILLER_0_101_635 VGND VGND VPWR VPWR sky130_fd_sc_hd__decap_8
X_07037_ _01862_ _01869_ tanh_inst.divider.z_\[-12\] VGND VGND VPWR VPWR _01871_ sky130_fd_sc_hd__a21o_2
X_08988_ _02022_ _03726_ _03730_ _02053_ VGND VGND VPWR VPWR _03731_ sky130_fd_sc_hd__a211o_2
X_07939_ _02645_ _02736_ tanh_inst.z_\[7\] VGND VGND VPWR VPWR _02737_ sky130_fd_sc_hd__a21o_2
XTAP_TAPCELL_ROW_39_750 VGND VPWR sky130_fd_sc_hd__tapvpwrvgnd_1
XFILLER_0_97_257 VGND VGND VPWR VPWR sky130_fd_sc_hd__decap_6
XFILLER_0_85_408 VGND VGND VPWR VPWR sky130_fd_sc_hd__fill_1
X_09609_ tanh_inst.divider.y\[-5\] _04334_ VGND VGND VPWR VPWR _04336_ sky130_fd_sc_hd__nor2_2
XTAP_TAPCELL_ROW_104_1564 VGND VPWR sky130_fd_sc_hd__tapvpwrvgnd_1
XFILLER_0_38_357 VGND VGND VPWR VPWR sky130_fd_sc_hd__decap_6
XFILLER_0_93_496 VGND VGND VPWR VPWR sky130_fd_sc_hd__decap_8
XFILLER_0_65_198 VGND VGND VPWR VPWR sky130_fd_sc_hd__decap_6
XFILLER_0_65_187 VGND VGND VPWR VPWR sky130_fd_sc_hd__decap_4
XFILLER_0_110_29 VPWR VGND VPWR VGND sky130_ef_sc_hd__decap_12
XFILLER_0_34_596 VGND VGND VPWR VPWR sky130_fd_sc_hd__decap_4
X_10315_ clknet_leaf_16_clk _00172_ VGND VGND VPWR VPWR tanh_out[7] sky130_fd_sc_hd__dfxtp_2
XFILLER_0_21_279 VGND VGND VPWR VPWR sky130_fd_sc_hd__fill_1
XFILLER_0_119_27 VPWR VGND VPWR VGND sky130_ef_sc_hd__decap_12
X_10246_ clknet_leaf_30_clk mac_inst.x\[8\] _00000_ VGND VGND VPWR VPWR mac_x_out[8]
+ sky130_fd_sc_hd__dfrtp_2
X_10177_ x_in[3] _00000_ VGND VGND VPWR VPWR mac_inst.x\[3\] sky130_fd_sc_hd__dlxtn_1
XFILLER_0_88_246 VGND VGND VPWR VPWR sky130_fd_sc_hd__decap_6
XFILLER_0_76_408 VGND VGND VPWR VPWR sky130_fd_sc_hd__fill_2
XFILLER_0_76_419 VGND VGND VPWR VPWR sky130_fd_sc_hd__fill_1
XFILLER_0_44_79 VGND VGND VPWR VPWR sky130_fd_sc_hd__decap_4
XFILLER_0_56_110 VGND VGND VPWR VPWR sky130_fd_sc_hd__decap_8
XTAP_TAPCELL_ROW_17_477 VGND VPWR sky130_fd_sc_hd__tapvpwrvgnd_1
XFILLER_0_29_335 VGND VGND VPWR VPWR sky130_fd_sc_hd__fill_1
XFILLER_0_44_305 VGND VGND VPWR VPWR sky130_fd_sc_hd__decap_3
X_06270_ tanh_inst.divider.y_\[-16\] _01208_ VGND VGND VPWR VPWR _01209_ sky130_fd_sc_hd__nand2_2
XFILLER_0_121_3 VPWR VGND VPWR VGND sky130_ef_sc_hd__decap_12
XFILLER_0_71_113 VPWR VGND VPWR VGND sky130_ef_sc_hd__decap_12
X_05221_ mac_inst.i\[3\] _04902_ _04910_ _04924_ VGND VGND VPWR VPWR _04925_ sky130_fd_sc_hd__a211o_2
XFILLER_0_25_552 VGND VGND VPWR VPWR sky130_fd_sc_hd__decap_8
XFILLER_0_4_435 VGND VGND VPWR VPWR sky130_fd_sc_hd__decap_8
X_05152_ mac_inst.x\[16\] _04852_ _04853_ VGND VGND VPWR VPWR _04856_ sky130_fd_sc_hd__a21oi_2
XFILLER_0_40_533 VGND VGND VPWR VPWR sky130_fd_sc_hd__decap_8
XFILLER_0_110_421 VGND VGND VPWR VPWR sky130_fd_sc_hd__decap_4
Xclkbuf_leaf_6_clk clknet_2_2__leaf_clk VGND VGND VPWR VPWR clknet_leaf_6_clk sky130_fd_sc_hd__clkbuf_8
X_09960_ _02015_ _04676_ _04677_ _01470_ VGND VGND VPWR VPWR _00325_ sky130_fd_sc_hd__o211a_2
X_05083_ tanh_counter\[3\] tanh_counter\[2\] _04804_ VGND VGND VPWR VPWR _04806_ sky130_fd_sc_hd__and3_2
X_08911_ _03647_ _03648_ _03651_ _03654_ tanh_inst.LOOKUP.index\[2\] tanh_inst.LOOKUP.index\[3\]
+ VGND VGND VPWR VPWR _03656_ sky130_fd_sc_hd__mux4_2
XFILLER_0_0_685 VGND VGND VPWR VPWR sky130_fd_sc_hd__decap_4
X_09891_ tanh_inst.divider.y\[2\] _02014_ _04610_ _01470_ VGND VGND VPWR VPWR _00323_
+ sky130_fd_sc_hd__o211a_2
X_08842_ _03509_ _03517_ _03519_ _03520_ _04761_ _04760_ VGND VGND VPWR VPWR _03587_
+ sky130_fd_sc_hd__mux4_2
XTAP_TAPCELL_ROW_90_1387 VGND VPWR sky130_fd_sc_hd__tapvpwrvgnd_1
XFILLER_0_109_93 VPWR VGND VPWR VGND sky130_ef_sc_hd__decap_12
X_08773_ tanh_inst.divider.x\[-14\] _02028_ _03508_ VGND VGND VPWR VPWR _03519_ sky130_fd_sc_hd__o21a_2
X_05985_ _00938_ _00939_ VGND VGND VPWR VPWR _00940_ sky130_fd_sc_hd__and2_2
X_07724_ tanh_inst.z_\[7\] _02526_ VGND VGND VPWR VPWR _02527_ sky130_fd_sc_hd__nand2_2
XFILLER_0_79_202 VGND VGND VPWR VPWR sky130_fd_sc_hd__decap_8
XFILLER_0_26_3 VPWR VGND VPWR VGND sky130_ef_sc_hd__decap_12
X_07655_ _02456_ _02458_ VGND VGND VPWR VPWR _02459_ sky130_fd_sc_hd__xor2_2
XFILLER_0_79_279 VGND VGND VPWR VPWR sky130_fd_sc_hd__fill_1
X_06606_ tanh_inst.LOOKUP.index\[4\] tanh_inst.LOOKUP.index\[2\] _01472_ _01485_ VGND
+ VGND VPWR VPWR _01519_ sky130_fd_sc_hd__o31a_2
X_07586_ _02389_ _02390_ _02023_ VGND VGND VPWR VPWR _02391_ sky130_fd_sc_hd__mux2_1
X_09325_ _02671_ _04059_ VGND VGND VPWR VPWR _04060_ sky130_fd_sc_hd__or2_2
X_06537_ _04793_ _01453_ VGND VGND VPWR VPWR _01454_ sky130_fd_sc_hd__and2_2
XFILLER_0_63_614 VGND VGND VPWR VPWR sky130_fd_sc_hd__fill_2
XFILLER_0_47_132 VGND VGND VPWR VPWR sky130_fd_sc_hd__fill_1
X_06468_ tanh_inst.divider.y_\[0\] _01389_ VGND VGND VPWR VPWR _01391_ sky130_fd_sc_hd__or2_2
X_09256_ _03991_ _03992_ VGND VGND VPWR VPWR _03993_ sky130_fd_sc_hd__and2b_2
XFILLER_0_47_187 VGND VGND VPWR VPWR sky130_fd_sc_hd__decap_4
XFILLER_0_118_587 VGND VGND VPWR VPWR sky130_fd_sc_hd__fill_1
XFILLER_0_7_273 VGND VGND VPWR VPWR sky130_fd_sc_hd__decap_6
X_05419_ mac_inst.y\[7\] _00422_ VGND VGND VPWR VPWR _00423_ sky130_fd_sc_hd__nand2_2
X_08207_ tanh_inst.divider.x\[-6\] _02014_ _02998_ _01470_ VGND VGND VPWR VPWR _00251_
+ sky130_fd_sc_hd__o211a_2
XFILLER_0_121_708 VPWR VGND VPWR VGND sky130_ef_sc_hd__decap_12
X_06399_ _01326_ _01327_ VGND VGND VPWR VPWR _01328_ sky130_fd_sc_hd__nand2_2
XFILLER_0_105_237 VGND VGND VPWR VPWR sky130_fd_sc_hd__decap_6
X_09187_ _03877_ _03879_ _03924_ VGND VGND VPWR VPWR _03926_ sky130_fd_sc_hd__o21ai_2
XFILLER_0_90_477 VPWR VGND VPWR VGND sky130_ef_sc_hd__decap_12
XFILLER_0_70_190 VGND VGND VPWR VPWR sky130_fd_sc_hd__decap_6
X_08138_ _02893_ _02902_ _02930_ VGND VGND VPWR VPWR _02931_ sky130_fd_sc_hd__a21oi_2
XFILLER_0_43_393 VGND VGND VPWR VPWR sky130_fd_sc_hd__decap_6
X_08069_ tanh_inst.divider.x\[-10\] _02824_ _02830_ VGND VGND VPWR VPWR _02864_ sky130_fd_sc_hd__a21bo_2
XFILLER_0_31_555 VGND VGND VPWR VPWR sky130_fd_sc_hd__decap_4
XFILLER_0_101_443 VGND VGND VPWR VPWR sky130_fd_sc_hd__decap_4
X_10100_ clknet_leaf_10_clk _00117_ VGND VGND VPWR VPWR tanh_inst.divider.y_\[7\]
+ sky130_fd_sc_hd__dfxtp_2
X_10031_ _04743_ _04745_ VGND VGND VPWR VPWR _04746_ sky130_fd_sc_hd__xnor2_2
XFILLER_0_98_533 VGND VGND VPWR VPWR sky130_fd_sc_hd__fill_2
XFILLER_0_14_27 VGND VGND VPWR VPWR sky130_fd_sc_hd__fill_1
XFILLER_0_66_441 VPWR VGND VPWR VGND sky130_ef_sc_hd__decap_12
XTAP_TAPCELL_ROW_65_1080 VGND VPWR sky130_fd_sc_hd__tapvpwrvgnd_1
XTAP_TAPCELL_ROW_14_436 VGND VPWR sky130_fd_sc_hd__tapvpwrvgnd_1
XFILLER_0_109_565 VGND VGND VPWR VPWR sky130_fd_sc_hd__fill_1
XFILLER_0_109_554 VGND VGND VPWR VPWR sky130_fd_sc_hd__decap_6
XFILLER_0_93_271 VGND VGND VPWR VPWR sky130_fd_sc_hd__fill_1
XFILLER_0_81_400 VGND VGND VPWR VPWR sky130_fd_sc_hd__fill_1
XTAP_TAPCELL_ROW_42_789 VGND VPWR sky130_fd_sc_hd__tapvpwrvgnd_1
XFILLER_0_53_113 VPWR VGND VPWR VGND sky130_ef_sc_hd__decap_12
XFILLER_0_109_576 VGND VGND VPWR VPWR sky130_fd_sc_hd__decap_3
XFILLER_0_30_15 VPWR VGND VPWR VGND sky130_ef_sc_hd__decap_12
XTAP_TAPCELL_ROW_117_1722 VGND VPWR sky130_fd_sc_hd__tapvpwrvgnd_1
XFILLER_0_22_511 VGND VGND VPWR VPWR sky130_fd_sc_hd__decap_3
XFILLER_0_112_719 VGND VGND VPWR VPWR sky130_fd_sc_hd__decap_4
XFILLER_0_1_405 VGND VGND VPWR VPWR sky130_fd_sc_hd__decap_6
XFILLER_0_22_533 VGND VGND VPWR VPWR sky130_fd_sc_hd__decap_4
XFILLER_0_1_438 VGND VGND VPWR VPWR sky130_fd_sc_hd__decap_4
XFILLER_0_22_577 VGND VGND VPWR VPWR sky130_fd_sc_hd__decap_8
X_10229_ clknet_leaf_29_clk mac_inst.y\[23\] _00000_ VGND VGND VPWR VPWR mac_y_out[23]
+ sky130_fd_sc_hd__dfrtp_2
XFILLER_0_55_23 VPWR VGND VPWR VGND sky130_ef_sc_hd__decap_12
XTAP_TAPCELL_ROW_68_1109 VGND VPWR sky130_fd_sc_hd__tapvpwrvgnd_1
X_05770_ _00729_ _00733_ mac_inst.z\[31\] VGND VGND VPWR VPWR _00742_ sky130_fd_sc_hd__a21o_2
XFILLER_0_89_588 VPWR VGND VPWR VGND sky130_ef_sc_hd__decap_12
XFILLER_0_9_505 VGND VGND VPWR VPWR sky130_fd_sc_hd__decap_8
XPHY_EDGE_ROW_8_Right_8 VGND VGND VPWR VPWR sky130_fd_sc_hd__decap_3
X_07440_ tanh_inst.divider.y\[7\] _02114_ _04760_ VGND VGND VPWR VPWR _02248_ sky130_fd_sc_hd__mux2_1
X_07371_ _02178_ _02179_ tanh_inst.LOOKUP.index\[2\] VGND VGND VPWR VPWR _02180_ sky130_fd_sc_hd__mux2_1
XFILLER_0_29_143 VGND VGND VPWR VPWR sky130_fd_sc_hd__fill_1
X_06322_ _01233_ _01234_ _01243_ VGND VGND VPWR VPWR _01257_ sky130_fd_sc_hd__and3_2
XFILLER_0_17_305 VPWR VGND VPWR VGND sky130_ef_sc_hd__decap_12
X_09110_ _03631_ _03633_ tanh_inst.LOOKUP.index\[2\] VGND VGND VPWR VPWR _03851_ sky130_fd_sc_hd__mux2_1
X_09041_ _03514_ _03566_ _02024_ VGND VGND VPWR VPWR _03783_ sky130_fd_sc_hd__mux2_1
XFILLER_0_5_722 VGND VGND VPWR VPWR sky130_fd_sc_hd__fill_2
XFILLER_0_17_349 VPWR VGND VPWR VGND sky130_ef_sc_hd__decap_12
X_06253_ _01039_ _01192_ _01191_ _01190_ VGND VGND VPWR VPWR _01193_ sky130_fd_sc_hd__o211a_2
XTAP_TAPCELL_ROW_79_1249 VGND VPWR sky130_fd_sc_hd__tapvpwrvgnd_1
XFILLER_0_4_221 VPWR VGND VPWR VGND sky130_ef_sc_hd__decap_12
X_06184_ _04776_ _01121_ _01124_ _01031_ VGND VGND VPWR VPWR _01128_ sky130_fd_sc_hd__o22a_2
XFILLER_0_4_265 VPWR VGND VPWR VGND sky130_ef_sc_hd__decap_12
XFILLER_0_13_533 VGND VGND VPWR VPWR sky130_fd_sc_hd__fill_1
X_05204_ mac_inst.i\[3\] mac_inst.i\[2\] VGND VGND VPWR VPWR _04908_ sky130_fd_sc_hd__nor2_2
XFILLER_0_25_382 VGND VGND VPWR VPWR sky130_fd_sc_hd__fill_1
XFILLER_0_25_393 VGND VGND VPWR VPWR sky130_fd_sc_hd__decap_3
XTAP_TAPCELL_ROW_92_1416 VGND VPWR sky130_fd_sc_hd__tapvpwrvgnd_1
X_05135_ mac_inst.i\[13\] mac_inst.i\[12\] mac_inst.i\[15\] mac_inst.i\[14\] VGND
+ VGND VPWR VPWR _04839_ sky130_fd_sc_hd__or4_2
XFILLER_0_40_363 VGND VGND VPWR VPWR sky130_fd_sc_hd__fill_1
XFILLER_0_96_41 VGND VGND VPWR VPWR sky130_fd_sc_hd__decap_4
XFILLER_0_110_251 VGND VGND VPWR VPWR sky130_fd_sc_hd__fill_1
X_05066_ mac_inst.x\[30\] VGND VGND VPWR VPWR _04790_ sky130_fd_sc_hd__inv_2
X_09943_ _04599_ _04623_ _04659_ _04604_ _04621_ VGND VGND VPWR VPWR _04661_ sky130_fd_sc_hd__o221a_2
XPHY_EDGE_ROW_39_Right_39 VGND VGND VPWR VPWR sky130_fd_sc_hd__decap_3
X_09874_ _04592_ _04593_ VGND VGND VPWR VPWR _04594_ sky130_fd_sc_hd__or2_2
X_08825_ _04775_ _03570_ VGND VGND VPWR VPWR _03571_ sky130_fd_sc_hd__or2_2
XFILLER_0_68_706 VGND VGND VPWR VPWR sky130_fd_sc_hd__decap_8
X_05968_ _04803_ _00923_ VGND VGND VPWR VPWR _00925_ sky130_fd_sc_hd__xnor2_2
X_08756_ _03505_ _03506_ VGND VGND VPWR VPWR _00292_ sky130_fd_sc_hd__nor2_2
XFILLER_0_95_503 VGND VGND VPWR VPWR sky130_fd_sc_hd__fill_1
XFILLER_0_67_205 VGND VGND VPWR VPWR sky130_fd_sc_hd__fill_2
X_08687_ _02019_ _03444_ VGND VGND VPWR VPWR _03467_ sky130_fd_sc_hd__nor2_2
X_05899_ _00829_ _00842_ _00857_ _00834_ _00843_ VGND VGND VPWR VPWR _00862_ sky130_fd_sc_hd__o221a_2
X_07707_ _02311_ _02314_ tanh_inst.LOOKUP.index\[2\] VGND VGND VPWR VPWR _02510_ sky130_fd_sc_hd__mux2_1
X_07638_ tanh_inst.divider.x\[-18\] _02441_ VGND VGND VPWR VPWR _02442_ sky130_fd_sc_hd__and2_2
XFILLER_0_67_249 VGND VGND VPWR VPWR sky130_fd_sc_hd__decap_6
XTAP_TAPCELL_ROW_101_1523 VGND VPWR sky130_fd_sc_hd__tapvpwrvgnd_1
X_07569_ _02123_ _02193_ _02259_ _02324_ VGND VGND VPWR VPWR _02375_ sky130_fd_sc_hd__and4_2
XPHY_EDGE_ROW_48_Right_48 VGND VGND VPWR VPWR sky130_fd_sc_hd__decap_3
XFILLER_0_75_271 VGND VGND VPWR VPWR sky130_fd_sc_hd__fill_2
XFILLER_0_35_113 VGND VGND VPWR VPWR sky130_fd_sc_hd__fill_1
XFILLER_0_36_614 VGND VGND VPWR VPWR sky130_fd_sc_hd__decap_8
XFILLER_0_36_636 VGND VGND VPWR VPWR sky130_fd_sc_hd__fill_1
X_09308_ tanh_inst.LOOKUP.index\[3\] _03704_ _03938_ VGND VGND VPWR VPWR _04044_ sky130_fd_sc_hd__o21ai_2
XFILLER_0_118_351 VGND VGND VPWR VPWR sky130_fd_sc_hd__fill_1
XFILLER_0_35_157 VGND VGND VPWR VPWR sky130_fd_sc_hd__decap_3
XFILLER_0_35_179 VGND VGND VPWR VPWR sky130_fd_sc_hd__decap_8
X_09239_ tanh_inst.LOOKUP.index\[3\] _03655_ _03938_ VGND VGND VPWR VPWR _03977_ sky130_fd_sc_hd__o21ai_2
XFILLER_0_50_105 VGND VGND VPWR VPWR sky130_fd_sc_hd__decap_3
XFILLER_0_121_505 VGND VGND VPWR VPWR sky130_fd_sc_hd__decap_6
XFILLER_0_50_127 VGND VGND VPWR VPWR sky130_fd_sc_hd__fill_1
XPHY_EDGE_ROW_57_Right_57 VGND VGND VPWR VPWR sky130_fd_sc_hd__decap_3
XFILLER_0_101_251 VGND VGND VPWR VPWR sky130_fd_sc_hd__decap_3
XTAP_TAPCELL_ROW_112_1663 VGND VPWR sky130_fd_sc_hd__tapvpwrvgnd_1
X_10014_ tanh_inst.z_\[7\] _04728_ _04729_ VGND VGND VPWR VPWR _04730_ sky130_fd_sc_hd__and3_2
XFILLER_0_59_706 VGND VGND VPWR VPWR sky130_fd_sc_hd__decap_6
XFILLER_0_25_15 VPWR VGND VPWR VGND sky130_ef_sc_hd__decap_12
XTAP_TAPCELL_ROW_47_848 VGND VPWR sky130_fd_sc_hd__tapvpwrvgnd_1
XFILLER_0_98_374 VGND VGND VPWR VPWR sky130_fd_sc_hd__decap_3
XFILLER_0_58_216 VGND VGND VPWR VPWR sky130_fd_sc_hd__decap_8
XFILLER_0_86_558 VGND VGND VPWR VPWR sky130_fd_sc_hd__fill_2
XPHY_EDGE_ROW_66_Right_66 VGND VGND VPWR VPWR sky130_fd_sc_hd__decap_3
XFILLER_0_58_238 VPWR VGND VPWR VGND sky130_ef_sc_hd__decap_12
XTAP_TAPCELL_ROW_27_594 VGND VPWR sky130_fd_sc_hd__tapvpwrvgnd_1
XFILLER_0_109_362 VGND VGND VPWR VPWR sky130_fd_sc_hd__decap_4
XFILLER_0_6_519 VGND VGND VPWR VPWR sky130_fd_sc_hd__decap_4
XFILLER_0_26_124 VGND VGND VPWR VPWR sky130_fd_sc_hd__decap_6
XFILLER_0_26_135 VGND VGND VPWR VPWR sky130_fd_sc_hd__decap_4
XFILLER_0_54_477 VGND VGND VPWR VPWR sky130_fd_sc_hd__decap_8
XFILLER_0_81_285 VGND VGND VPWR VPWR sky130_fd_sc_hd__fill_1
XFILLER_0_41_149 VGND VGND VPWR VPWR sky130_fd_sc_hd__fill_2
XPHY_EDGE_ROW_75_Right_75 VGND VGND VPWR VPWR sky130_fd_sc_hd__decap_3
XFILLER_0_34_190 VGND VGND VPWR VPWR sky130_fd_sc_hd__decap_6
XFILLER_0_10_514 VGND VGND VPWR VPWR sky130_fd_sc_hd__fill_1
XFILLER_0_1_279 VGND VGND VPWR VPWR sky130_fd_sc_hd__fill_1
X_06940_ tanh_inst.divider.i\[0\] tanh_inst.divider.i\[1\] tanh_inst.divider.i\[2\]
+ VGND VGND VPWR VPWR _01784_ sky130_fd_sc_hd__nand3b_2
XFILLER_0_5_69 VPWR VGND VPWR VGND sky130_ef_sc_hd__decap_12
X_06871_ _01754_ _01756_ VGND VGND VPWR VPWR _01757_ sky130_fd_sc_hd__xnor2_2
X_05822_ _04801_ _00788_ VGND VGND VPWR VPWR _00790_ sky130_fd_sc_hd__nand2_2
X_08610_ _04757_ _02733_ _02858_ VGND VGND VPWR VPWR _03392_ sky130_fd_sc_hd__a21o_2
XPHY_EDGE_ROW_84_Right_84 VGND VGND VPWR VPWR sky130_fd_sc_hd__decap_3
X_09590_ _04765_ _04308_ VGND VGND VPWR VPWR _04318_ sky130_fd_sc_hd__xnor2_2
X_05753_ _00723_ _00725_ VGND VGND VPWR VPWR _00727_ sky130_fd_sc_hd__nand2_2
X_08541_ _02019_ _03294_ _03295_ _02014_ VGND VGND VPWR VPWR _03325_ sky130_fd_sc_hd__o31ai_2
X_05684_ mac_inst.z\[0\] _04982_ VGND VGND VPWR VPWR _00663_ sky130_fd_sc_hd__and2_2
X_08472_ _03250_ _03256_ VGND VGND VPWR VPWR _03257_ sky130_fd_sc_hd__and2_2
XFILLER_0_106_83 VGND VGND VPWR VPWR sky130_fd_sc_hd__fill_1
X_07423_ _02229_ _02230_ VGND VGND VPWR VPWR _02231_ sky130_fd_sc_hd__and2_2
XFILLER_0_15_81 VPWR VGND VPWR VGND sky130_ef_sc_hd__decap_12
XFILLER_0_119_137 VPWR VGND VPWR VGND sky130_ef_sc_hd__decap_12
XFILLER_0_57_260 VGND VGND VPWR VPWR sky130_fd_sc_hd__fill_1
XFILLER_0_9_335 VGND VGND VPWR VPWR sky130_fd_sc_hd__fill_1
XFILLER_0_17_113 VPWR VGND VPWR VGND sky130_ef_sc_hd__decap_12
XFILLER_0_18_614 VGND VGND VPWR VPWR sky130_fd_sc_hd__decap_8
X_07354_ tanh_inst.divider.x\[-24\] _02103_ _02162_ VGND VGND VPWR VPWR _02163_ sky130_fd_sc_hd__a21o_2
X_06305_ _01228_ _01230_ tanh_inst.divider.y_\[7\] VGND VGND VPWR VPWR _01241_ sky130_fd_sc_hd__a21o_2
XFILLER_0_93_3 VPWR VGND VPWR VGND sky130_ef_sc_hd__decap_12
X_07285_ tanh_inst.divider.y\[-8\] _02028_ _02029_ VGND VGND VPWR VPWR _02095_ sky130_fd_sc_hd__o21ai_2
XFILLER_0_33_617 VGND VGND VPWR VPWR sky130_fd_sc_hd__fill_2
X_06236_ _01093_ _01104_ _04777_ VGND VGND VPWR VPWR _01177_ sky130_fd_sc_hd__mux2_1
XPHY_EDGE_ROW_93_Right_93 VGND VGND VPWR VPWR sky130_fd_sc_hd__decap_3
XFILLER_0_72_296 VGND VGND VPWR VPWR sky130_fd_sc_hd__decap_4
X_09024_ tanh_inst.divider.x\[-13\] tanh_inst.divider.x\[-12\] tanh_inst.divider.x\[-11\]
+ tanh_inst.divider.x\[-10\] tanh_inst.LOOKUP.index\[0\] tanh_inst.LOOKUP.index\[1\]
+ VGND VGND VPWR VPWR _03767_ sky130_fd_sc_hd__mux4_2
X_06167_ _01063_ _01087_ _01086_ VGND VGND VPWR VPWR _01112_ sky130_fd_sc_hd__a21o_2
X_06098_ tanh_inst.divider.y_\[-3\] tanh_inst.divider.y_\[-4\] tanh_inst.divider.y_\[-1\]
+ tanh_inst.divider.y_\[-2\] VGND VGND VPWR VPWR _01045_ sky130_fd_sc_hd__or4_2
X_05118_ _04809_ _04826_ _04828_ VGND VGND VPWR VPWR _00124_ sky130_fd_sc_hd__nor3_2
X_05049_ tanh_inst.divider.x\[-22\] VGND VGND VPWR VPWR _04773_ sky130_fd_sc_hd__inv_2
X_09926_ _04576_ _04634_ _04633_ VGND VGND VPWR VPWR _04644_ sky130_fd_sc_hd__a21o_2
XFILLER_0_99_127 VPWR VGND VPWR VGND sky130_ef_sc_hd__decap_12
X_09857_ _04576_ VGND VGND VPWR VPWR _04577_ sky130_fd_sc_hd__inv_2
X_08808_ tanh_inst.divider.x\[-2\] _02028_ _03508_ VGND VGND VPWR VPWR _03554_ sky130_fd_sc_hd__o21a_2
X_09788_ tanh_inst.divider.y\[0\] _04509_ VGND VGND VPWR VPWR _04510_ sky130_fd_sc_hd__nand2_2
X_08739_ mac_inst.i\[18\] _03497_ VGND VGND VPWR VPWR _03499_ sky130_fd_sc_hd__and2_2
XFILLER_0_95_311 VGND VGND VPWR VPWR sky130_fd_sc_hd__decap_6
XTAP_TAPCELL_ROW_44_807 VGND VPWR sky130_fd_sc_hd__tapvpwrvgnd_1
XTAP_TAPCELL_ROW_44_818 VGND VPWR sky130_fd_sc_hd__tapvpwrvgnd_1
XFILLER_0_95_399 VPWR VGND VPWR VGND sky130_ef_sc_hd__decap_12
XFILLER_0_83_517 VGND VGND VPWR VPWR sky130_fd_sc_hd__fill_2
XTAP_TAPCELL_ROW_24_564 VGND VPWR sky130_fd_sc_hd__tapvpwrvgnd_1
XFILLER_0_106_321 VGND VGND VPWR VPWR sky130_fd_sc_hd__decap_4
XFILLER_0_63_263 VPWR VGND VPWR VGND sky130_ef_sc_hd__decap_12
XFILLER_0_11_39 VPWR VGND VPWR VGND sky130_ef_sc_hd__decap_12
XFILLER_0_23_105 VGND VGND VPWR VPWR sky130_fd_sc_hd__decap_6
XFILLER_0_36_69 VGND VGND VPWR VPWR sky130_fd_sc_hd__fill_2
XFILLER_0_59_514 VGND VGND VPWR VPWR sky130_fd_sc_hd__decap_8
XFILLER_0_74_506 VGND VGND VPWR VPWR sky130_fd_sc_hd__decap_8
XFILLER_0_67_591 VGND VGND VPWR VPWR sky130_fd_sc_hd__fill_1
XFILLER_0_54_230 VPWR VGND VPWR VGND sky130_ef_sc_hd__decap_12
XFILLER_0_27_444 VGND VGND VPWR VPWR sky130_fd_sc_hd__decap_4
XFILLER_0_39_293 VGND VGND VPWR VPWR sky130_fd_sc_hd__decap_3
XFILLER_0_15_617 VPWR VGND VPWR VGND sky130_ef_sc_hd__decap_12
X_07070_ _01887_ _01892_ _01899_ VGND VGND VPWR VPWR _01901_ sky130_fd_sc_hd__nand3_2
XFILLER_0_82_594 VPWR VGND VPWR VGND sky130_ef_sc_hd__decap_12
XTAP_TAPCELL_ROW_76_1208 VGND VPWR sky130_fd_sc_hd__tapvpwrvgnd_1
X_06021_ _00973_ _00974_ VGND VGND VPWR VPWR _00975_ sky130_fd_sc_hd__and2_2
XFILLER_0_2_533 VGND VGND VPWR VPWR sky130_fd_sc_hd__decap_6
XFILLER_0_10_333 VPWR VGND VPWR VGND sky130_ef_sc_hd__decap_12
X_07972_ _02767_ _02768_ VGND VGND VPWR VPWR _02769_ sky130_fd_sc_hd__nor2_2
XFILLER_0_77_98 VPWR VGND VPWR VGND sky130_ef_sc_hd__decap_12
X_09711_ tanh_inst.divider.y\[-3\] _02014_ _04425_ _04435_ _01470_ VGND VGND VPWR
+ VPWR _00318_ sky130_fd_sc_hd__o221a_2
X_06923_ tanh_inst.div_en tanh_inst.divider.z_\[5\] VGND VGND VPWR VPWR _00194_ sky130_fd_sc_hd__and2b_2
XFILLER_0_93_75 VGND VGND VPWR VPWR sky130_fd_sc_hd__fill_1
X_06854_ _01740_ _01741_ VGND VGND VPWR VPWR _01742_ sky130_fd_sc_hd__xor2_2
X_09642_ tanh_inst.divider.y\[-4\] _04366_ VGND VGND VPWR VPWR _04368_ sky130_fd_sc_hd__and2_2
XTAP_TAPCELL_ROW_87_1348 VGND VPWR sky130_fd_sc_hd__tapvpwrvgnd_1
X_05805_ _00762_ _00773_ VGND VGND VPWR VPWR _00774_ sky130_fd_sc_hd__nand2_2
X_09573_ tanh_inst.divider.y\[-6\] _04300_ VGND VGND VPWR VPWR _04301_ sky130_fd_sc_hd__nand2_2
X_06785_ _01502_ _01680_ _01681_ _01469_ mac_y_out[18] VGND VGND VPWR VPWR _00146_
+ sky130_fd_sc_hd__a32o_2
XFILLER_0_117_93 VPWR VGND VPWR VGND sky130_ef_sc_hd__decap_12
X_05736_ mac_inst.z\[31\] _00707_ _00708_ _04797_ VGND VGND VPWR VPWR _00711_ sky130_fd_sc_hd__a211o_2
X_08524_ _03305_ _03307_ VGND VGND VPWR VPWR _03308_ sky130_fd_sc_hd__xnor2_2
XFILLER_0_65_517 VPWR VGND VPWR VGND sky130_ef_sc_hd__decap_12
X_08455_ _04757_ _02565_ _02858_ VGND VGND VPWR VPWR _03241_ sky130_fd_sc_hd__a21o_2
X_05667_ _00648_ VGND VGND VPWR VPWR _00649_ sky130_fd_sc_hd__inv_2
XFILLER_0_46_720 VGND VGND VPWR VPWR sky130_fd_sc_hd__decap_4
X_07406_ _02066_ _02071_ _02072_ _02067_ _04760_ _04761_ VGND VGND VPWR VPWR _02214_
+ sky130_fd_sc_hd__mux4_2
X_08386_ _03163_ _03170_ VGND VGND VPWR VPWR _03173_ sky130_fd_sc_hd__xnor2_2
X_05598_ _04911_ _00414_ VGND VGND VPWR VPWR _00586_ sky130_fd_sc_hd__and2_2
XFILLER_0_45_230 VGND VGND VPWR VPWR sky130_fd_sc_hd__decap_6
X_07337_ _02028_ _02145_ _02029_ VGND VGND VPWR VPWR _02146_ sky130_fd_sc_hd__o21a_2
XTAP_TAPCELL_ROW_21_523 VGND VPWR sky130_fd_sc_hd__tapvpwrvgnd_1
XFILLER_0_73_594 VGND VGND VPWR VPWR sky130_fd_sc_hd__fill_1
XFILLER_0_103_302 VGND VGND VPWR VPWR sky130_fd_sc_hd__fill_2
XTAP_TAPCELL_ROW_98_1488 VGND VPWR sky130_fd_sc_hd__tapvpwrvgnd_1
X_07268_ _02070_ _02077_ _02025_ VGND VGND VPWR VPWR _02078_ sky130_fd_sc_hd__mux2_1
X_06219_ _01064_ _01080_ _04777_ VGND VGND VPWR VPWR _01161_ sky130_fd_sc_hd__mux2_1
X_09007_ _02303_ _03739_ VGND VGND VPWR VPWR _03750_ sky130_fd_sc_hd__nand2_2
X_07199_ _01502_ _01529_ tanh_inst.IS_FIRST13 _01469_ VGND VGND VPWR VPWR _00230_
+ sky130_fd_sc_hd__o2bb2a_2
XFILLER_0_60_277 VPWR VGND VPWR VGND sky130_ef_sc_hd__decap_12
XFILLER_0_5_393 VGND VGND VPWR VPWR sky130_fd_sc_hd__fill_1
XFILLER_0_13_193 VPWR VGND VPWR VGND sky130_ef_sc_hd__decap_12
X_09909_ _02018_ _04627_ VGND VGND VPWR VPWR _04628_ sky130_fd_sc_hd__nor2_2
XFILLER_0_87_108 VGND VGND VPWR VPWR sky130_fd_sc_hd__decap_4
XTAP_TAPCELL_ROW_29_623 VGND VPWR sky130_fd_sc_hd__tapvpwrvgnd_1
XTAP_TAPCELL_ROW_57_976 VGND VPWR sky130_fd_sc_hd__tapvpwrvgnd_1
XTAP_TAPCELL_ROW_1_270 VGND VPWR sky130_fd_sc_hd__tapvpwrvgnd_1
XTAP_TAPCELL_ROW_107_1595 VGND VPWR sky130_fd_sc_hd__tapvpwrvgnd_1
XFILLER_0_96_664 VGND VGND VPWR VPWR sky130_fd_sc_hd__fill_1
XFILLER_0_68_333 VPWR VGND VPWR VGND sky130_ef_sc_hd__decap_12
XFILLER_0_95_152 VPWR VGND VPWR VGND sky130_ef_sc_hd__decap_12
XFILLER_0_68_377 VPWR VGND VPWR VGND sky130_ef_sc_hd__decap_12
XTAP_TAPCELL_ROW_120_1762 VGND VPWR sky130_fd_sc_hd__tapvpwrvgnd_1
XTAP_TAPCELL_ROW_60_1009 VGND VPWR sky130_fd_sc_hd__tapvpwrvgnd_1
XFILLER_0_22_27 VGND VGND VPWR VPWR sky130_fd_sc_hd__fill_1
XFILLER_0_71_509 VGND VGND VPWR VPWR sky130_fd_sc_hd__fill_1
XFILLER_0_52_701 VGND VGND VPWR VPWR sky130_fd_sc_hd__fill_2
X_10477_ clknet_leaf_33_clk _00334_ _00078_ VGND VGND VPWR VPWR tanh_counter\[0\]
+ sky130_fd_sc_hd__dfrtp_2
XFILLER_0_121_165 VGND VGND VPWR VPWR sky130_fd_sc_hd__decap_3
XTAP_TAPCELL_ROW_9_370 VGND VPWR sky130_fd_sc_hd__tapvpwrvgnd_1
XFILLER_0_20_653 VGND VGND VPWR VPWR sky130_fd_sc_hd__fill_2
XTAP_TAPCELL_ROW_71_1149 VGND VPWR sky130_fd_sc_hd__tapvpwrvgnd_1
XFILLER_0_47_57 VGND VGND VPWR VPWR sky130_fd_sc_hd__decap_4
XFILLER_0_2_15 VPWR VGND VPWR VGND sky130_ef_sc_hd__decap_12
XFILLER_0_78_108 VGND VGND VPWR VPWR sky130_fd_sc_hd__decap_4
XFILLER_0_63_23 VGND VGND VPWR VPWR sky130_fd_sc_hd__decap_3
XFILLER_0_87_664 VGND VGND VPWR VPWR sky130_fd_sc_hd__fill_1
XFILLER_0_86_141 VGND VGND VPWR VPWR sky130_fd_sc_hd__fill_1
X_06570_ _01471_ _01484_ VGND VGND VPWR VPWR _01485_ sky130_fd_sc_hd__or2_2
XFILLER_0_59_388 VGND VGND VPWR VPWR sky130_fd_sc_hd__decap_4
X_05521_ mac_inst.y\[15\] _00515_ VGND VGND VPWR VPWR _00517_ sky130_fd_sc_hd__nor2_2
XFILLER_0_47_517 VPWR VGND VPWR VGND sky130_ef_sc_hd__decap_12
XTAP_TAPCELL_ROW_82_1289 VGND VPWR sky130_fd_sc_hd__tapvpwrvgnd_1
X_05452_ _04911_ _00449_ _00450_ _00452_ VGND VGND VPWR VPWR _00453_ sky130_fd_sc_hd__a31o_2
X_08240_ tanh_inst.divider.x\[-4\] _03028_ VGND VGND VPWR VPWR _03030_ sky130_fd_sc_hd__nor2_2
XFILLER_0_117_427 VGND VGND VPWR VPWR sky130_fd_sc_hd__decap_8
XFILLER_0_103_51 VGND VGND VPWR VPWR sky130_fd_sc_hd__decap_4
X_08171_ _02874_ _02939_ VGND VGND VPWR VPWR _02963_ sky130_fd_sc_hd__nor2_2
XFILLER_0_55_561 VGND VGND VPWR VPWR sky130_fd_sc_hd__fill_2
XFILLER_0_55_550 VGND VGND VPWR VPWR sky130_fd_sc_hd__decap_8
XFILLER_0_27_252 VGND VGND VPWR VPWR sky130_fd_sc_hd__fill_1
X_07122_ _01933_ _01940_ _01946_ VGND VGND VPWR VPWR _01947_ sky130_fd_sc_hd__and3_2
X_05383_ mac_inst.i\[2\] _04984_ _00388_ VGND VGND VPWR VPWR _00389_ sky130_fd_sc_hd__a21oi_2
XFILLER_0_42_211 VPWR VGND VPWR VGND sky130_ef_sc_hd__decap_12
XFILLER_0_43_723 VGND VGND VPWR VPWR sky130_fd_sc_hd__fill_1
XFILLER_0_42_244 VGND VGND VPWR VPWR sky130_fd_sc_hd__fill_1
XFILLER_0_113_655 VGND VGND VPWR VPWR sky130_fd_sc_hd__fill_1
XFILLER_0_112_121 VGND VGND VPWR VPWR sky130_fd_sc_hd__decap_6
X_07053_ _01039_ _01818_ VGND VGND VPWR VPWR _01885_ sky130_fd_sc_hd__or2_2
XFILLER_0_42_277 VGND VGND VPWR VPWR sky130_fd_sc_hd__decap_4
XFILLER_0_2_363 VGND VGND VPWR VPWR sky130_fd_sc_hd__fill_1
X_06004_ mac_inst.i\[7\] mac_inst.i\[6\] _00954_ _00956_ VGND VGND VPWR VPWR _00958_
+ sky130_fd_sc_hd__and4_2
XFILLER_0_56_3 VPWR VGND VPWR VGND sky130_ef_sc_hd__decap_12
XFILLER_0_10_141 VPWR VGND VPWR VGND sky130_ef_sc_hd__decap_12
X_07955_ tanh_inst.divider.y\[7\] _02389_ _02390_ _02385_ _02023_ _02052_ VGND VGND
+ VPWR VPWR _02752_ sky130_fd_sc_hd__mux4_2
X_06906_ tanh_inst.div_en tanh_inst.divider.z_\[-12\] VGND VGND VPWR VPWR _00177_
+ sky130_fd_sc_hd__and2b_2
X_07886_ tanh_inst.divider.x\[-13\] _02682_ VGND VGND VPWR VPWR _02685_ sky130_fd_sc_hd__xnor2_2
X_09625_ _04350_ _04351_ tanh_inst.z_\[7\] _04346_ VGND VGND VPWR VPWR _04352_ sky130_fd_sc_hd__a2bb2o_2
X_06837_ mac_y_out[24] _01469_ _01726_ _01727_ VGND VGND VPWR VPWR _00152_ sky130_fd_sc_hd__a22o_2
X_09556_ _04283_ _04284_ VGND VGND VPWR VPWR _04285_ sky130_fd_sc_hd__xnor2_2
X_06768_ _01654_ _01655_ VGND VGND VPWR VPWR _01666_ sky130_fd_sc_hd__and2_2
XTAP_TAPCELL_ROW_54_935 VGND VPWR sky130_fd_sc_hd__tapvpwrvgnd_1
X_09487_ _04166_ _04170_ _04217_ VGND VGND VPWR VPWR _04218_ sky130_fd_sc_hd__a21o_2
X_06699_ mac_y_out[9] _01469_ _01502_ _01604_ VGND VGND VPWR VPWR _00137_ sky130_fd_sc_hd__a22o_2
XFILLER_0_65_303 VGND VGND VPWR VPWR sky130_fd_sc_hd__fill_1
X_05719_ _04979_ _00666_ _00677_ _04944_ VGND VGND VPWR VPWR _00695_ sky130_fd_sc_hd__a31o_2
X_08507_ tanh_inst.divider.x\[1\] _03277_ _03243_ tanh_inst.divider.x\[0\] VGND VGND
+ VPWR VPWR _03291_ sky130_fd_sc_hd__o211a_2
X_08438_ _03096_ _03134_ _03165_ _03130_ _03164_ VGND VGND VPWR VPWR _03224_ sky130_fd_sc_hd__o221a_2
XTAP_TAPCELL_ROW_34_681 VGND VPWR sky130_fd_sc_hd__tapvpwrvgnd_1
XTAP_TAPCELL_ROW_34_692 VGND VPWR sky130_fd_sc_hd__tapvpwrvgnd_1
XFILLER_0_34_701 VGND VGND VPWR VPWR sky130_fd_sc_hd__fill_2
XFILLER_0_33_211 VGND VGND VPWR VPWR sky130_fd_sc_hd__fill_1
X_08369_ _03043_ _03155_ _03156_ VGND VGND VPWR VPWR _03157_ sky130_fd_sc_hd__a21bo_2
XFILLER_0_46_583 VGND VGND VPWR VPWR sky130_fd_sc_hd__decap_4
XFILLER_0_73_391 VGND VGND VPWR VPWR sky130_fd_sc_hd__fill_1
X_10400_ clknet_leaf_45_clk _00257_ VGND VGND VPWR VPWR tanh_inst.divider.x\[0\] sky130_fd_sc_hd__dfxtp_2
X_10331_ clknet_leaf_17_clk _00188_ VGND VGND VPWR VPWR tanh_out[23] sky130_fd_sc_hd__dfxtp_2
XFILLER_0_61_597 VGND VGND VPWR VPWR sky130_fd_sc_hd__fill_1
XFILLER_0_14_491 VGND VGND VPWR VPWR sky130_fd_sc_hd__decap_8
X_10262_ clknet_leaf_32_clk mac_inst.x\[24\] _00000_ VGND VGND VPWR VPWR mac_x_out[24]
+ sky130_fd_sc_hd__dfrtp_2
XFILLER_0_103_187 VGND VGND VPWR VPWR sky130_fd_sc_hd__fill_1
X_10193_ x_in[19] _00000_ VGND VGND VPWR VPWR mac_inst.x\[19\] sky130_fd_sc_hd__dlxtn_1
XTAP_TAPCELL_ROW_6_340 VGND VPWR sky130_fd_sc_hd__tapvpwrvgnd_1
XFILLER_0_108_29 VPWR VGND VPWR VGND sky130_ef_sc_hd__decap_12
XFILLER_0_17_27 VPWR VGND VPWR VGND sky130_ef_sc_hd__decap_12
XTAP_TAPCELL_ROW_109_1624 VGND VPWR sky130_fd_sc_hd__tapvpwrvgnd_1
XFILLER_0_88_428 VGND VGND VPWR VPWR sky130_fd_sc_hd__fill_1
XFILLER_0_33_15 VPWR VGND VPWR VGND sky130_ef_sc_hd__decap_12
XFILLER_0_83_100 VGND VGND VPWR VPWR sky130_fd_sc_hd__fill_1
XFILLER_0_56_314 VPWR VGND VPWR VGND sky130_ef_sc_hd__decap_12
XFILLER_0_68_185 VGND VGND VPWR VPWR sky130_fd_sc_hd__decap_4
XFILLER_0_44_509 VGND VGND VPWR VPWR sky130_fd_sc_hd__fill_1
XFILLER_0_114_408 VGND VGND VPWR VPWR sky130_fd_sc_hd__decap_3
XFILLER_0_71_317 VGND VGND VPWR VPWR sky130_fd_sc_hd__decap_3
XFILLER_0_114_419 VGND VGND VPWR VPWR sky130_fd_sc_hd__fill_1
XFILLER_0_107_460 VPWR VGND VPWR VGND sky130_ef_sc_hd__decap_12
XFILLER_0_3_105 VGND VGND VPWR VPWR sky130_fd_sc_hd__decap_6
XFILLER_0_24_222 VPWR VGND VPWR VGND sky130_ef_sc_hd__decap_12
XFILLER_0_52_531 VGND VGND VPWR VPWR sky130_fd_sc_hd__fill_1
XFILLER_0_3_149 VPWR VGND VPWR VGND sky130_ef_sc_hd__decap_12
XFILLER_0_24_277 VPWR VGND VPWR VGND sky130_ef_sc_hd__decap_12
XFILLER_0_52_564 VGND VGND VPWR VPWR sky130_fd_sc_hd__fill_2
XFILLER_0_110_658 VPWR VGND VPWR VGND sky130_ef_sc_hd__decap_12
XFILLER_0_58_67 VGND VGND VPWR VPWR sky130_fd_sc_hd__decap_3
X_07740_ _02539_ _02540_ VGND VGND VPWR VPWR _02542_ sky130_fd_sc_hd__xnor2_2
XFILLER_0_74_66 VGND VGND VPWR VPWR sky130_fd_sc_hd__decap_3
XTAP_TAPCELL_ROW_84_1307 VGND VPWR sky130_fd_sc_hd__tapvpwrvgnd_1
X_07671_ _02466_ _02474_ VGND VGND VPWR VPWR _02475_ sky130_fd_sc_hd__xnor2_2
X_09410_ _02766_ _04131_ VGND VGND VPWR VPWR _04143_ sky130_fd_sc_hd__or2_2
XTAP_TAPCELL_ROW_84_1318 VGND VPWR sky130_fd_sc_hd__tapvpwrvgnd_1
X_06622_ _01511_ _01516_ _01517_ _01485_ VGND VGND VPWR VPWR _01535_ sky130_fd_sc_hd__or4b_2
X_06553_ tanh_counter\[7\] tanh_counter\[6\] tanh_counter\[3\] tanh_counter\[2\] VGND
+ VGND VPWR VPWR _01468_ sky130_fd_sc_hd__or4_2
X_09341_ tanh_inst.LOOKUP.index\[3\] _03762_ _03938_ VGND VGND VPWR VPWR _04076_ sky130_fd_sc_hd__o21ai_2
XFILLER_0_47_314 VPWR VGND VPWR VGND sky130_ef_sc_hd__decap_12
XTAP_TAPCELL_ROW_51_905 VGND VPWR sky130_fd_sc_hd__tapvpwrvgnd_1
XFILLER_0_90_76 VGND VGND VPWR VPWR sky130_fd_sc_hd__decap_8
XFILLER_0_75_634 VPWR VGND VPWR VGND sky130_ef_sc_hd__decap_12
X_05504_ mac_inst.y\[14\] _00500_ VGND VGND VPWR VPWR _00501_ sky130_fd_sc_hd__nand2_2
XFILLER_0_114_83 VGND VGND VPWR VPWR sky130_fd_sc_hd__fill_1
X_06484_ _01404_ _01405_ VGND VGND VPWR VPWR _01406_ sky130_fd_sc_hd__and2b_2
X_09272_ _03944_ _03945_ _03979_ tanh_inst.z_\[7\] VGND VGND VPWR VPWR _04009_ sky130_fd_sc_hd__a31o_2
XFILLER_0_16_701 VGND VGND VPWR VPWR sky130_fd_sc_hd__fill_2
XFILLER_0_23_81 VPWR VGND VPWR VGND sky130_ef_sc_hd__decap_12
X_05435_ _00424_ _00437_ VGND VGND VPWR VPWR _00438_ sky130_fd_sc_hd__or2_2
XTAP_TAPCELL_ROW_31_651 VGND VPWR sky130_fd_sc_hd__tapvpwrvgnd_1
X_08223_ _03012_ _03013_ VGND VGND VPWR VPWR _03014_ sky130_fd_sc_hd__nor2_2
X_05366_ _04836_ _00372_ VGND VGND VPWR VPWR _00373_ sky130_fd_sc_hd__nor2_2
X_08154_ tanh_inst.divider.x\[-7\] _02946_ VGND VGND VPWR VPWR _02947_ sky130_fd_sc_hd__nand2_2
X_07105_ _01088_ _00184_ _01931_ _01059_ VGND VGND VPWR VPWR _00216_ sky130_fd_sc_hd__o22a_2
X_08085_ _02707_ _02796_ _02877_ _02878_ VGND VGND VPWR VPWR _02879_ sky130_fd_sc_hd__o31ai_2
XFILLER_0_30_203 VGND VGND VPWR VPWR sky130_fd_sc_hd__decap_8
XFILLER_0_31_704 VPWR VGND VPWR VGND sky130_ef_sc_hd__decap_12
XFILLER_0_113_463 VGND VGND VPWR VPWR sky130_fd_sc_hd__fill_1
XTAP_TAPCELL_ROW_95_1447 VGND VPWR sky130_fd_sc_hd__tapvpwrvgnd_1
X_07036_ tanh_inst.divider.z_\[-12\] _01862_ _01869_ VGND VGND VPWR VPWR _01870_ sky130_fd_sc_hd__and3_2
XFILLER_0_3_650 VGND VGND VPWR VPWR sky130_fd_sc_hd__fill_1
X_05297_ _04995_ _04996_ mac_inst.i\[2\] VGND VGND VPWR VPWR _04997_ sky130_fd_sc_hd__mux2_1
XFILLER_0_11_461 VGND VGND VPWR VPWR sky130_fd_sc_hd__fill_2
X_08987_ _02025_ _03727_ _03728_ _03729_ _02023_ VGND VGND VPWR VPWR _03730_ sky130_fd_sc_hd__o221a_2
X_07938_ _02644_ _02680_ VGND VGND VPWR VPWR _02736_ sky130_fd_sc_hd__nor2_2
X_07869_ tanh_inst.divider.y\[-13\] tanh_inst.divider.x\[-13\] VGND VGND VPWR VPWR
+ _02668_ sky130_fd_sc_hd__nand2_2
Xclkbuf_2_2__f_clk clknet_0_clk VGND VGND VPWR VPWR clknet_2_2__leaf_clk sky130_fd_sc_hd__clkbuf_16
XTAP_TAPCELL_ROW_39_751 VGND VPWR sky130_fd_sc_hd__tapvpwrvgnd_1
X_09608_ tanh_inst.divider.y\[-5\] _04334_ VGND VGND VPWR VPWR _04335_ sky130_fd_sc_hd__and2_2
XFILLER_0_78_461 VGND VGND VPWR VPWR sky130_fd_sc_hd__decap_8
X_09539_ tanh_inst.divider.y\[-8\] _02014_ _04267_ _04268_ _01470_ VGND VGND VPWR
+ VPWR _00313_ sky130_fd_sc_hd__o221a_2
XTAP_TAPCELL_ROW_104_1565 VGND VPWR sky130_fd_sc_hd__tapvpwrvgnd_1
XFILLER_0_66_645 VGND VGND VPWR VPWR sky130_fd_sc_hd__fill_1
XFILLER_0_93_475 VGND VGND VPWR VPWR sky130_fd_sc_hd__decap_3
XFILLER_0_93_442 VGND VGND VPWR VPWR sky130_fd_sc_hd__decap_6
XFILLER_0_81_604 VPWR VGND VPWR VGND sky130_ef_sc_hd__decap_12
XFILLER_0_66_667 VGND VGND VPWR VPWR sky130_fd_sc_hd__decap_8
XFILLER_0_19_561 VPWR VGND VPWR VGND sky130_ef_sc_hd__decap_12
XFILLER_0_80_103 VGND VGND VPWR VPWR sky130_fd_sc_hd__fill_1
XFILLER_0_19_583 VGND VGND VPWR VPWR sky130_fd_sc_hd__decap_6
XFILLER_0_34_531 VGND VGND VPWR VPWR sky130_fd_sc_hd__fill_1
XFILLER_0_80_169 VGND VGND VPWR VPWR sky130_fd_sc_hd__decap_8
XTAP_TAPCELL_ROW_59_1000 VGND VPWR sky130_fd_sc_hd__tapvpwrvgnd_1
XFILLER_0_34_564 VGND VGND VPWR VPWR sky130_fd_sc_hd__fill_1
XFILLER_0_21_225 VPWR VGND VPWR VGND sky130_ef_sc_hd__decap_12
X_10314_ clknet_leaf_16_clk _00171_ VGND VGND VPWR VPWR tanh_out[6] sky130_fd_sc_hd__dfxtp_2
XTAP_TAPCELL_ROW_115_1694 VGND VPWR sky130_fd_sc_hd__tapvpwrvgnd_1
X_10245_ clknet_leaf_31_clk mac_inst.x\[7\] _00000_ VGND VGND VPWR VPWR mac_x_out[7]
+ sky130_fd_sc_hd__dfrtp_2
XFILLER_0_119_39 VPWR VGND VPWR VGND sky130_ef_sc_hd__decap_12
XFILLER_0_28_15 VPWR VGND VPWR VGND sky130_ef_sc_hd__decap_12
X_10176_ x_in[2] _00000_ VGND VGND VPWR VPWR mac_inst.x\[2\] sky130_fd_sc_hd__dlxtn_1
XFILLER_0_57_612 VGND VGND VPWR VPWR sky130_fd_sc_hd__decap_4
XTAP_TAPCELL_ROW_17_478 VGND VPWR sky130_fd_sc_hd__tapvpwrvgnd_1
XFILLER_0_56_133 VGND VGND VPWR VPWR sky130_fd_sc_hd__decap_6
XFILLER_0_29_369 VPWR VGND VPWR VGND sky130_ef_sc_hd__decap_12
XFILLER_0_84_475 VGND VGND VPWR VPWR sky130_fd_sc_hd__fill_1
XFILLER_0_71_125 VPWR VGND VPWR VGND sky130_ef_sc_hd__decap_12
XFILLER_0_44_317 VPWR VGND VPWR VGND sky130_ef_sc_hd__decap_12
XFILLER_0_44_339 VPWR VGND VPWR VGND sky130_ef_sc_hd__decap_12
XFILLER_0_114_3 VPWR VGND VPWR VGND sky130_ef_sc_hd__decap_12
X_05220_ _04921_ _04922_ _04912_ VGND VGND VPWR VPWR _04924_ sky130_fd_sc_hd__a21o_2
XFILLER_0_71_169 VPWR VGND VPWR VGND sky130_ef_sc_hd__decap_12
X_05151_ mac_inst.x\[17\] _04852_ _04853_ VGND VGND VPWR VPWR _04855_ sky130_fd_sc_hd__a21o_2
XFILLER_0_40_523 VGND VGND VPWR VPWR sky130_fd_sc_hd__decap_8
XFILLER_0_100_41 VPWR VGND VPWR VGND sky130_ef_sc_hd__decap_12
X_05082_ tanh_counter\[2\] _04804_ VGND VGND VPWR VPWR _04805_ sky130_fd_sc_hd__and2_2
XFILLER_0_100_85 VGND VGND VPWR VPWR sky130_fd_sc_hd__decap_8
XFILLER_0_0_653 VPWR VGND VPWR VGND sky130_ef_sc_hd__decap_12
X_09890_ _02019_ _04608_ _04609_ _02015_ VGND VGND VPWR VPWR _04610_ sky130_fd_sc_hd__a211o_2
XFILLER_0_40_589 VPWR VGND VPWR VGND sky130_ef_sc_hd__decap_12
X_08910_ _03651_ _03654_ tanh_inst.LOOKUP.index\[2\] VGND VGND VPWR VPWR _03655_ sky130_fd_sc_hd__mux2_1
X_08841_ _03510_ _03512_ _03558_ _03511_ _04760_ tanh_inst.LOOKUP.index\[0\] VGND
+ VGND VPWR VPWR _03586_ sky130_fd_sc_hd__mux4_2
XTAP_TAPCELL_ROW_90_1388 VGND VPWR sky130_fd_sc_hd__tapvpwrvgnd_1
XFILLER_0_85_76 VGND VGND VPWR VPWR sky130_fd_sc_hd__fill_1
X_08772_ tanh_inst.divider.x\[-15\] _02028_ _03508_ VGND VGND VPWR VPWR _03518_ sky130_fd_sc_hd__o21ai_2
X_05984_ mac_inst.z\[24\] _00936_ _00937_ VGND VGND VPWR VPWR _00939_ sky130_fd_sc_hd__or3_2
X_07723_ _02497_ _02498_ VGND VGND VPWR VPWR _02526_ sky130_fd_sc_hd__xnor2_2
XFILLER_0_79_225 VGND VGND VPWR VPWR sky130_fd_sc_hd__decap_6
X_07654_ _02405_ _02457_ VGND VGND VPWR VPWR _02458_ sky130_fd_sc_hd__nand2_2
XFILLER_0_79_247 VGND VGND VPWR VPWR sky130_fd_sc_hd__decap_8
XFILLER_0_19_3 VPWR VGND VPWR VGND sky130_ef_sc_hd__decap_12
XTAP_TAPCELL_ROW_36_710 VGND VPWR sky130_fd_sc_hd__tapvpwrvgnd_1
X_06605_ _01472_ _01480_ VGND VGND VPWR VPWR _01518_ sky130_fd_sc_hd__or2_2
XFILLER_0_48_601 VPWR VGND VPWR VGND sky130_ef_sc_hd__decap_12
X_07585_ _02132_ _02134_ _02025_ VGND VGND VPWR VPWR _02390_ sky130_fd_sc_hd__mux2_1
XFILLER_0_75_420 VGND VGND VPWR VPWR sky130_fd_sc_hd__decap_6
XFILLER_0_34_91 VGND VGND VPWR VPWR sky130_fd_sc_hd__fill_1
X_06536_ _01441_ _01442_ VGND VGND VPWR VPWR _01453_ sky130_fd_sc_hd__or2_2
X_09324_ tanh_inst.divider.x\[7\] _03733_ _03737_ _03726_ _02023_ _02052_ VGND VGND
+ VPWR VPWR _04059_ sky130_fd_sc_hd__mux4_2
XFILLER_0_63_604 VGND VGND VPWR VPWR sky130_fd_sc_hd__fill_1
X_06467_ tanh_inst.divider.y_\[0\] _01389_ VGND VGND VPWR VPWR _01390_ sky130_fd_sc_hd__nand2_2
X_09255_ _02584_ _03990_ VGND VGND VPWR VPWR _03992_ sky130_fd_sc_hd__nand2_2
XFILLER_0_75_475 VGND VGND VPWR VPWR sky130_fd_sc_hd__fill_1
XFILLER_0_35_328 VGND VGND VPWR VPWR sky130_fd_sc_hd__decap_3
XFILLER_0_118_577 VGND VGND VPWR VPWR sky130_fd_sc_hd__decap_3
XFILLER_0_16_531 VGND VGND VPWR VPWR sky130_fd_sc_hd__fill_1
X_05418_ _00419_ _00421_ VGND VGND VPWR VPWR _00422_ sky130_fd_sc_hd__xnor2_2
X_08206_ _02019_ _02985_ _02997_ _02015_ VGND VGND VPWR VPWR _02998_ sky130_fd_sc_hd__a211o_2
X_06398_ _01303_ _01308_ _01313_ _01315_ VGND VGND VPWR VPWR _01327_ sky130_fd_sc_hd__a31o_2
X_09186_ _03877_ _03879_ _03924_ VGND VGND VPWR VPWR _03925_ sky130_fd_sc_hd__nor3_2
XFILLER_0_90_489 VGND VGND VPWR VPWR sky130_fd_sc_hd__decap_6
XFILLER_0_43_361 VGND VGND VPWR VPWR sky130_fd_sc_hd__decap_8
X_08137_ _02924_ _02929_ VGND VGND VPWR VPWR _02930_ sky130_fd_sc_hd__xnor2_2
X_05349_ _00355_ _00356_ mac_inst.i\[2\] VGND VGND VPWR VPWR _00357_ sky130_fd_sc_hd__mux2_1
X_08068_ tanh_inst.divider.x\[-9\] _02862_ VGND VGND VPWR VPWR _02863_ sky130_fd_sc_hd__xnor2_2
X_07019_ tanh_inst.divider.z_\[-14\] _01853_ VGND VGND VPWR VPWR _01855_ sky130_fd_sc_hd__nor2_2
X_10030_ _03482_ _04744_ VGND VGND VPWR VPWR _04745_ sky130_fd_sc_hd__xnor2_2
XFILLER_0_98_501 VGND VGND VPWR VPWR sky130_fd_sc_hd__decap_8
XFILLER_0_93_250 VGND VGND VPWR VPWR sky130_fd_sc_hd__fill_2
XFILLER_0_66_453 VPWR VGND VPWR VGND sky130_ef_sc_hd__decap_12
XTAP_TAPCELL_ROW_65_1070 VGND VPWR sky130_fd_sc_hd__tapvpwrvgnd_1
XTAP_TAPCELL_ROW_14_437 VGND VPWR sky130_fd_sc_hd__tapvpwrvgnd_1
XFILLER_0_81_423 VGND VGND VPWR VPWR sky130_fd_sc_hd__decap_6
XFILLER_0_38_166 VGND VGND VPWR VPWR sky130_fd_sc_hd__fill_1
XFILLER_0_39_689 VGND VGND VPWR VPWR sky130_fd_sc_hd__decap_8
XFILLER_0_121_29 VPWR VGND VPWR VGND sky130_ef_sc_hd__decap_12
XFILLER_0_81_445 VGND VGND VPWR VPWR sky130_fd_sc_hd__decap_3
XFILLER_0_30_27 VGND VGND VPWR VPWR sky130_fd_sc_hd__fill_1
XFILLER_0_53_125 VGND VGND VPWR VPWR sky130_fd_sc_hd__decap_8
XTAP_TAPCELL_ROW_117_1723 VGND VPWR sky130_fd_sc_hd__tapvpwrvgnd_1
XFILLER_0_81_467 VGND VGND VPWR VPWR sky130_fd_sc_hd__fill_2
XFILLER_0_30_49 VGND VGND VPWR VPWR sky130_fd_sc_hd__fill_1
XPHY_EDGE_ROW_49_Left_171 VGND VGND VPWR VPWR sky130_fd_sc_hd__decap_3
XFILLER_0_53_169 VGND VGND VPWR VPWR sky130_fd_sc_hd__decap_8
XFILLER_0_62_692 VGND VGND VPWR VPWR sky130_fd_sc_hd__decap_8
XFILLER_0_22_556 VPWR VGND VPWR VGND sky130_ef_sc_hd__decap_12
XFILLER_0_22_589 VGND VGND VPWR VPWR sky130_fd_sc_hd__decap_3
X_10228_ clknet_leaf_28_clk mac_inst.y\[22\] _00000_ VGND VGND VPWR VPWR mac_y_out[22]
+ sky130_fd_sc_hd__dfrtp_2
XPHY_EDGE_ROW_58_Left_180 VGND VGND VPWR VPWR sky130_fd_sc_hd__decap_3
XFILLER_0_55_35 VGND VGND VPWR VPWR sky130_fd_sc_hd__decap_4
XFILLER_0_89_523 VGND VGND VPWR VPWR sky130_fd_sc_hd__decap_3
XFILLER_0_89_567 VGND VGND VPWR VPWR sky130_fd_sc_hd__fill_1
XFILLER_0_76_239 VGND VGND VPWR VPWR sky130_fd_sc_hd__fill_1
X_07370_ tanh_inst.divider.y\[-3\] tanh_inst.divider.y\[-2\] tanh_inst.divider.y\[-1\]
+ tanh_inst.divider.y\[0\] tanh_inst.LOOKUP.index\[0\] tanh_inst.LOOKUP.index\[1\]
+ VGND VGND VPWR VPWR _02179_ sky130_fd_sc_hd__mux4_2
XFILLER_0_57_453 VGND VGND VPWR VPWR sky130_fd_sc_hd__fill_1
XFILLER_0_57_442 VGND VGND VPWR VPWR sky130_fd_sc_hd__decap_6
X_06321_ tanh_inst.divider.y_\[-14\] _01232_ _01242_ tanh_inst.divider.y_\[-13\] VGND
+ VGND VPWR VPWR _01256_ sky130_fd_sc_hd__a22o_2
XFILLER_0_17_317 VPWR VGND VPWR VGND sky130_ef_sc_hd__decap_12
XFILLER_0_44_103 VGND VGND VPWR VPWR sky130_fd_sc_hd__decap_6
XFILLER_0_115_503 VGND VGND VPWR VPWR sky130_fd_sc_hd__fill_1
X_06252_ _01115_ _01126_ _04777_ VGND VGND VPWR VPWR _01192_ sky130_fd_sc_hd__mux2_1
X_09040_ _03689_ _03690_ _03746_ _03781_ _03745_ VGND VGND VPWR VPWR _03782_ sky130_fd_sc_hd__a311oi_2
XFILLER_0_72_434 VGND VGND VPWR VPWR sky130_fd_sc_hd__fill_2
XFILLER_0_115_536 VGND VGND VPWR VPWR sky130_fd_sc_hd__decap_8
XFILLER_0_4_233 VPWR VGND VPWR VGND sky130_ef_sc_hd__decap_12
X_05203_ _04783_ mac_inst.x\[0\] _04852_ _04906_ VGND VGND VPWR VPWR _04907_ sky130_fd_sc_hd__a31o_2
XFILLER_0_25_361 VGND VGND VPWR VPWR sky130_fd_sc_hd__decap_4
XFILLER_0_111_51 VGND VGND VPWR VPWR sky130_fd_sc_hd__decap_4
X_06183_ _01125_ _01126_ tanh_inst.divider.i\[2\] VGND VGND VPWR VPWR _01127_ sky130_fd_sc_hd__mux2_1
XTAP_TAPCELL_ROW_92_1417 VGND VPWR sky130_fd_sc_hd__tapvpwrvgnd_1
XTAP_TAPCELL_ROW_92_1406 VGND VPWR sky130_fd_sc_hd__tapvpwrvgnd_1
XFILLER_0_4_277 VPWR VGND VPWR VGND sky130_ef_sc_hd__decap_12
XFILLER_0_13_556 VGND VGND VPWR VPWR sky130_fd_sc_hd__decap_4
X_05134_ mac_inst.i\[9\] mac_inst.i\[8\] mac_inst.i\[11\] mac_inst.i\[10\] VGND VGND
+ VPWR VPWR _04838_ sky130_fd_sc_hd__or4_2
X_05065_ mac_inst.i\[1\] VGND VGND VPWR VPWR _04789_ sky130_fd_sc_hd__inv_2
X_09942_ _04527_ _04528_ _04602_ _04659_ VGND VGND VPWR VPWR _04660_ sky130_fd_sc_hd__a211o_2
XFILLER_0_40_386 VGND VGND VPWR VPWR sky130_fd_sc_hd__decap_4
XFILLER_0_96_64 VGND VGND VPWR VPWR sky130_fd_sc_hd__decap_8
XFILLER_0_0_461 VPWR VGND VPWR VGND sky130_ef_sc_hd__decap_12
X_09873_ tanh_inst.divider.y\[2\] _04585_ VGND VGND VPWR VPWR _04593_ sky130_fd_sc_hd__nor2_2
X_08824_ _02052_ _03568_ _03569_ VGND VGND VPWR VPWR _03570_ sky130_fd_sc_hd__o21a_2
X_08755_ mac_inst.i\[27\] mac_inst.i\[26\] _00968_ VGND VGND VPWR VPWR _03506_ sky130_fd_sc_hd__and3_2
X_07706_ tanh_inst.LOOKUP.index\[3\] _04762_ VGND VGND VPWR VPWR _02509_ sky130_fd_sc_hd__nand2_2
X_05967_ mac_inst.z\[31\] _00921_ _00922_ _04803_ VGND VGND VPWR VPWR _00924_ sky130_fd_sc_hd__a211o_2
X_08686_ _03454_ _03455_ _03464_ _03465_ VGND VGND VPWR VPWR _03466_ sky130_fd_sc_hd__o22ai_2
X_05898_ _00831_ _00857_ _00858_ _00860_ VGND VGND VPWR VPWR _00861_ sky130_fd_sc_hd__o211ai_2
XFILLER_0_95_559 VGND VGND VPWR VPWR sky130_fd_sc_hd__fill_1
X_07637_ _02437_ _02440_ _02053_ VGND VGND VPWR VPWR _02441_ sky130_fd_sc_hd__mux2_1
XTAP_TAPCELL_ROW_101_1524 VGND VPWR sky130_fd_sc_hd__tapvpwrvgnd_1
XFILLER_0_82_209 VGND VGND VPWR VPWR sky130_fd_sc_hd__decap_4
X_07568_ _02373_ VGND VGND VPWR VPWR _02374_ sky130_fd_sc_hd__inv_2
X_06519_ _01398_ _01436_ _01437_ VGND VGND VPWR VPWR _01438_ sky130_fd_sc_hd__a21o_2
X_09307_ _04034_ _04042_ _04791_ VGND VGND VPWR VPWR _04043_ sky130_fd_sc_hd__mux2_1
XFILLER_0_0_81 VGND VGND VPWR VPWR sky130_fd_sc_hd__decap_3
XFILLER_0_106_514 VPWR VGND VPWR VGND sky130_ef_sc_hd__decap_12
X_07499_ _02304_ _02305_ VGND VGND VPWR VPWR _02306_ sky130_fd_sc_hd__nor2_2
XFILLER_0_63_445 VGND VGND VPWR VPWR sky130_fd_sc_hd__decap_3
XFILLER_0_90_253 VGND VGND VPWR VPWR sky130_fd_sc_hd__fill_1
X_09238_ _03949_ _03951_ _03948_ VGND VGND VPWR VPWR _03976_ sky130_fd_sc_hd__a21oi_2
XFILLER_0_121_517 VGND VGND VPWR VPWR sky130_fd_sc_hd__decap_4
X_09169_ _02018_ _03908_ VGND VGND VPWR VPWR _03909_ sky130_fd_sc_hd__nand2_2
XFILLER_0_121_528 VGND VGND VPWR VPWR sky130_fd_sc_hd__decap_4
XFILLER_0_8_3 VPWR VGND VPWR VGND sky130_ef_sc_hd__decap_12
XTAP_TAPCELL_ROW_112_1664 VGND VPWR sky130_fd_sc_hd__tapvpwrvgnd_1
XFILLER_0_101_296 VGND VGND VPWR VPWR sky130_fd_sc_hd__fill_1
X_10013_ _04726_ _04727_ _04725_ VGND VGND VPWR VPWR _04729_ sky130_fd_sc_hd__o21ai_2
XFILLER_0_116_29 VPWR VGND VPWR VGND sky130_ef_sc_hd__decap_12
XFILLER_0_25_27 VPWR VGND VPWR VGND sky130_ef_sc_hd__decap_12
XTAP_TAPCELL_ROW_47_849 VGND VPWR sky130_fd_sc_hd__tapvpwrvgnd_1
XTAP_TAPCELL_ROW_27_595 VGND VPWR sky130_fd_sc_hd__tapvpwrvgnd_1
XFILLER_0_27_615 VGND VGND VPWR VPWR sky130_fd_sc_hd__fill_1
XFILLER_0_66_294 VGND VGND VPWR VPWR sky130_fd_sc_hd__fill_1
XFILLER_0_14_309 VPWR VGND VPWR VGND sky130_ef_sc_hd__decap_12
XFILLER_0_42_607 VGND VGND VPWR VPWR sky130_fd_sc_hd__fill_1
XFILLER_0_35_670 VGND VGND VPWR VPWR sky130_fd_sc_hd__fill_2
XFILLER_0_105_580 VGND VGND VPWR VPWR sky130_fd_sc_hd__decap_3
XFILLER_0_1_225 VPWR VGND VPWR VGND sky130_ef_sc_hd__decap_12
XFILLER_0_22_353 VGND VGND VPWR VPWR sky130_fd_sc_hd__decap_6
XFILLER_0_10_559 VGND VGND VPWR VPWR sky130_fd_sc_hd__decap_4
XFILLER_0_5_15 VPWR VGND VPWR VGND sky130_ef_sc_hd__decap_12
X_06870_ _01753_ _01755_ VGND VGND VPWR VPWR _01756_ sky130_fd_sc_hd__nor2_2
X_05821_ mac_inst.z\[11\] _00787_ VGND VGND VPWR VPWR _00789_ sky130_fd_sc_hd__nor2_2
X_05752_ mac_inst.z\[5\] _00722_ VGND VGND VPWR VPWR _00726_ sky130_fd_sc_hd__and2_2
X_08540_ _02018_ _03323_ VGND VGND VPWR VPWR _03324_ sky130_fd_sc_hd__nor2_2
XFILLER_0_77_548 VPWR VGND VPWR VGND sky130_ef_sc_hd__decap_12
XFILLER_0_77_526 VPWR VGND VPWR VGND sky130_ef_sc_hd__decap_12
X_05683_ mac_inst.z\[0\] _04982_ VGND VGND VPWR VPWR _00662_ sky130_fd_sc_hd__nor2_2
X_08471_ _03254_ _03255_ VGND VGND VPWR VPWR _03256_ sky130_fd_sc_hd__xor2_2
XFILLER_0_119_105 VGND VGND VPWR VPWR sky130_fd_sc_hd__decap_6
X_07422_ tanh_inst.divider.x\[-24\] _02103_ _02161_ _02160_ VGND VGND VPWR VPWR _02230_
+ sky130_fd_sc_hd__a31o_2
XFILLER_0_15_93 VPWR VGND VPWR VGND sky130_ef_sc_hd__decap_12
XFILLER_0_119_149 VPWR VGND VPWR VGND sky130_ef_sc_hd__decap_12
X_07353_ _02160_ _02161_ VGND VGND VPWR VPWR _02162_ sky130_fd_sc_hd__and2b_2
XFILLER_0_17_125 VPWR VGND VPWR VGND sky130_ef_sc_hd__decap_12
X_06304_ _01039_ _01117_ _01239_ VGND VGND VPWR VPWR _01240_ sky130_fd_sc_hd__o21a_2
X_07284_ tanh_inst.divider.y\[-8\] _02028_ _02029_ VGND VGND VPWR VPWR _02094_ sky130_fd_sc_hd__o21a_2
XFILLER_0_17_169 VPWR VGND VPWR VGND sky130_ef_sc_hd__decap_12
X_06235_ _01103_ _01141_ _01142_ _01100_ VGND VGND VPWR VPWR _01176_ sky130_fd_sc_hd__o22a_2
XFILLER_0_86_3 VGND VGND VPWR VPWR sky130_fd_sc_hd__fill_2
X_09023_ _01482_ _03593_ _03764_ _01486_ VGND VGND VPWR VPWR _03766_ sky130_fd_sc_hd__o22a_2
XFILLER_0_103_528 VGND VGND VPWR VPWR sky130_fd_sc_hd__decap_4
XFILLER_0_5_586 VGND VGND VPWR VPWR sky130_fd_sc_hd__decap_8
X_06166_ tanh_inst.divider.y_\[-22\] _01109_ VGND VGND VPWR VPWR _01111_ sky130_fd_sc_hd__xor2_2
XFILLER_0_41_684 VGND VGND VPWR VPWR sky130_fd_sc_hd__decap_3
X_06097_ _01027_ _01037_ _01043_ VGND VGND VPWR VPWR _01044_ sky130_fd_sc_hd__and3_2
X_05117_ mac_counter\[5\] _04825_ mac_counter\[6\] VGND VGND VPWR VPWR _04828_ sky130_fd_sc_hd__a21oi_2
X_05048_ tanh_inst.divider.x\[-14\] VGND VGND VPWR VPWR _04772_ sky130_fd_sc_hd__inv_2
X_09925_ tanh_inst.divider.y\[4\] _04641_ VGND VGND VPWR VPWR _04643_ sky130_fd_sc_hd__xnor2_2
X_09856_ tanh_inst.divider.y\[2\] _04575_ VGND VGND VPWR VPWR _04576_ sky130_fd_sc_hd__nand2_2
X_08807_ tanh_inst.divider.x\[-3\] _02028_ _03508_ VGND VGND VPWR VPWR _03553_ sky130_fd_sc_hd__o21ai_2
X_06999_ tanh_inst.divider.z_\[-17\] _01092_ _01837_ _01088_ VGND VGND VPWR VPWR _00204_
+ sky130_fd_sc_hd__a22o_2
XFILLER_0_99_139 VPWR VGND VPWR VGND sky130_ef_sc_hd__decap_12
X_09787_ _04507_ _04508_ VGND VGND VPWR VPWR _04509_ sky130_fd_sc_hd__xor2_2
XFILLER_0_68_504 VGND VGND VPWR VPWR sky130_fd_sc_hd__decap_8
X_08738_ mac_inst.i\[18\] _03497_ VGND VGND VPWR VPWR _03498_ sky130_fd_sc_hd__nor2_2
X_08669_ _03405_ _03406_ _03407_ VGND VGND VPWR VPWR _03449_ sky130_fd_sc_hd__o21ai_2
XTAP_TAPCELL_ROW_44_808 VGND VPWR sky130_fd_sc_hd__tapvpwrvgnd_1
XFILLER_0_64_721 VGND VGND VPWR VPWR sky130_fd_sc_hd__decap_3
XFILLER_0_36_401 VPWR VGND VPWR VGND sky130_ef_sc_hd__decap_12
XFILLER_0_119_661 VGND VGND VPWR VPWR sky130_fd_sc_hd__decap_8
XFILLER_0_63_220 VGND VGND VPWR VPWR sky130_fd_sc_hd__decap_4
XTAP_TAPCELL_ROW_62_1040 VGND VPWR sky130_fd_sc_hd__tapvpwrvgnd_1
XTAP_TAPCELL_ROW_24_565 VGND VPWR sky130_fd_sc_hd__tapvpwrvgnd_1
XFILLER_0_36_434 VPWR VGND VPWR VGND sky130_ef_sc_hd__decap_12
XFILLER_0_8_391 VGND VGND VPWR VPWR sky130_fd_sc_hd__fill_1
XFILLER_0_63_275 VGND VGND VPWR VPWR sky130_fd_sc_hd__decap_4
XFILLER_0_36_489 VGND VGND VPWR VPWR sky130_fd_sc_hd__decap_6
XFILLER_0_102_572 VPWR VGND VPWR VGND sky130_ef_sc_hd__decap_12
XTAP_TAPCELL_ROW_73_1180 VGND VPWR sky130_fd_sc_hd__tapvpwrvgnd_1
XFILLER_0_36_15 VPWR VGND VPWR VGND sky130_ef_sc_hd__decap_12
XFILLER_0_98_183 VPWR VGND VPWR VGND sky130_ef_sc_hd__decap_12
XFILLER_0_86_345 VGND VGND VPWR VPWR sky130_fd_sc_hd__decap_8
XFILLER_0_55_721 VGND VGND VPWR VPWR sky130_fd_sc_hd__decap_3
XFILLER_0_67_581 VGND VGND VPWR VPWR sky130_fd_sc_hd__decap_4
XFILLER_0_27_434 VGND VGND VPWR VPWR sky130_fd_sc_hd__decap_3
XFILLER_0_54_253 VGND VGND VPWR VPWR sky130_fd_sc_hd__decap_4
XFILLER_0_54_242 VGND VGND VPWR VPWR sky130_fd_sc_hd__decap_3
XFILLER_0_42_404 VGND VGND VPWR VPWR sky130_fd_sc_hd__decap_8
XTAP_TAPCELL_ROW_76_1209 VGND VPWR sky130_fd_sc_hd__tapvpwrvgnd_1
XFILLER_0_14_139 VGND VGND VPWR VPWR sky130_fd_sc_hd__fill_1
X_06020_ mac_inst.z\[25\] _00972_ VGND VGND VPWR VPWR _00974_ sky130_fd_sc_hd__or2_2
XFILLER_0_112_336 VGND VGND VPWR VPWR sky130_fd_sc_hd__decap_4
XFILLER_0_10_301 VGND VGND VPWR VPWR sky130_fd_sc_hd__decap_6
XFILLER_0_23_673 VPWR VGND VPWR VGND sky130_ef_sc_hd__decap_12
XFILLER_0_2_589 VPWR VGND VPWR VGND sky130_ef_sc_hd__decap_12
X_07971_ _02752_ _02766_ VGND VGND VPWR VPWR _02768_ sky130_fd_sc_hd__nor2_2
XFILLER_0_10_345 VPWR VGND VPWR VGND sky130_ef_sc_hd__decap_12
X_06922_ tanh_inst.div_en tanh_inst.divider.z_\[4\] VGND VGND VPWR VPWR _00193_ sky130_fd_sc_hd__and2b_2
X_09710_ _04433_ _04434_ _02015_ VGND VGND VPWR VPWR _04435_ sky130_fd_sc_hd__a21o_2
X_06853_ _01734_ _01737_ _01733_ VGND VGND VPWR VPWR _01741_ sky130_fd_sc_hd__o21ba_2
X_09641_ tanh_inst.divider.y\[-4\] _04366_ VGND VGND VPWR VPWR _04367_ sky130_fd_sc_hd__nor2_2
XTAP_TAPCELL_ROW_87_1349 VGND VPWR sky130_fd_sc_hd__tapvpwrvgnd_1
X_05804_ _04943_ _00772_ VGND VGND VPWR VPWR _00773_ sky130_fd_sc_hd__nand2_2
X_09572_ _04297_ _04299_ VGND VGND VPWR VPWR _04300_ sky130_fd_sc_hd__xor2_2
X_06784_ _01676_ _01679_ VGND VGND VPWR VPWR _01681_ sky130_fd_sc_hd__nand2_2
XFILLER_0_77_301 VPWR VGND VPWR VGND sky130_ef_sc_hd__decap_12
X_05735_ _04795_ _00709_ _00705_ VGND VGND VPWR VPWR _00710_ sky130_fd_sc_hd__a21o_2
X_08523_ _03232_ _03306_ _03258_ VGND VGND VPWR VPWR _03307_ sky130_fd_sc_hd__o21a_2
XFILLER_0_65_529 VPWR VGND VPWR VGND sky130_ef_sc_hd__decap_12
XFILLER_0_9_111 VGND VGND VPWR VPWR sky130_fd_sc_hd__fill_1
X_08454_ _03079_ _03237_ _03238_ _03239_ VGND VGND VPWR VPWR _03240_ sky130_fd_sc_hd__o211a_2
X_05666_ mac_inst.y\[29\] _00646_ VGND VGND VPWR VPWR _00648_ sky130_fd_sc_hd__nor2_2
X_07405_ _02027_ _02069_ _02127_ VGND VGND VPWR VPWR _02213_ sky130_fd_sc_hd__o21a_2
XFILLER_0_18_412 VGND VGND VPWR VPWR sky130_fd_sc_hd__decap_8
X_08385_ _03163_ _03170_ VGND VGND VPWR VPWR _03172_ sky130_fd_sc_hd__nor2_2
X_05597_ _00580_ _00585_ VGND VGND VPWR VPWR _05597_/X sky130_fd_sc_hd__xor2_2
XFILLER_0_45_220 VGND VGND VPWR VPWR sky130_fd_sc_hd__decap_4
X_07336_ tanh_inst.divider.y\[-19\] tanh_inst.divider.y\[-18\] tanh_inst.LOOKUP.index\[0\]
+ VGND VGND VPWR VPWR _02145_ sky130_fd_sc_hd__mux2_1
XTAP_TAPCELL_ROW_21_524 VGND VPWR sky130_fd_sc_hd__tapvpwrvgnd_1
XFILLER_0_115_141 VGND VGND VPWR VPWR sky130_fd_sc_hd__fill_1
XTAP_TAPCELL_ROW_98_1489 VGND VPWR sky130_fd_sc_hd__tapvpwrvgnd_1
X_09006_ _02303_ _03739_ VGND VGND VPWR VPWR _03749_ sky130_fd_sc_hd__or2_2
X_07267_ _02071_ _02073_ _02075_ _02072_ _04760_ _04761_ VGND VGND VPWR VPWR _02077_
+ sky130_fd_sc_hd__mux4_2
XFILLER_0_5_361 VPWR VGND VPWR VGND sky130_ef_sc_hd__decap_12
X_06218_ _01079_ _01141_ _01142_ _01074_ VGND VGND VPWR VPWR _01160_ sky130_fd_sc_hd__o22a_2
X_07198_ tanh_inst.IS_Z_ZERO _01501_ _01470_ VGND VGND VPWR VPWR _00229_ sky130_fd_sc_hd__o21a_2
XFILLER_0_60_289 VGND VGND VPWR VPWR sky130_fd_sc_hd__fill_1
XFILLER_0_13_161 VGND VGND VPWR VPWR sky130_fd_sc_hd__decap_6
XFILLER_0_20_109 VPWR VGND VPWR VGND sky130_ef_sc_hd__decap_12
X_06149_ tanh_inst.divider.x\[-2\] tanh_inst.divider.x\[-1\] tanh_inst.divider.x\[0\]
+ tanh_inst.divider.x\[1\] tanh_inst.divider.i\[0\] tanh_inst.divider.i\[1\] VGND
+ VGND VPWR VPWR _01094_ sky130_fd_sc_hd__mux4_2
X_09908_ _04626_ _04625_ _04614_ tanh_inst.z_\[7\] VGND VGND VPWR VPWR _04627_ sky130_fd_sc_hd__o2bb2a_2
X_09839_ _04558_ _04559_ VGND VGND VPWR VPWR _04560_ sky130_fd_sc_hd__and2b_2
XTAP_TAPCELL_ROW_29_624 VGND VPWR sky130_fd_sc_hd__tapvpwrvgnd_1
XTAP_TAPCELL_ROW_57_977 VGND VPWR sky130_fd_sc_hd__tapvpwrvgnd_1
XFILLER_0_96_643 VGND VGND VPWR VPWR sky130_fd_sc_hd__fill_1
XFILLER_0_95_131 VGND VGND VPWR VPWR sky130_fd_sc_hd__fill_1
XFILLER_0_68_345 VPWR VGND VPWR VGND sky130_ef_sc_hd__decap_12
XTAP_TAPCELL_ROW_1_271 VGND VPWR sky130_fd_sc_hd__tapvpwrvgnd_1
XTAP_TAPCELL_ROW_107_1596 VGND VPWR sky130_fd_sc_hd__tapvpwrvgnd_1
XFILLER_0_95_164 VGND VGND VPWR VPWR sky130_fd_sc_hd__decap_4
XFILLER_0_68_389 VGND VGND VPWR VPWR sky130_fd_sc_hd__decap_8
XTAP_TAPCELL_ROW_120_1763 VGND VPWR sky130_fd_sc_hd__tapvpwrvgnd_1
XFILLER_0_83_337 VGND VGND VPWR VPWR sky130_fd_sc_hd__fill_1
XFILLER_0_106_141 VGND VGND VPWR VPWR sky130_fd_sc_hd__decap_8
XFILLER_0_91_381 VGND VGND VPWR VPWR sky130_fd_sc_hd__decap_8
XFILLER_0_51_223 VGND VGND VPWR VPWR sky130_fd_sc_hd__fill_1
X_10476_ clknet_leaf_25_clk _00333_ VGND VGND VPWR VPWR tanh_inst.LOOKUP.index\[4\]
+ sky130_fd_sc_hd__dfxtp_2
XTAP_TAPCELL_ROW_9_371 VGND VPWR sky130_fd_sc_hd__tapvpwrvgnd_1
XFILLER_0_2_27 VGND VGND VPWR VPWR sky130_fd_sc_hd__fill_1
XFILLER_0_63_46 VGND VGND VPWR VPWR sky130_fd_sc_hd__decap_4
XFILLER_0_63_68 VGND VGND VPWR VPWR sky130_fd_sc_hd__fill_2
XFILLER_0_59_345 VGND VGND VPWR VPWR sky130_fd_sc_hd__fill_1
XFILLER_0_59_334 VGND VGND VPWR VPWR sky130_fd_sc_hd__fill_2
X_05520_ mac_inst.y\[15\] _00515_ VGND VGND VPWR VPWR _00516_ sky130_fd_sc_hd__nand2_2
XFILLER_0_47_529 VGND VGND VPWR VPWR sky130_fd_sc_hd__fill_1
XFILLER_0_86_197 VGND VGND VPWR VPWR sky130_fd_sc_hd__fill_2
X_05451_ _04835_ _00451_ _05020_ VGND VGND VPWR VPWR _00452_ sky130_fd_sc_hd__a21o_2
XPHY_EDGE_ROW_120_Right_120 VGND VGND VPWR VPWR sky130_fd_sc_hd__decap_3
XFILLER_0_7_637 VGND VGND VPWR VPWR sky130_fd_sc_hd__decap_3
X_08170_ _02960_ _02961_ VGND VGND VPWR VPWR _02962_ sky130_fd_sc_hd__nand2_2
X_07121_ _01943_ _01945_ VGND VGND VPWR VPWR _01946_ sky130_fd_sc_hd__nor2_2
X_05382_ mac_inst.i\[2\] _04996_ VGND VGND VPWR VPWR _00388_ sky130_fd_sc_hd__nor2_2
XFILLER_0_113_612 VGND VGND VPWR VPWR sky130_fd_sc_hd__decap_4
XFILLER_0_12_83 VGND VGND VPWR VPWR sky130_fd_sc_hd__fill_1
X_07052_ _01088_ _00178_ _01884_ _01059_ VGND VGND VPWR VPWR _00210_ sky130_fd_sc_hd__o22a_2
XFILLER_0_30_418 VGND VGND VPWR VPWR sky130_fd_sc_hd__fill_2
XFILLER_0_23_492 VPWR VGND VPWR VGND sky130_ef_sc_hd__decap_12
X_06003_ _00954_ _00956_ VGND VGND VPWR VPWR _00957_ sky130_fd_sc_hd__nand2_2
XFILLER_0_10_153 VPWR VGND VPWR VGND sky130_ef_sc_hd__decap_12
X_07954_ _02022_ _02389_ _02488_ VGND VGND VPWR VPWR _02751_ sky130_fd_sc_hd__o21ai_2
XFILLER_0_10_197 VPWR VGND VPWR VGND sky130_ef_sc_hd__decap_12
XFILLER_0_49_3 VPWR VGND VPWR VGND sky130_ef_sc_hd__decap_12
X_06905_ tanh_inst.div_en tanh_inst.divider.z_\[-13\] VGND VGND VPWR VPWR _00176_
+ sky130_fd_sc_hd__and2b_2
X_07885_ tanh_inst.divider.x\[-13\] _02682_ VGND VGND VPWR VPWR _02684_ sky130_fd_sc_hd__nand2_2
X_06836_ _01720_ _01724_ _01725_ _01503_ VGND VGND VPWR VPWR _01727_ sky130_fd_sc_hd__a31oi_2
X_09624_ _04309_ _04314_ _04349_ tanh_inst.z_\[7\] VGND VGND VPWR VPWR _04351_ sky130_fd_sc_hd__a31o_2
XFILLER_0_97_429 VGND VGND VPWR VPWR sky130_fd_sc_hd__decap_3
XFILLER_0_77_131 VGND VGND VPWR VPWR sky130_fd_sc_hd__decap_6
X_09555_ _04255_ _04264_ _04262_ VGND VGND VPWR VPWR _04284_ sky130_fd_sc_hd__a21o_2
X_06767_ _01486_ _01513_ _01531_ VGND VGND VPWR VPWR _01665_ sky130_fd_sc_hd__o21a_2
XTAP_TAPCELL_ROW_54_936 VGND VPWR sky130_fd_sc_hd__tapvpwrvgnd_1
XFILLER_0_93_613 VGND VGND VPWR VPWR sky130_fd_sc_hd__decap_3
XFILLER_0_93_602 VGND VGND VPWR VPWR sky130_fd_sc_hd__decap_3
XFILLER_0_78_676 VGND VGND VPWR VPWR sky130_fd_sc_hd__decap_4
X_09486_ tanh_inst.divider.y\[-9\] _04216_ VGND VGND VPWR VPWR _04217_ sky130_fd_sc_hd__xnor2_2
X_06698_ _01602_ _01603_ VGND VGND VPWR VPWR _01604_ sky130_fd_sc_hd__xnor2_2
X_05718_ _04795_ _00682_ _00692_ VGND VGND VPWR VPWR _00694_ sky130_fd_sc_hd__a21o_2
X_08506_ _03245_ _03278_ VGND VGND VPWR VPWR _03290_ sky130_fd_sc_hd__or2_2
XFILLER_0_93_635 VGND VGND VPWR VPWR sky130_fd_sc_hd__fill_1
XFILLER_0_65_337 VPWR VGND VPWR VGND sky130_ef_sc_hd__decap_12
X_08437_ _03172_ _03221_ _03222_ VGND VGND VPWR VPWR _03223_ sky130_fd_sc_hd__and3b_2
X_05649_ _00631_ _00632_ VGND VGND VPWR VPWR _05649_/Y sky130_fd_sc_hd__xnor2_2
XFILLER_0_80_307 VGND VGND VPWR VPWR sky130_fd_sc_hd__fill_1
XFILLER_0_18_253 VPWR VGND VPWR VGND sky130_ef_sc_hd__decap_12
XTAP_TAPCELL_ROW_34_682 VGND VPWR sky130_fd_sc_hd__tapvpwrvgnd_1
XTAP_TAPCELL_ROW_34_693 VGND VPWR sky130_fd_sc_hd__tapvpwrvgnd_1
XFILLER_0_92_178 VGND VGND VPWR VPWR sky130_fd_sc_hd__fill_2
X_08368_ _03036_ _03091_ _03092_ VGND VGND VPWR VPWR _03156_ sky130_fd_sc_hd__a21oi_2
X_07319_ tanh_inst.divider.y\[5\] _02028_ _02029_ _04761_ VGND VGND VPWR VPWR _02128_
+ sky130_fd_sc_hd__o211a_2
XPHY_EDGE_ROW_12_Left_134 VGND VGND VPWR VPWR sky130_fd_sc_hd__decap_3
X_08299_ tanh_inst.divider.y\[-3\] _03086_ VGND VGND VPWR VPWR _03088_ sky130_fd_sc_hd__and2_2
XFILLER_0_104_645 VGND VGND VPWR VPWR sky130_fd_sc_hd__decap_4
X_10330_ clknet_leaf_17_clk _00187_ VGND VGND VPWR VPWR tanh_out[22] sky130_fd_sc_hd__dfxtp_2
XFILLER_0_61_576 VGND VGND VPWR VPWR sky130_fd_sc_hd__fill_1
XFILLER_0_104_689 VGND VGND VPWR VPWR sky130_fd_sc_hd__decap_8
X_10261_ clknet_leaf_32_clk mac_inst.x\[23\] _00000_ VGND VGND VPWR VPWR mac_x_out[23]
+ sky130_fd_sc_hd__dfrtp_2
X_10192_ x_in[18] _00000_ VGND VGND VPWR VPWR mac_inst.x\[18\] sky130_fd_sc_hd__dlxtn_1
XTAP_TAPCELL_ROW_6_341 VGND VPWR sky130_fd_sc_hd__tapvpwrvgnd_1
XPHY_EDGE_ROW_21_Left_143 VGND VGND VPWR VPWR sky130_fd_sc_hd__decap_3
XTAP_TAPCELL_ROW_109_1625 VGND VPWR sky130_fd_sc_hd__tapvpwrvgnd_1
XFILLER_0_17_39 VPWR VGND VPWR VGND sky130_ef_sc_hd__decap_12
XFILLER_0_96_440 VPWR VGND VPWR VGND sky130_ef_sc_hd__decap_12
XFILLER_0_84_613 VGND VGND VPWR VPWR sky130_fd_sc_hd__fill_2
XFILLER_0_56_326 VGND VGND VPWR VPWR sky130_fd_sc_hd__decap_4
XPHY_EDGE_ROW_30_Left_152 VGND VGND VPWR VPWR sky130_fd_sc_hd__decap_3
XFILLER_0_107_472 VGND VGND VPWR VPWR sky130_fd_sc_hd__decap_8
XFILLER_0_4_629 VGND VGND VPWR VPWR sky130_fd_sc_hd__decap_8
XFILLER_0_24_234 VPWR VGND VPWR VGND sky130_ef_sc_hd__decap_12
XFILLER_0_24_289 VPWR VGND VPWR VGND sky130_ef_sc_hd__decap_12
X_10459_ clknet_leaf_0_clk _00316_ VGND VGND VPWR VPWR tanh_inst.divider.y\[-5\] sky130_fd_sc_hd__dfxtp_2
XTAP_TAPCELL_ROW_84_1308 VGND VPWR sky130_fd_sc_hd__tapvpwrvgnd_1
X_07670_ tanh_inst.LOOKUP.index\[4\] _02473_ _02470_ VGND VGND VPWR VPWR _02474_ sky130_fd_sc_hd__a21oi_2
X_06621_ _01521_ _01532_ _01533_ VGND VGND VPWR VPWR _01534_ sky130_fd_sc_hd__and3b_2
X_09340_ _04791_ _04062_ _04063_ _04073_ _04074_ VGND VGND VPWR VPWR _04075_ sky130_fd_sc_hd__a32o_2
XFILLER_0_75_613 VGND VGND VPWR VPWR sky130_fd_sc_hd__decap_3
X_06552_ tanh_counter\[5\] tanh_counter\[4\] tanh_counter\[1\] tanh_counter\[0\] VGND
+ VGND VPWR VPWR _01467_ sky130_fd_sc_hd__or4_2
XFILLER_0_75_646 VGND VGND VPWR VPWR sky130_fd_sc_hd__decap_4
XFILLER_0_59_175 VGND VGND VPWR VPWR sky130_fd_sc_hd__fill_1
X_09271_ tanh_inst.LOOKUP.index\[4\] _04006_ _04007_ VGND VGND VPWR VPWR _04008_ sky130_fd_sc_hd__a21bo_2
X_05503_ _00497_ _00499_ VGND VGND VPWR VPWR _00500_ sky130_fd_sc_hd__xor2_2
XFILLER_0_47_326 VGND VGND VPWR VPWR sky130_fd_sc_hd__decap_8
XFILLER_0_47_337 VGND VGND VPWR VPWR sky130_fd_sc_hd__decap_6
X_06483_ tanh_inst.divider.y_\[1\] _01403_ VGND VGND VPWR VPWR _01405_ sky130_fd_sc_hd__nand2_2
X_08222_ _02955_ _02957_ _03011_ VGND VGND VPWR VPWR _03013_ sky130_fd_sc_hd__o21a_2
XFILLER_0_47_359 VGND VGND VPWR VPWR sky130_fd_sc_hd__decap_3
XFILLER_0_62_329 VPWR VGND VPWR VGND sky130_ef_sc_hd__decap_12
XFILLER_0_23_93 VPWR VGND VPWR VGND sky130_ef_sc_hd__decap_12
X_05434_ _00395_ _00408_ _00409_ _00423_ _00406_ VGND VGND VPWR VPWR _00437_ sky130_fd_sc_hd__o311a_2
XTAP_TAPCELL_ROW_31_652 VGND VPWR sky130_fd_sc_hd__tapvpwrvgnd_1
XFILLER_0_15_223 VGND VGND VPWR VPWR sky130_fd_sc_hd__fill_1
X_05365_ _00370_ _00371_ _04781_ VGND VGND VPWR VPWR _00372_ sky130_fd_sc_hd__mux2_1
XFILLER_0_43_521 VGND VGND VPWR VPWR sky130_fd_sc_hd__fill_2
X_08153_ _02944_ _02945_ VGND VGND VPWR VPWR _02946_ sky130_fd_sc_hd__xor2_2
XFILLER_0_99_75 VGND VGND VPWR VPWR sky130_fd_sc_hd__fill_1
X_07104_ _01929_ _01930_ VGND VGND VPWR VPWR _01931_ sky130_fd_sc_hd__xor2_2
X_08084_ _02794_ _02843_ _02877_ _02797_ _02844_ VGND VGND VPWR VPWR _02878_ sky130_fd_sc_hd__o221a_2
XFILLER_0_31_716 VGND VGND VPWR VPWR sky130_fd_sc_hd__decap_8
X_07035_ _01039_ _01799_ VGND VGND VPWR VPWR _01869_ sky130_fd_sc_hd__or2_2
XTAP_TAPCELL_ROW_95_1448 VGND VPWR sky130_fd_sc_hd__tapvpwrvgnd_1
X_05296_ _04856_ _04897_ _04899_ _04893_ _04783_ _04789_ VGND VGND VPWR VPWR _04996_
+ sky130_fd_sc_hd__mux4_2
X_08986_ _02027_ _03508_ _03590_ _02024_ VGND VGND VPWR VPWR _03729_ sky130_fd_sc_hd__a31o_2
XTAP_TAPCELL_ROW_3_300 VGND VPWR sky130_fd_sc_hd__tapvpwrvgnd_1
X_07937_ tanh_inst.LOOKUP.index\[4\] _02733_ _02734_ VGND VGND VPWR VPWR _02735_ sky130_fd_sc_hd__a21bo_2
X_07868_ tanh_inst.divider.y\[-13\] tanh_inst.divider.x\[-13\] VGND VGND VPWR VPWR
+ _02667_ sky130_fd_sc_hd__or2_2
XFILLER_0_3_81 VPWR VGND VPWR VGND sky130_ef_sc_hd__decap_12
XTAP_TAPCELL_ROW_39_752 VGND VPWR sky130_fd_sc_hd__tapvpwrvgnd_1
X_09607_ _02053_ _03738_ _04193_ VGND VGND VPWR VPWR _04334_ sky130_fd_sc_hd__o21a_2
X_06819_ _01502_ _01710_ _01711_ _01469_ mac_y_out[22] VGND VGND VPWR VPWR _00150_
+ sky130_fd_sc_hd__a32o_2
X_07799_ tanh_inst.LOOKUP.index\[3\] _02184_ _02509_ VGND VGND VPWR VPWR _02600_ sky130_fd_sc_hd__o21ai_2
X_09538_ _02019_ _04235_ _04236_ _02014_ VGND VGND VPWR VPWR _04268_ sky130_fd_sc_hd__o31ai_2
XTAP_TAPCELL_ROW_104_1566 VGND VPWR sky130_fd_sc_hd__tapvpwrvgnd_1
X_09469_ tanh_inst.divider.x\[-9\] _04198_ VGND VGND VPWR VPWR _04200_ sky130_fd_sc_hd__xor2_2
XFILLER_0_93_454 VGND VGND VPWR VPWR sky130_fd_sc_hd__decap_6
XFILLER_0_65_167 VGND VGND VPWR VPWR sky130_fd_sc_hd__fill_1
XFILLER_0_19_573 VGND VGND VPWR VPWR sky130_fd_sc_hd__fill_1
XFILLER_0_80_148 VPWR VGND VPWR VGND sky130_ef_sc_hd__decap_12
XTAP_TAPCELL_ROW_59_1001 VGND VPWR sky130_fd_sc_hd__tapvpwrvgnd_1
XFILLER_0_34_554 VGND VGND VPWR VPWR sky130_fd_sc_hd__decap_4
X_10313_ clknet_leaf_16_clk _00170_ VGND VGND VPWR VPWR tanh_out[5] sky130_fd_sc_hd__dfxtp_2
XFILLER_0_61_373 VPWR VGND VPWR VGND sky130_ef_sc_hd__decap_12
XFILLER_0_0_109 VGND VGND VPWR VPWR sky130_fd_sc_hd__decap_3
XFILLER_0_21_237 VPWR VGND VPWR VGND sky130_ef_sc_hd__decap_12
XFILLER_0_104_475 VGND VGND VPWR VPWR sky130_fd_sc_hd__fill_1
XTAP_TAPCELL_ROW_115_1695 VGND VPWR sky130_fd_sc_hd__tapvpwrvgnd_1
X_10244_ clknet_leaf_31_clk mac_inst.x\[6\] _00000_ VGND VGND VPWR VPWR mac_x_out[6]
+ sky130_fd_sc_hd__dfrtp_2
X_10175_ x_in[1] _00000_ VGND VGND VPWR VPWR mac_inst.x\[1\] sky130_fd_sc_hd__dlxtn_1
XFILLER_0_28_27 VGND VGND VPWR VPWR sky130_fd_sc_hd__fill_1
XFILLER_0_44_48 VPWR VGND VPWR VGND sky130_ef_sc_hd__decap_12
XFILLER_0_84_421 VGND VGND VPWR VPWR sky130_fd_sc_hd__fill_2
XFILLER_0_57_635 VGND VGND VPWR VPWR sky130_fd_sc_hd__fill_2
XFILLER_0_8_209 VPWR VGND VPWR VGND sky130_ef_sc_hd__decap_12
XTAP_TAPCELL_ROW_17_479 VGND VPWR sky130_fd_sc_hd__tapvpwrvgnd_1
XFILLER_0_44_329 VGND VGND VPWR VPWR sky130_fd_sc_hd__decap_3
XFILLER_0_71_137 VGND VGND VPWR VPWR sky130_fd_sc_hd__decap_4
XFILLER_0_107_3 VPWR VGND VPWR VGND sky130_ef_sc_hd__decap_12
XFILLER_0_69_23 VGND VGND VPWR VPWR sky130_fd_sc_hd__fill_1
XFILLER_0_8_15 VPWR VGND VPWR VGND sky130_ef_sc_hd__decap_12
X_05150_ mac_inst.x\[17\] _04852_ _04853_ VGND VGND VPWR VPWR _04854_ sky130_fd_sc_hd__a21oi_2
XFILLER_0_80_693 VGND VGND VPWR VPWR sky130_fd_sc_hd__decap_4
XFILLER_0_100_53 VPWR VGND VPWR VGND sky130_ef_sc_hd__decap_12
X_05081_ tanh_counter\[1\] tanh_counter\[0\] _04779_ VGND VGND VPWR VPWR _04804_ sky130_fd_sc_hd__and3_2
XFILLER_0_0_643 VGND VGND VPWR VPWR sky130_fd_sc_hd__fill_1
XFILLER_0_0_665 VGND VGND VPWR VPWR sky130_fd_sc_hd__decap_6
X_08840_ tanh_inst.divider.y\[-24\] _03572_ VGND VGND VPWR VPWR _03585_ sky130_fd_sc_hd__and2_2
XFILLER_0_85_11 VGND VGND VPWR VPWR sky130_fd_sc_hd__fill_2
XTAP_TAPCELL_ROW_90_1389 VGND VPWR sky130_fd_sc_hd__tapvpwrvgnd_1
XFILLER_0_109_51 VGND VGND VPWR VPWR sky130_fd_sc_hd__decap_4
X_08771_ tanh_inst.divider.x\[-15\] _02028_ _03508_ VGND VGND VPWR VPWR _03517_ sky130_fd_sc_hd__o21a_2
X_05983_ _00936_ _00937_ mac_inst.z\[24\] VGND VGND VPWR VPWR _00938_ sky130_fd_sc_hd__o21ai_2
X_07722_ _02507_ _02508_ VGND VGND VPWR VPWR _02525_ sky130_fd_sc_hd__nor2_2
XFILLER_0_79_215 VGND VGND VPWR VPWR sky130_fd_sc_hd__decap_8
X_07653_ _02357_ _02358_ _02406_ _02355_ VGND VGND VPWR VPWR _02457_ sky130_fd_sc_hd__o211ai_2
XTAP_TAPCELL_ROW_36_711 VGND VPWR sky130_fd_sc_hd__tapvpwrvgnd_1
X_06604_ _01472_ _01480_ VGND VGND VPWR VPWR _01517_ sky130_fd_sc_hd__nor2_2
X_09323_ _02022_ _03733_ _03916_ VGND VGND VPWR VPWR _04058_ sky130_fd_sc_hd__o21a_2
XFILLER_0_87_281 VPWR VGND VPWR VGND sky130_ef_sc_hd__decap_12
X_07584_ tanh_inst.divider.y\[7\] _02130_ _02025_ VGND VGND VPWR VPWR _02389_ sky130_fd_sc_hd__mux2_1
XFILLER_0_34_70 VGND VGND VPWR VPWR sky130_fd_sc_hd__fill_1
XFILLER_0_47_101 VGND VGND VPWR VPWR sky130_fd_sc_hd__decap_4
XFILLER_0_48_613 VPWR VGND VPWR VGND sky130_ef_sc_hd__decap_12
XFILLER_0_118_501 VGND VGND VPWR VPWR sky130_fd_sc_hd__fill_1
X_06535_ tanh_inst.divider.i\[4\] _01277_ _01289_ VGND VGND VPWR VPWR _01452_ sky130_fd_sc_hd__o21a_2
X_06466_ _01387_ _01388_ VGND VGND VPWR VPWR _01389_ sky130_fd_sc_hd__nor2_2
X_09254_ _02584_ _03990_ VGND VGND VPWR VPWR _03991_ sky130_fd_sc_hd__nor2_2
XFILLER_0_118_589 VGND VGND VPWR VPWR sky130_fd_sc_hd__decap_4
X_09185_ _03922_ _03923_ VGND VGND VPWR VPWR _03924_ sky130_fd_sc_hd__nor2_2
XFILLER_0_62_126 VPWR VGND VPWR VGND sky130_ef_sc_hd__decap_12
X_05417_ mac_inst.z\[31\] _00420_ VGND VGND VPWR VPWR _00421_ sky130_fd_sc_hd__or2_2
X_08205_ _02018_ _02995_ _02996_ VGND VGND VPWR VPWR _02997_ sky130_fd_sc_hd__and3_2
X_06397_ _04792_ _01323_ VGND VGND VPWR VPWR _01326_ sky130_fd_sc_hd__xnor2_2
X_08136_ _02927_ _02928_ VGND VGND VPWR VPWR _02929_ sky130_fd_sc_hd__xor2_2
XFILLER_0_50_80 VGND VGND VPWR VPWR sky130_fd_sc_hd__decap_4
XFILLER_0_120_209 VPWR VGND VPWR VGND sky130_ef_sc_hd__decap_12
X_05348_ _04854_ _04859_ _04897_ _04856_ mac_inst.i\[0\] _04789_ VGND VGND VPWR VPWR
+ _00356_ sky130_fd_sc_hd__mux4_2
XFILLER_0_16_587 VGND VGND VPWR VPWR sky130_fd_sc_hd__fill_1
XFILLER_0_113_250 VGND VGND VPWR VPWR sky130_fd_sc_hd__fill_2
X_08067_ _02860_ _02861_ VGND VGND VPWR VPWR _02862_ sky130_fd_sc_hd__xnor2_2
X_05279_ _04944_ _04955_ _04975_ _04978_ VGND VGND VPWR VPWR _04980_ sky130_fd_sc_hd__or4_2
X_07018_ tanh_inst.divider.z_\[-14\] _01853_ VGND VGND VPWR VPWR _01854_ sky130_fd_sc_hd__and2_2
XFILLER_0_3_492 VPWR VGND VPWR VGND sky130_ef_sc_hd__decap_12
XFILLER_0_101_467 VPWR VGND VPWR VGND sky130_ef_sc_hd__decap_12
XFILLER_0_11_281 VPWR VGND VPWR VGND sky130_ef_sc_hd__decap_12
X_08969_ tanh_inst.LOOKUP.index\[4\] _03705_ _03712_ VGND VGND VPWR VPWR _03713_ sky130_fd_sc_hd__a21oi_2
XFILLER_0_39_602 VGND VGND VPWR VPWR sky130_fd_sc_hd__fill_1
XFILLER_0_14_29 VPWR VGND VPWR VGND sky130_ef_sc_hd__decap_12
XFILLER_0_38_112 VGND VGND VPWR VPWR sky130_fd_sc_hd__fill_2
XTAP_TAPCELL_ROW_65_1071 VGND VPWR sky130_fd_sc_hd__tapvpwrvgnd_1
XFILLER_0_38_134 VGND VGND VPWR VPWR sky130_fd_sc_hd__decap_6
XFILLER_0_39_668 VGND VGND VPWR VPWR sky130_fd_sc_hd__decap_4
XFILLER_0_66_465 VGND VGND VPWR VPWR sky130_fd_sc_hd__decap_8
XTAP_TAPCELL_ROW_14_438 VGND VPWR sky130_fd_sc_hd__tapvpwrvgnd_1
XFILLER_0_26_307 VGND VGND VPWR VPWR sky130_fd_sc_hd__fill_1
XFILLER_0_19_381 VGND VGND VPWR VPWR sky130_fd_sc_hd__decap_8
XTAP_TAPCELL_ROW_117_1724 VGND VPWR sky130_fd_sc_hd__tapvpwrvgnd_1
XFILLER_0_61_192 VGND VGND VPWR VPWR sky130_fd_sc_hd__fill_2
X_10227_ clknet_leaf_28_clk mac_inst.y\[21\] _00000_ VGND VGND VPWR VPWR mac_y_out[21]
+ sky130_fd_sc_hd__dfrtp_2
X_10089_ clknet_leaf_5_clk _00106_ VGND VGND VPWR VPWR tanh_inst.divider.y_\[-4\]
+ sky130_fd_sc_hd__dfxtp_2
XFILLER_0_55_47 VGND VGND VPWR VPWR sky130_fd_sc_hd__fill_2
XFILLER_0_69_281 VGND VGND VPWR VPWR sky130_fd_sc_hd__fill_2
XFILLER_0_71_57 VGND VGND VPWR VPWR sky130_fd_sc_hd__fill_1
X_06320_ _01253_ _01254_ VGND VGND VPWR VPWR _01255_ sky130_fd_sc_hd__and2_2
XFILLER_0_84_251 VGND VGND VPWR VPWR sky130_fd_sc_hd__fill_1
XFILLER_0_17_329 VGND VGND VPWR VPWR sky130_fd_sc_hd__decap_6
X_06251_ _01125_ _01141_ _01142_ _01122_ VGND VGND VPWR VPWR _01191_ sky130_fd_sc_hd__o22a_2
XFILLER_0_38_690 VGND VGND VPWR VPWR sky130_fd_sc_hd__decap_8
X_05202_ mac_inst.i\[0\] mac_inst.x\[1\] _04852_ _04853_ mac_inst.i\[1\] VGND VGND
+ VPWR VPWR _04906_ sky130_fd_sc_hd__a311o_2
XTAP_TAPCELL_ROW_41_780 VGND VPWR sky130_fd_sc_hd__tapvpwrvgnd_1
X_06182_ tanh_inst.divider.x\[-9\] tanh_inst.divider.x\[-8\] tanh_inst.divider.x\[-7\]
+ tanh_inst.divider.x\[-6\] tanh_inst.divider.i\[0\] tanh_inst.divider.i\[1\] VGND
+ VGND VPWR VPWR _01126_ sky130_fd_sc_hd__mux4_2
XFILLER_0_4_245 VGND VGND VPWR VPWR sky130_fd_sc_hd__decap_6
XFILLER_0_40_321 VPWR VGND VPWR VGND sky130_ef_sc_hd__decap_12
XTAP_TAPCELL_ROW_92_1418 VGND VPWR sky130_fd_sc_hd__tapvpwrvgnd_1
XTAP_TAPCELL_ROW_92_1407 VGND VPWR sky130_fd_sc_hd__tapvpwrvgnd_1
XFILLER_0_4_289 VPWR VGND VPWR VGND sky130_ef_sc_hd__decap_12
XFILLER_0_20_83 VGND VGND VPWR VPWR sky130_fd_sc_hd__fill_1
X_05133_ mac_inst.i\[9\] mac_inst.i\[8\] VGND VGND VPWR VPWR _04837_ sky130_fd_sc_hd__or2_2
XFILLER_0_40_343 VGND VGND VPWR VPWR sky130_fd_sc_hd__decap_8
XFILLER_0_110_231 VPWR VGND VPWR VGND sky130_ef_sc_hd__decap_12
XFILLER_0_13_579 VGND VGND VPWR VPWR sky130_fd_sc_hd__fill_1
X_05064_ mac_inst.x\[31\] VGND VGND VPWR VPWR _04788_ sky130_fd_sc_hd__inv_2
X_09941_ _04601_ _04624_ VGND VGND VPWR VPWR _04659_ sky130_fd_sc_hd__nand2_2
XFILLER_0_40_365 VGND VGND VPWR VPWR sky130_fd_sc_hd__decap_3
XFILLER_0_0_473 VGND VGND VPWR VPWR sky130_fd_sc_hd__decap_3
XFILLER_0_40_398 VGND VGND VPWR VPWR sky130_fd_sc_hd__decap_4
X_09872_ tanh_inst.divider.y\[2\] _04585_ VGND VGND VPWR VPWR _04592_ sky130_fd_sc_hd__and2_2
X_08823_ _02022_ _03522_ _03538_ _02053_ VGND VGND VPWR VPWR _03569_ sky130_fd_sc_hd__a211o_2
X_05966_ _00914_ _00920_ VGND VGND VPWR VPWR _00923_ sky130_fd_sc_hd__nand2_2
X_08754_ mac_inst.i\[26\] _00968_ mac_inst.i\[27\] VGND VGND VPWR VPWR _03505_ sky130_fd_sc_hd__a21oi_2
XFILLER_0_31_3 VPWR VGND VPWR VGND sky130_ef_sc_hd__decap_12
X_07705_ _02462_ _02463_ _02460_ VGND VGND VPWR VPWR _02508_ sky130_fd_sc_hd__o21ba_2
XFILLER_0_95_505 VGND VGND VPWR VPWR sky130_fd_sc_hd__decap_6
X_08685_ _03462_ _03463_ tanh_inst.z_\[7\] VGND VGND VPWR VPWR _03465_ sky130_fd_sc_hd__o21ai_2
X_05897_ mac_inst.z\[15\] _00839_ _00859_ VGND VGND VPWR VPWR _00860_ sky130_fd_sc_hd__a21oi_2
XTAP_TAPCELL_ROW_49_880 VGND VPWR sky130_fd_sc_hd__tapvpwrvgnd_1
X_07636_ tanh_inst.divider.y\[7\] _02213_ _02214_ _02219_ _02025_ _02023_ VGND VGND
+ VPWR VPWR _02440_ sky130_fd_sc_hd__mux4_2
XFILLER_0_48_421 VPWR VGND VPWR VGND sky130_ef_sc_hd__decap_12
X_07567_ _01525_ _02372_ _02371_ _02370_ VGND VGND VPWR VPWR _02373_ sky130_fd_sc_hd__o211a_2
X_09306_ _04037_ _04039_ VGND VGND VPWR VPWR _04042_ sky130_fd_sc_hd__xnor2_2
X_06518_ _01417_ _01435_ _01434_ _01426_ VGND VGND VPWR VPWR _01437_ sky130_fd_sc_hd__a211o_2
XTAP_TAPCELL_ROW_101_1525 VGND VPWR sky130_fd_sc_hd__tapvpwrvgnd_1
X_09237_ _03973_ _03974_ _02019_ _03968_ VGND VGND VPWR VPWR _03975_ sky130_fd_sc_hd__o211ai_2
X_07498_ _02288_ _02303_ VGND VGND VPWR VPWR _02305_ sky130_fd_sc_hd__and2_2
XFILLER_0_61_90 VGND VGND VPWR VPWR sky130_fd_sc_hd__decap_4
X_06449_ _01351_ _01353_ _01363_ _01348_ VGND VGND VPWR VPWR _01374_ sky130_fd_sc_hd__o211a_2
XFILLER_0_106_526 VGND VGND VPWR VPWR sky130_fd_sc_hd__decap_6
XFILLER_0_16_351 VGND VGND VPWR VPWR sky130_fd_sc_hd__fill_1
X_09168_ _03905_ _03907_ VGND VGND VPWR VPWR _03908_ sky130_fd_sc_hd__xor2_2
X_09099_ tanh_inst.divider.y\[-19\] _03834_ VGND VGND VPWR VPWR _03840_ sky130_fd_sc_hd__nand2_2
X_08119_ _02820_ _02860_ VGND VGND VPWR VPWR _02913_ sky130_fd_sc_hd__nor2_2
XFILLER_0_31_321 VGND VGND VPWR VPWR sky130_fd_sc_hd__fill_1
XFILLER_0_31_332 VGND VGND VPWR VPWR sky130_fd_sc_hd__decap_4
XFILLER_0_43_181 VGND VGND VPWR VPWR sky130_fd_sc_hd__decap_8
XTAP_TAPCELL_ROW_112_1665 VGND VPWR sky130_fd_sc_hd__tapvpwrvgnd_1
X_10012_ _04725_ _04726_ _04727_ VGND VGND VPWR VPWR _04728_ sky130_fd_sc_hd__or3_2
XTAP_TAPCELL_ROW_67_1100 VGND VPWR sky130_fd_sc_hd__tapvpwrvgnd_1
XFILLER_0_25_39 VPWR VGND VPWR VGND sky130_ef_sc_hd__decap_12
XTAP_TAPCELL_ROW_27_596 VGND VPWR sky130_fd_sc_hd__tapvpwrvgnd_1
XFILLER_0_66_251 VGND VGND VPWR VPWR sky130_fd_sc_hd__fill_1
XFILLER_0_54_413 VGND VGND VPWR VPWR sky130_fd_sc_hd__decap_6
XPHY_EDGE_ROW_4_Left_126 VGND VGND VPWR VPWR sky130_fd_sc_hd__decap_3
XFILLER_0_81_221 VGND VGND VPWR VPWR sky130_fd_sc_hd__decap_3
XFILLER_0_109_397 VGND VGND VPWR VPWR sky130_fd_sc_hd__fill_1
XTAP_TAPCELL_ROW_78_1240 VGND VPWR sky130_fd_sc_hd__tapvpwrvgnd_1
XFILLER_0_22_321 VPWR VGND VPWR VGND sky130_ef_sc_hd__decap_12
XFILLER_0_50_641 VGND VGND VPWR VPWR sky130_fd_sc_hd__decap_3
XFILLER_0_1_237 VPWR VGND VPWR VGND sky130_ef_sc_hd__decap_12
XFILLER_0_5_27 VPWR VGND VPWR VGND sky130_ef_sc_hd__decap_12
XFILLER_0_66_68 VGND VGND VPWR VPWR sky130_fd_sc_hd__fill_1
X_05820_ mac_inst.z\[31\] _00771_ _00777_ _00783_ VGND VGND VPWR VPWR _00788_ sky130_fd_sc_hd__o211a_2
XTAP_TAPCELL_ROW_89_1380 VGND VPWR sky130_fd_sc_hd__tapvpwrvgnd_1
XFILLER_0_89_354 VGND VGND VPWR VPWR sky130_fd_sc_hd__decap_3
XFILLER_0_77_505 VPWR VGND VPWR VGND sky130_ef_sc_hd__decap_12
X_05751_ mac_inst.z\[5\] _00720_ VGND VGND VPWR VPWR _00725_ sky130_fd_sc_hd__nand2_2
XFILLER_0_106_41 VPWR VGND VPWR VGND sky130_ef_sc_hd__decap_12
XFILLER_0_77_538 VGND VGND VPWR VPWR sky130_fd_sc_hd__fill_1
X_05682_ _00658_ _00661_ VGND VGND VPWR VPWR _05682_/Y sky130_fd_sc_hd__xnor2_2
X_08470_ tanh_inst.divider.y\[0\] tanh_inst.divider.x\[0\] _03226_ _03227_ VGND VGND
+ VPWR VPWR _03255_ sky130_fd_sc_hd__a22o_2
XFILLER_0_106_85 VPWR VGND VPWR VGND sky130_ef_sc_hd__decap_12
XFILLER_0_92_508 VGND VGND VPWR VPWR sky130_fd_sc_hd__fill_2
X_07421_ _02227_ _02228_ VGND VGND VPWR VPWR _02229_ sky130_fd_sc_hd__xor2_2
X_07352_ _02158_ _02159_ _02101_ VGND VGND VPWR VPWR _02161_ sky130_fd_sc_hd__a21o_2
XFILLER_0_9_337 VPWR VGND VPWR VGND sky130_ef_sc_hd__decap_12
X_06303_ tanh_inst.divider.i\[4\] _01238_ _01127_ _01031_ VGND VGND VPWR VPWR _01239_
+ sky130_fd_sc_hd__o2bb2a_2
XFILLER_0_17_137 VPWR VGND VPWR VGND sky130_ef_sc_hd__decap_12
X_07283_ tanh_inst.divider.y\[-7\] _02028_ _02029_ VGND VGND VPWR VPWR _02093_ sky130_fd_sc_hd__o21ai_2
X_06234_ _01173_ _01174_ tanh_inst.divider.i\[3\] VGND VGND VPWR VPWR _01175_ sky130_fd_sc_hd__mux2_1
X_09022_ _02110_ _03638_ VGND VGND VPWR VPWR _03765_ sky130_fd_sc_hd__or2_2
X_06165_ tanh_inst.divider.y_\[-22\] _01109_ VGND VGND VPWR VPWR _01110_ sky130_fd_sc_hd__and2_2
XFILLER_0_103_518 VGND VGND VPWR VPWR sky130_fd_sc_hd__fill_1
XFILLER_0_79_3 VGND VGND VPWR VPWR sky130_fd_sc_hd__decap_8
X_05116_ mac_counter\[7\] _04826_ _04827_ VGND VGND VPWR VPWR _00125_ sky130_fd_sc_hd__o21a_2
X_06096_ _01038_ _01042_ VGND VGND VPWR VPWR _01043_ sky130_fd_sc_hd__nand2_2
XFILLER_0_111_540 VGND VGND VPWR VPWR sky130_fd_sc_hd__decap_6
XFILLER_0_40_184 VGND VGND VPWR VPWR sky130_fd_sc_hd__decap_6
X_05047_ tanh_inst.divider.x\[-8\] VGND VGND VPWR VPWR _04771_ sky130_fd_sc_hd__inv_2
XFILLER_0_0_281 VPWR VGND VPWR VGND sky130_ef_sc_hd__decap_12
X_09924_ tanh_inst.divider.y\[4\] _04641_ VGND VGND VPWR VPWR _04642_ sky130_fd_sc_hd__nand2_2
X_09855_ _04573_ _04574_ VGND VGND VPWR VPWR _04575_ sky130_fd_sc_hd__xnor2_2
X_08806_ tanh_inst.divider.x\[-3\] _02028_ _03508_ VGND VGND VPWR VPWR _03552_ sky130_fd_sc_hd__o21a_2
X_06998_ _01835_ _01836_ VGND VGND VPWR VPWR _01837_ sky130_fd_sc_hd__xnor2_2
X_09786_ _04791_ _04493_ _04494_ VGND VGND VPWR VPWR _04508_ sky130_fd_sc_hd__a21oi_2
X_05949_ _00886_ _00904_ _00906_ _00861_ _00907_ VGND VGND VPWR VPWR _00908_ sky130_fd_sc_hd__a221o_2
X_08737_ _03496_ _03497_ VGND VGND VPWR VPWR _00282_ sky130_fd_sc_hd__nor2_2
X_08668_ _03446_ _03447_ VGND VGND VPWR VPWR _03448_ sky130_fd_sc_hd__nand2_2
XTAP_TAPCELL_ROW_44_809 VGND VPWR sky130_fd_sc_hd__tapvpwrvgnd_1
XPHY_EDGE_ROW_77_Left_199 VGND VGND VPWR VPWR sky130_fd_sc_hd__decap_3
X_07619_ _02423_ VGND VGND VPWR VPWR _02424_ sky130_fd_sc_hd__inv_2
X_08599_ tanh_inst.divider.y\[4\] tanh_inst.divider.x\[4\] VGND VGND VPWR VPWR _03381_
+ sky130_fd_sc_hd__or2_2
XFILLER_0_119_673 VGND VGND VPWR VPWR sky130_fd_sc_hd__fill_1
XTAP_TAPCELL_ROW_62_1041 VGND VPWR sky130_fd_sc_hd__tapvpwrvgnd_1
XTAP_TAPCELL_ROW_24_566 VGND VPWR sky130_fd_sc_hd__tapvpwrvgnd_1
XFILLER_0_36_413 VGND VGND VPWR VPWR sky130_fd_sc_hd__fill_1
XFILLER_0_36_446 VGND VGND VPWR VPWR sky130_fd_sc_hd__decap_8
XFILLER_0_91_552 VGND VGND VPWR VPWR sky130_fd_sc_hd__fill_2
XFILLER_0_91_541 VGND VGND VPWR VPWR sky130_fd_sc_hd__decap_4
XFILLER_0_8_381 VGND VGND VPWR VPWR sky130_fd_sc_hd__decap_3
XFILLER_0_24_608 VGND VGND VPWR VPWR sky130_fd_sc_hd__decap_3
XFILLER_0_36_468 VGND VGND VPWR VPWR sky130_fd_sc_hd__decap_8
XFILLER_0_63_287 VGND VGND VPWR VPWR sky130_fd_sc_hd__fill_2
XFILLER_0_51_449 VPWR VGND VPWR VGND sky130_ef_sc_hd__decap_12
XFILLER_0_32_696 VGND VGND VPWR VPWR sky130_fd_sc_hd__decap_4
XFILLER_0_102_584 VGND VGND VPWR VPWR sky130_fd_sc_hd__decap_4
XTAP_TAPCELL_ROW_73_1170 VGND VPWR sky130_fd_sc_hd__tapvpwrvgnd_1
XFILLER_0_36_27 VGND VGND VPWR VPWR sky130_fd_sc_hd__fill_1
XPHY_EDGE_ROW_101_Right_101 VGND VGND VPWR VPWR sky130_fd_sc_hd__decap_3
XFILLER_0_98_195 VGND VGND VPWR VPWR sky130_fd_sc_hd__fill_1
XFILLER_0_52_48 VGND VGND VPWR VPWR sky130_fd_sc_hd__fill_1
XFILLER_0_67_571 VGND VGND VPWR VPWR sky130_fd_sc_hd__decap_4
XFILLER_0_52_59 VGND VGND VPWR VPWR sky130_fd_sc_hd__decap_3
XFILLER_0_116_109 VPWR VGND VPWR VGND sky130_ef_sc_hd__decap_12
XFILLER_0_6_307 VGND VGND VPWR VPWR sky130_fd_sc_hd__fill_1
XFILLER_0_15_608 VGND VGND VPWR VPWR sky130_fd_sc_hd__decap_8
XFILLER_0_42_438 VGND VGND VPWR VPWR sky130_fd_sc_hd__decap_3
XFILLER_0_2_502 VGND VGND VPWR VPWR sky130_fd_sc_hd__fill_1
XFILLER_0_23_685 VGND VGND VPWR VPWR sky130_fd_sc_hd__decap_3
XFILLER_0_50_460 VGND VGND VPWR VPWR sky130_fd_sc_hd__fill_1
XFILLER_0_77_23 VGND VGND VPWR VPWR sky130_fd_sc_hd__decap_6
XFILLER_0_65_9 VGND VGND VPWR VPWR sky130_fd_sc_hd__fill_1
XFILLER_0_2_568 VPWR VGND VPWR VGND sky130_ef_sc_hd__decap_12
XFILLER_0_22_195 VGND VGND VPWR VPWR sky130_fd_sc_hd__fill_1
X_07970_ _02752_ _02766_ VGND VGND VPWR VPWR _02767_ sky130_fd_sc_hd__and2_2
XFILLER_0_10_357 VGND VGND VPWR VPWR sky130_fd_sc_hd__decap_6
X_06921_ tanh_inst.div_en tanh_inst.divider.z_\[3\] VGND VGND VPWR VPWR _00192_ sky130_fd_sc_hd__and2b_2
XFILLER_0_93_55 VGND VGND VPWR VPWR sky130_fd_sc_hd__fill_1
X_06852_ tanh_inst.z_\[3\] _01667_ VGND VGND VPWR VPWR _01740_ sky130_fd_sc_hd__xnor2_2
X_09640_ _04363_ _04365_ VGND VGND VPWR VPWR _04366_ sky130_fd_sc_hd__xor2_2
XFILLER_0_117_51 VGND VGND VPWR VPWR sky130_fd_sc_hd__decap_4
X_05803_ _00680_ _00760_ VGND VGND VPWR VPWR _00772_ sky130_fd_sc_hd__nor2_2
X_09571_ _04163_ _04229_ _04298_ tanh_inst.z_\[7\] VGND VGND VPWR VPWR _04299_ sky130_fd_sc_hd__a31o_2
X_06783_ _01676_ _01679_ VGND VGND VPWR VPWR _01680_ sky130_fd_sc_hd__or2_2
XFILLER_0_77_324 VGND VGND VPWR VPWR sky130_fd_sc_hd__decap_4
XFILLER_0_77_313 VGND VGND VPWR VPWR sky130_fd_sc_hd__decap_4
X_05734_ _00693_ _00695_ VGND VGND VPWR VPWR _00709_ sky130_fd_sc_hd__nand2_2
XFILLER_0_26_93 VGND VGND VPWR VPWR sky130_fd_sc_hd__decap_3
X_08522_ _03229_ _03259_ VGND VGND VPWR VPWR _03306_ sky130_fd_sc_hd__or2_2
X_08453_ _03122_ _03193_ _03194_ VGND VGND VPWR VPWR _03239_ sky130_fd_sc_hd__o21a_2
XFILLER_0_92_316 VGND VGND VPWR VPWR sky130_fd_sc_hd__fill_2
X_07404_ _02023_ _02206_ _02208_ _02211_ _02052_ VGND VGND VPWR VPWR _02212_ sky130_fd_sc_hd__o221a_2
X_05665_ mac_inst.y\[29\] _00646_ VGND VGND VPWR VPWR _00647_ sky130_fd_sc_hd__nand2_2
XFILLER_0_85_390 VGND VGND VPWR VPWR sky130_fd_sc_hd__fill_2
XFILLER_0_9_167 VGND VGND VPWR VPWR sky130_fd_sc_hd__fill_1
X_08384_ _03163_ _03170_ VGND VGND VPWR VPWR _03171_ sky130_fd_sc_hd__nand2_2
X_05596_ _00568_ _00584_ _00582_ VGND VGND VPWR VPWR _00585_ sky130_fd_sc_hd__o21ai_2
X_07335_ tanh_inst.divider.y\[-17\] tanh_inst.divider.y\[-16\] tanh_inst.LOOKUP.index\[0\]
+ VGND VGND VPWR VPWR _02144_ sky130_fd_sc_hd__mux2_1
XTAP_TAPCELL_ROW_21_525 VGND VPWR sky130_fd_sc_hd__tapvpwrvgnd_1
XFILLER_0_116_643 VGND VGND VPWR VPWR sky130_fd_sc_hd__fill_1
X_07266_ tanh_inst.divider.y\[0\] _02028_ _02029_ VGND VGND VPWR VPWR _02076_ sky130_fd_sc_hd__o21ai_2
XFILLER_0_45_276 VGND VGND VPWR VPWR sky130_fd_sc_hd__decap_4
XFILLER_0_116_698 VGND VGND VPWR VPWR sky130_fd_sc_hd__fill_2
XFILLER_0_116_687 VGND VGND VPWR VPWR sky130_fd_sc_hd__decap_4
X_06217_ _01157_ _01158_ tanh_inst.divider.i\[3\] VGND VGND VPWR VPWR _01159_ sky130_fd_sc_hd__mux2_1
XFILLER_0_103_315 VGND VGND VPWR VPWR sky130_fd_sc_hd__decap_4
X_09005_ _03746_ _03747_ VGND VGND VPWR VPWR _03748_ sky130_fd_sc_hd__xnor2_2
XFILLER_0_5_373 VGND VGND VPWR VPWR sky130_fd_sc_hd__decap_6
XFILLER_0_14_641 VGND VGND VPWR VPWR sky130_fd_sc_hd__decap_3
XFILLER_0_33_449 VGND VGND VPWR VPWR sky130_fd_sc_hd__decap_4
X_07197_ _01088_ _00196_ _02010_ _02011_ VGND VGND VPWR VPWR _00228_ sky130_fd_sc_hd__o22a_2
XFILLER_0_103_337 VGND VGND VPWR VPWR sky130_fd_sc_hd__decap_8
X_06148_ tanh_inst.divider.x\[-6\] tanh_inst.divider.x\[-5\] tanh_inst.divider.x\[-4\]
+ tanh_inst.divider.x\[-3\] tanh_inst.divider.i\[0\] tanh_inst.divider.i\[1\] VGND
+ VGND VPWR VPWR _01093_ sky130_fd_sc_hd__mux4_2
X_06079_ _01019_ _01020_ _01022_ _01024_ tanh_inst.divider.i\[2\] tanh_inst.divider.i\[3\]
+ VGND VGND VPWR VPWR _01026_ sky130_fd_sc_hd__mux4_2
X_09907_ _04598_ _04606_ _04624_ tanh_inst.z_\[7\] VGND VGND VPWR VPWR _04626_ sky130_fd_sc_hd__o31a_2
X_09838_ _04517_ _04520_ _04557_ VGND VGND VPWR VPWR _04559_ sky130_fd_sc_hd__o21ai_2
XPHY_EDGE_ROW_85_Left_207 VGND VGND VPWR VPWR sky130_fd_sc_hd__decap_3
X_09769_ tanh_inst.z_\[7\] _04490_ _04491_ _04479_ VGND VGND VPWR VPWR _04492_ sky130_fd_sc_hd__a31o_2
XTAP_TAPCELL_ROW_29_625 VGND VPWR sky130_fd_sc_hd__tapvpwrvgnd_1
XTAP_TAPCELL_ROW_57_978 VGND VPWR sky130_fd_sc_hd__tapvpwrvgnd_1
Xclkbuf_leaf_38_clk clknet_2_0__leaf_clk VGND VGND VPWR VPWR clknet_leaf_38_clk sky130_fd_sc_hd__clkbuf_8
XFILLER_0_96_633 VGND VGND VPWR VPWR sky130_fd_sc_hd__decap_3
XFILLER_0_68_357 VGND VGND VPWR VPWR sky130_fd_sc_hd__decap_6
XTAP_TAPCELL_ROW_1_272 VGND VPWR sky130_fd_sc_hd__tapvpwrvgnd_1
XTAP_TAPCELL_ROW_107_1597 VGND VPWR sky130_fd_sc_hd__tapvpwrvgnd_1
XFILLER_0_83_305 VGND VGND VPWR VPWR sky130_fd_sc_hd__decap_8
XFILLER_0_22_29 VPWR VGND VPWR VGND sky130_ef_sc_hd__decap_12
XFILLER_0_49_593 VGND VGND VPWR VPWR sky130_fd_sc_hd__fill_1
XTAP_TAPCELL_ROW_120_1764 VGND VPWR sky130_fd_sc_hd__tapvpwrvgnd_1
XFILLER_0_107_610 VGND VGND VPWR VPWR sky130_fd_sc_hd__decap_6
XFILLER_0_36_232 VGND VGND VPWR VPWR sky130_fd_sc_hd__fill_2
XFILLER_0_24_416 VGND VGND VPWR VPWR sky130_fd_sc_hd__decap_4
XFILLER_0_24_427 VGND VGND VPWR VPWR sky130_fd_sc_hd__fill_2
XFILLER_0_36_287 VGND VGND VPWR VPWR sky130_fd_sc_hd__decap_8
XPHY_EDGE_ROW_94_Left_216 VGND VGND VPWR VPWR sky130_fd_sc_hd__decap_3
XFILLER_0_91_393 VPWR VGND VPWR VGND sky130_ef_sc_hd__decap_12
XFILLER_0_51_246 VGND VGND VPWR VPWR sky130_fd_sc_hd__fill_2
X_10475_ clknet_leaf_25_clk _00332_ VGND VGND VPWR VPWR tanh_inst.LOOKUP.index\[3\]
+ sky130_fd_sc_hd__dfxtp_2
XFILLER_0_20_611 VGND VGND VPWR VPWR sky130_fd_sc_hd__fill_1
XFILLER_0_102_392 VGND VGND VPWR VPWR sky130_fd_sc_hd__decap_3
XTAP_TAPCELL_ROW_9_372 VGND VPWR sky130_fd_sc_hd__tapvpwrvgnd_1
XFILLER_0_59_302 VPWR VGND VPWR VGND sky130_ef_sc_hd__decap_12
Xclkbuf_leaf_29_clk clknet_2_1__leaf_clk VGND VGND VPWR VPWR clknet_leaf_29_clk sky130_fd_sc_hd__clkbuf_8
XFILLER_0_74_305 VGND VGND VPWR VPWR sky130_fd_sc_hd__decap_3
X_05450_ mac_inst.i\[3\] _05015_ _00412_ VGND VGND VPWR VPWR _00451_ sky130_fd_sc_hd__o21ai_2
XFILLER_0_7_627 VGND VGND VPWR VPWR sky130_fd_sc_hd__fill_2
X_05381_ _04836_ _00386_ VGND VGND VPWR VPWR _00387_ sky130_fd_sc_hd__nor2_2
X_07120_ _01941_ _01942_ tanh_inst.divider.z_\[-3\] VGND VGND VPWR VPWR _01945_ sky130_fd_sc_hd__a21oi_2
XFILLER_0_82_360 VGND VGND VPWR VPWR sky130_fd_sc_hd__decap_4
XFILLER_0_15_449 VGND VGND VPWR VPWR sky130_fd_sc_hd__decap_8
X_07051_ _01882_ _01883_ VGND VGND VPWR VPWR _01884_ sky130_fd_sc_hd__xnor2_2
XFILLER_0_2_321 VPWR VGND VPWR VGND sky130_ef_sc_hd__decap_12
XFILLER_0_11_611 VGND VGND VPWR VPWR sky130_fd_sc_hd__fill_1
XFILLER_0_2_365 VPWR VGND VPWR VGND sky130_ef_sc_hd__decap_12
X_06002_ mac_inst.i\[4\] mac_inst.i\[3\] mac_inst.i\[5\] VGND VGND VPWR VPWR _00956_
+ sky130_fd_sc_hd__and3_2
XFILLER_0_10_121 VPWR VGND VPWR VGND sky130_ef_sc_hd__decap_12
XFILLER_0_10_165 VPWR VGND VPWR VGND sky130_ef_sc_hd__decap_12
X_07953_ tanh_inst.divider.x\[-12\] _02014_ _02750_ _01470_ VGND VGND VPWR VPWR _00245_
+ sky130_fd_sc_hd__o211a_2
X_06904_ tanh_inst.div_en tanh_inst.divider.z_\[-14\] VGND VGND VPWR VPWR _00175_
+ sky130_fd_sc_hd__and2b_2
X_07884_ tanh_inst.divider.x\[-13\] _02682_ VGND VGND VPWR VPWR _02683_ sky130_fd_sc_hd__nor2_2
X_06835_ _01724_ _01725_ _01720_ VGND VGND VPWR VPWR _01726_ sky130_fd_sc_hd__a21o_2
XFILLER_0_37_81 VPWR VGND VPWR VGND sky130_ef_sc_hd__decap_12
X_09623_ _04309_ _04314_ _04349_ VGND VGND VPWR VPWR _04350_ sky130_fd_sc_hd__a21oi_2
XFILLER_0_77_110 VGND VGND VPWR VPWR sky130_fd_sc_hd__fill_2
X_09554_ _04281_ _04282_ VGND VGND VPWR VPWR _04283_ sky130_fd_sc_hd__nor2_2
XTAP_TAPCELL_ROW_54_937 VGND VPWR sky130_fd_sc_hd__tapvpwrvgnd_1
X_06766_ _01502_ _01663_ _01664_ _01469_ mac_y_out[16] VGND VGND VPWR VPWR _00144_
+ sky130_fd_sc_hd__a32o_2
X_06697_ _01591_ _01597_ VGND VGND VPWR VPWR _01603_ sky130_fd_sc_hd__nor2_2
X_05717_ _04923_ _04944_ _04977_ _00690_ VGND VGND VPWR VPWR _00693_ sky130_fd_sc_hd__or4_2
X_08505_ _03286_ _03288_ VGND VGND VPWR VPWR _03289_ sky130_fd_sc_hd__or2_2
X_09485_ _04214_ _04215_ VGND VGND VPWR VPWR _04216_ sky130_fd_sc_hd__xnor2_2
XFILLER_0_77_176 VGND VGND VPWR VPWR sky130_fd_sc_hd__decap_4
X_08436_ _03163_ _03170_ _03139_ VGND VGND VPWR VPWR _03222_ sky130_fd_sc_hd__a21o_2
X_05648_ _00622_ _00625_ _00620_ VGND VGND VPWR VPWR _00632_ sky130_fd_sc_hd__a21o_2
XFILLER_0_108_418 VGND VGND VPWR VPWR sky130_fd_sc_hd__fill_2
XFILLER_0_65_349 VPWR VGND VPWR VGND sky130_ef_sc_hd__decap_12
XFILLER_0_18_221 VPWR VGND VPWR VGND sky130_ef_sc_hd__decap_12
XTAP_TAPCELL_ROW_34_683 VGND VPWR sky130_fd_sc_hd__tapvpwrvgnd_1
X_08367_ _03154_ VGND VGND VPWR VPWR _03155_ sky130_fd_sc_hd__inv_2
X_07318_ _04762_ _02027_ VGND VGND VPWR VPWR _02127_ sky130_fd_sc_hd__nand2_2
XFILLER_0_73_371 VPWR VGND VPWR VGND sky130_ef_sc_hd__decap_12
XFILLER_0_18_265 VPWR VGND VPWR VGND sky130_ef_sc_hd__decap_12
X_05579_ _04911_ _00386_ VGND VGND VPWR VPWR _00569_ sky130_fd_sc_hd__nand2_2
XFILLER_0_116_462 VGND VGND VPWR VPWR sky130_fd_sc_hd__fill_1
XFILLER_0_73_393 VPWR VGND VPWR VGND sky130_ef_sc_hd__decap_12
X_08298_ tanh_inst.divider.y\[-3\] _03086_ VGND VGND VPWR VPWR _03087_ sky130_fd_sc_hd__nor2_2
X_07249_ tanh_inst.divider.y\[-22\] tanh_inst.divider.y\[-21\] tanh_inst.LOOKUP.index\[0\]
+ VGND VGND VPWR VPWR _02059_ sky130_fd_sc_hd__mux2_1
XFILLER_0_5_181 VPWR VGND VPWR VGND sky130_ef_sc_hd__decap_12
XFILLER_0_33_279 VGND VGND VPWR VPWR sky130_fd_sc_hd__fill_1
X_10260_ clknet_leaf_32_clk mac_inst.x\[22\] _00000_ VGND VGND VPWR VPWR mac_x_out[22]
+ sky130_fd_sc_hd__dfrtp_2
XFILLER_0_103_167 VGND VGND VPWR VPWR sky130_fd_sc_hd__fill_1
XFILLER_0_112_690 VGND VGND VPWR VPWR sky130_fd_sc_hd__decap_8
X_10191_ x_in[17] _00000_ VGND VGND VPWR VPWR mac_inst.x\[17\] sky130_fd_sc_hd__dlxtn_1
XTAP_TAPCELL_ROW_70_1140 VGND VPWR sky130_fd_sc_hd__tapvpwrvgnd_1
XTAP_TAPCELL_ROW_6_342 VGND VPWR sky130_fd_sc_hd__tapvpwrvgnd_1
XTAP_TAPCELL_ROW_6_331 VGND VPWR sky130_fd_sc_hd__tapvpwrvgnd_1
XTAP_TAPCELL_ROW_109_1626 VGND VPWR sky130_fd_sc_hd__tapvpwrvgnd_1
XFILLER_0_96_474 VGND VGND VPWR VPWR sky130_fd_sc_hd__fill_2
XFILLER_0_96_452 VGND VGND VPWR VPWR sky130_fd_sc_hd__decap_4
XFILLER_0_68_132 VGND VGND VPWR VPWR sky130_fd_sc_hd__fill_1
XFILLER_0_83_113 VGND VGND VPWR VPWR sky130_fd_sc_hd__decap_8
XFILLER_0_56_338 VGND VGND VPWR VPWR sky130_fd_sc_hd__decap_6
XFILLER_0_83_179 VGND VGND VPWR VPWR sky130_fd_sc_hd__decap_4
XTAP_TAPCELL_ROW_81_1280 VGND VPWR sky130_fd_sc_hd__tapvpwrvgnd_1
XFILLER_0_24_202 VGND VGND VPWR VPWR sky130_fd_sc_hd__decap_3
XFILLER_0_12_419 VGND VGND VPWR VPWR sky130_fd_sc_hd__fill_1
XFILLER_0_24_246 VGND VGND VPWR VPWR sky130_fd_sc_hd__decap_6
X_10458_ clknet_leaf_0_clk _00315_ VGND VGND VPWR VPWR tanh_inst.divider.y\[-6\] sky130_fd_sc_hd__dfxtp_2
X_10389_ clknet_leaf_1_clk _00246_ VGND VGND VPWR VPWR tanh_inst.divider.x\[-11\]
+ sky130_fd_sc_hd__dfxtp_2
X_06620_ _04759_ _01523_ _01525_ _01482_ _01485_ VGND VGND VPWR VPWR _01533_ sky130_fd_sc_hd__o311a_2
XTAP_TAPCELL_ROW_84_1309 VGND VPWR sky130_fd_sc_hd__tapvpwrvgnd_1
X_06551_ _01088_ _01465_ _01466_ VGND VGND VPWR VPWR _00117_ sky130_fd_sc_hd__a21o_2
XFILLER_0_87_441 VGND VGND VPWR VPWR sky130_fd_sc_hd__decap_6
XFILLER_0_114_41 VPWR VGND VPWR VGND sky130_ef_sc_hd__decap_12
X_06482_ tanh_inst.divider.y_\[1\] _01403_ VGND VGND VPWR VPWR _01404_ sky130_fd_sc_hd__nor2_2
XFILLER_0_74_124 VGND VGND VPWR VPWR sky130_fd_sc_hd__decap_3
X_09270_ _01525_ _03632_ _03643_ _01477_ VGND VGND VPWR VPWR _04007_ sky130_fd_sc_hd__o22a_2
X_05502_ _00481_ _00482_ _00489_ mac_inst.z\[31\] VGND VGND VPWR VPWR _00499_ sky130_fd_sc_hd__a31o_2
XFILLER_0_117_215 VGND VGND VPWR VPWR sky130_fd_sc_hd__fill_1
XFILLER_0_114_85 VPWR VGND VPWR VGND sky130_ef_sc_hd__decap_12
X_05433_ _00434_ _00435_ VGND VGND VPWR VPWR _00436_ sky130_fd_sc_hd__nand2_2
X_08221_ _02955_ _02957_ _03011_ VGND VGND VPWR VPWR _03012_ sky130_fd_sc_hd__nor3_2
XFILLER_0_74_168 VGND VGND VPWR VPWR sky130_fd_sc_hd__fill_1
XFILLER_0_55_371 VGND VGND VPWR VPWR sky130_fd_sc_hd__decap_4
XTAP_TAPCELL_ROW_31_653 VGND VPWR sky130_fd_sc_hd__tapvpwrvgnd_1
XFILLER_0_55_393 VGND VGND VPWR VPWR sky130_fd_sc_hd__decap_6
X_05364_ _04867_ _04873_ mac_inst.i\[2\] VGND VGND VPWR VPWR _00371_ sky130_fd_sc_hd__mux2_1
X_08152_ _02822_ _02912_ _02913_ tanh_inst.z_\[7\] VGND VGND VPWR VPWR _02945_ sky130_fd_sc_hd__a31o_2
X_07103_ _01917_ _01921_ _01916_ VGND VGND VPWR VPWR _01930_ sky130_fd_sc_hd__o21ba_2
X_08083_ _02795_ _02845_ VGND VGND VPWR VPWR _02877_ sky130_fd_sc_hd__nand2_2
Xclkbuf_leaf_9_clk clknet_2_2__leaf_clk VGND VGND VPWR VPWR clknet_leaf_9_clk sky130_fd_sc_hd__clkbuf_8
X_05295_ _04884_ _04888_ _04890_ _04895_ mac_inst.i\[1\] mac_inst.i\[0\] VGND VGND
+ VPWR VPWR _04995_ sky130_fd_sc_hd__mux4_2
XTAP_TAPCELL_ROW_95_1449 VGND VPWR sky130_fd_sc_hd__tapvpwrvgnd_1
X_07034_ _01088_ _00176_ _01868_ _01059_ VGND VGND VPWR VPWR _00208_ sky130_fd_sc_hd__o22a_2
XFILLER_0_15_279 VGND VGND VPWR VPWR sky130_fd_sc_hd__fill_1
XFILLER_0_61_3 VGND VGND VPWR VPWR sky130_fd_sc_hd__decap_6
XFILLER_0_11_441 VGND VGND VPWR VPWR sky130_fd_sc_hd__fill_1
XFILLER_0_2_195 VGND VGND VPWR VPWR sky130_fd_sc_hd__fill_1
X_08985_ _02027_ _03594_ VGND VGND VPWR VPWR _03728_ sky130_fd_sc_hd__nor2_2
XTAP_TAPCELL_ROW_3_301 VGND VPWR sky130_fd_sc_hd__tapvpwrvgnd_1
X_07936_ _01525_ _02366_ _02372_ _01477_ VGND VGND VPWR VPWR _02734_ sky130_fd_sc_hd__o22a_2
X_07867_ _02664_ _02665_ VGND VGND VPWR VPWR _02666_ sky130_fd_sc_hd__xnor2_2
XTAP_TAPCELL_ROW_39_753 VGND VPWR sky130_fd_sc_hd__tapvpwrvgnd_1
X_07798_ _02588_ _02589_ _02598_ tanh_inst.z_\[7\] VGND VGND VPWR VPWR _02599_ sky130_fd_sc_hd__a22o_2
XFILLER_0_97_249 VGND VGND VPWR VPWR sky130_fd_sc_hd__fill_1
X_06818_ _01707_ _01709_ _01706_ VGND VGND VPWR VPWR _01711_ sky130_fd_sc_hd__o21ai_2
XFILLER_0_3_93 VPWR VGND VPWR VGND sky130_ef_sc_hd__decap_12
X_09606_ tanh_inst.divider.y\[-6\] _02014_ _04332_ _04333_ _01470_ VGND VGND VPWR
+ VPWR _00315_ sky130_fd_sc_hd__o221a_2
X_09537_ _02018_ _04266_ VGND VGND VPWR VPWR _04267_ sky130_fd_sc_hd__nor2_2
X_06749_ tanh_inst.z_\[-9\] _01647_ VGND VGND VPWR VPWR _01649_ sky130_fd_sc_hd__nand2_2
XTAP_TAPCELL_ROW_104_1567 VGND VPWR sky130_fd_sc_hd__tapvpwrvgnd_1
XTAP_TAPCELL_ROW_104_1556 VGND VPWR sky130_fd_sc_hd__tapvpwrvgnd_1
XFILLER_0_65_113 VGND VGND VPWR VPWR sky130_fd_sc_hd__decap_4
X_09468_ tanh_inst.divider.x\[-9\] _04198_ VGND VGND VPWR VPWR _04199_ sky130_fd_sc_hd__nor2_2
X_09399_ tanh_inst.divider.y\[-11\] _04131_ VGND VGND VPWR VPWR _04132_ sky130_fd_sc_hd__nand2_2
X_08419_ _03203_ _03204_ VGND VGND VPWR VPWR _03205_ sky130_fd_sc_hd__nor2_2
XFILLER_0_61_330 VGND VGND VPWR VPWR sky130_fd_sc_hd__decap_6
XFILLER_0_104_410 VGND VGND VPWR VPWR sky130_fd_sc_hd__decap_8
XTAP_TAPCELL_ROW_59_1002 VGND VPWR sky130_fd_sc_hd__tapvpwrvgnd_1
X_10312_ clknet_leaf_16_clk _00169_ VGND VGND VPWR VPWR tanh_out[4] sky130_fd_sc_hd__dfxtp_2
XFILLER_0_61_385 VGND VGND VPWR VPWR sky130_fd_sc_hd__decap_6
XFILLER_0_21_205 VPWR VGND VPWR VGND sky130_ef_sc_hd__decap_12
XFILLER_0_21_249 VPWR VGND VPWR VGND sky130_ef_sc_hd__decap_12
XTAP_TAPCELL_ROW_115_1696 VGND VPWR sky130_fd_sc_hd__tapvpwrvgnd_1
X_10243_ clknet_leaf_31_clk mac_inst.x\[5\] _00000_ VGND VGND VPWR VPWR mac_x_out[5]
+ sky130_fd_sc_hd__dfrtp_2
X_10174_ x_in[0] _00000_ VGND VGND VPWR VPWR mac_inst.x\[0\] sky130_fd_sc_hd__dlxtn_1
XFILLER_0_44_27 VGND VGND VPWR VPWR sky130_fd_sc_hd__fill_1
XFILLER_0_84_400 VGND VGND VPWR VPWR sky130_fd_sc_hd__decap_4
XTAP_TAPCELL_ROW_17_469 VGND VPWR sky130_fd_sc_hd__tapvpwrvgnd_1
XFILLER_0_60_37 VPWR VGND VPWR VGND sky130_ef_sc_hd__decap_12
XFILLER_0_60_15 VPWR VGND VPWR VGND sky130_ef_sc_hd__decap_12
XFILLER_0_8_27 VGND VGND VPWR VPWR sky130_fd_sc_hd__fill_1
XFILLER_0_52_363 VGND VGND VPWR VPWR sky130_fd_sc_hd__fill_1
XFILLER_0_69_57 VGND VGND VPWR VPWR sky130_fd_sc_hd__decap_4
XFILLER_0_52_396 VGND VGND VPWR VPWR sky130_fd_sc_hd__decap_8
XFILLER_0_100_65 VGND VGND VPWR VPWR sky130_fd_sc_hd__fill_1
X_05080_ rst VGND VGND VPWR VPWR _00066_ sky130_fd_sc_hd__inv_2
XFILLER_0_0_699 VGND VGND VPWR VPWR sky130_fd_sc_hd__fill_1
X_08770_ tanh_inst.divider.x\[-16\] _02028_ _03508_ VGND VGND VPWR VPWR _03516_ sky130_fd_sc_hd__o21ai_2
X_05982_ _00930_ _00932_ mac_inst.z\[31\] VGND VGND VPWR VPWR _00937_ sky130_fd_sc_hd__a21oi_2
X_07721_ _02507_ _02508_ VGND VGND VPWR VPWR _02524_ sky130_fd_sc_hd__and2_2
XFILLER_0_18_83 VGND VGND VPWR VPWR sky130_fd_sc_hd__fill_1
X_07652_ _02454_ _02455_ VGND VGND VPWR VPWR _02456_ sky130_fd_sc_hd__and2b_2
XTAP_TAPCELL_ROW_36_712 VGND VPWR sky130_fd_sc_hd__tapvpwrvgnd_1
X_07583_ _02022_ _02385_ _02387_ _02053_ VGND VGND VPWR VPWR _02388_ sky130_fd_sc_hd__a211o_2
X_06603_ _01482_ _01515_ VGND VGND VPWR VPWR _01516_ sky130_fd_sc_hd__nand2_2
X_06534_ tanh_inst.divider.y\[5\] tanh_inst.div_en tanh_inst.divider.y_\[5\] _01092_
+ _01451_ VGND VGND VPWR VPWR _00115_ sky130_fd_sc_hd__a221o_2
XFILLER_0_87_260 VGND VGND VPWR VPWR sky130_fd_sc_hd__decap_8
X_09322_ tanh_inst.divider.y\[-14\] _02014_ _04057_ _01470_ VGND VGND VPWR VPWR _00307_
+ sky130_fd_sc_hd__o211a_2
XFILLER_0_87_293 VGND VGND VPWR VPWR sky130_fd_sc_hd__decap_4
XFILLER_0_75_455 VGND VGND VPWR VPWR sky130_fd_sc_hd__fill_1
X_06465_ _04793_ _01385_ _01386_ VGND VGND VPWR VPWR _01388_ sky130_fd_sc_hd__and3_2
X_09253_ tanh_inst.divider.x\[7\] _03606_ _03609_ _03588_ _02023_ _02052_ VGND VGND
+ VPWR VPWR _03990_ sky130_fd_sc_hd__mux4_2
XFILLER_0_63_617 VGND VGND VPWR VPWR sky130_fd_sc_hd__decap_3
X_06396_ _01324_ VGND VGND VPWR VPWR _01325_ sky130_fd_sc_hd__inv_2
X_09184_ _03921_ tanh_inst.divider.x\[-17\] VGND VGND VPWR VPWR _03923_ sky130_fd_sc_hd__and2b_2
XFILLER_0_62_138 VGND VGND VPWR VPWR sky130_fd_sc_hd__fill_2
X_05416_ _00376_ _00377_ _00392_ _00403_ VGND VGND VPWR VPWR _00420_ sky130_fd_sc_hd__and4_2
X_08204_ _02992_ _02994_ VGND VGND VPWR VPWR _02996_ sky130_fd_sc_hd__or2_2
XFILLER_0_71_661 VGND VGND VPWR VPWR sky130_fd_sc_hd__fill_2
X_08135_ _02888_ _02890_ VGND VGND VPWR VPWR _02928_ sky130_fd_sc_hd__nand2_2
X_05347_ _04888_ _04893_ _04895_ _04899_ mac_inst.i\[1\] mac_inst.i\[0\] VGND VGND
+ VPWR VPWR _00355_ sky130_fd_sc_hd__mux4_2
XFILLER_0_16_544 VGND VGND VPWR VPWR sky130_fd_sc_hd__fill_1
XFILLER_0_31_503 VGND VGND VPWR VPWR sky130_fd_sc_hd__fill_1
XFILLER_0_43_385 VGND VGND VPWR VPWR sky130_fd_sc_hd__decap_6
X_08066_ _02821_ _02822_ tanh_inst.z_\[7\] VGND VGND VPWR VPWR _02861_ sky130_fd_sc_hd__a21oi_2
X_05278_ _04955_ _04975_ _04978_ VGND VGND VPWR VPWR _04979_ sky130_fd_sc_hd__or3_2
X_07017_ _01039_ _01784_ _01847_ tanh_inst.divider.y_\[7\] VGND VGND VPWR VPWR _01853_
+ sky130_fd_sc_hd__o22a_2
XFILLER_0_101_479 VPWR VGND VPWR VGND sky130_ef_sc_hd__decap_12
XFILLER_0_11_293 VPWR VGND VPWR VGND sky130_ef_sc_hd__decap_12
X_08968_ _03707_ _03708_ _03711_ _01524_ VGND VGND VPWR VPWR _03712_ sky130_fd_sc_hd__a22o_2
X_07919_ _02716_ VGND VGND VPWR VPWR _02717_ sky130_fd_sc_hd__inv_2
X_08899_ _02110_ _03593_ _03639_ _01486_ VGND VGND VPWR VPWR _03644_ sky130_fd_sc_hd__o22a_2
XFILLER_0_93_230 VGND VGND VPWR VPWR sky130_fd_sc_hd__fill_2
XFILLER_0_78_282 VPWR VGND VPWR VGND sky130_ef_sc_hd__decap_12
XTAP_TAPCELL_ROW_65_1072 VGND VPWR sky130_fd_sc_hd__tapvpwrvgnd_1
XFILLER_0_66_477 VPWR VGND VPWR VGND sky130_ef_sc_hd__decap_12
XTAP_TAPCELL_ROW_14_439 VGND VPWR sky130_fd_sc_hd__tapvpwrvgnd_1
XFILLER_0_19_393 VGND VGND VPWR VPWR sky130_fd_sc_hd__fill_2
XFILLER_0_30_29 VPWR VGND VPWR VGND sky130_ef_sc_hd__decap_12
XFILLER_0_47_680 VGND VGND VPWR VPWR sky130_fd_sc_hd__decap_8
XFILLER_0_46_190 VGND VGND VPWR VPWR sky130_fd_sc_hd__fill_1
XFILLER_0_53_149 VGND VGND VPWR VPWR sky130_fd_sc_hd__decap_3
XFILLER_0_117_590 VGND VGND VPWR VPWR sky130_fd_sc_hd__decap_3
XTAP_TAPCELL_ROW_117_1725 VGND VPWR sky130_fd_sc_hd__tapvpwrvgnd_1
XFILLER_0_34_363 VGND VGND VPWR VPWR sky130_fd_sc_hd__fill_1
X_10226_ clknet_leaf_28_clk mac_inst.y\[20\] _00000_ VGND VGND VPWR VPWR mac_y_out[20]
+ sky130_fd_sc_hd__dfrtp_2
X_10088_ clknet_leaf_4_clk _00105_ VGND VGND VPWR VPWR tanh_inst.divider.y_\[-5\]
+ sky130_fd_sc_hd__dfxtp_2
XFILLER_0_69_260 VPWR VGND VPWR VGND sky130_ef_sc_hd__decap_12
XFILLER_0_97_591 VGND VGND VPWR VPWR sky130_fd_sc_hd__decap_8
XFILLER_0_29_113 VPWR VGND VPWR VGND sky130_ef_sc_hd__decap_12
XFILLER_0_29_179 VPWR VGND VPWR VGND sky130_ef_sc_hd__decap_12
XFILLER_0_45_617 VGND VGND VPWR VPWR sky130_fd_sc_hd__decap_4
X_06250_ _04776_ _01189_ VGND VGND VPWR VPWR _01190_ sky130_fd_sc_hd__or2_2
XFILLER_0_72_447 VGND VGND VPWR VPWR sky130_fd_sc_hd__fill_1
XFILLER_0_5_714 VGND VGND VPWR VPWR sky130_fd_sc_hd__decap_8
XFILLER_0_44_116 VPWR VGND VPWR VGND sky130_ef_sc_hd__decap_12
X_05201_ _04789_ _04853_ _04903_ _04904_ VGND VGND VPWR VPWR _04905_ sky130_fd_sc_hd__or4_2
XTAP_TAPCELL_ROW_41_770 VGND VPWR sky130_fd_sc_hd__tapvpwrvgnd_1
X_06181_ tanh_inst.divider.x\[-13\] tanh_inst.divider.x\[-12\] tanh_inst.divider.x\[-11\]
+ tanh_inst.divider.x\[-10\] tanh_inst.divider.i\[0\] tanh_inst.divider.i\[1\] VGND
+ VGND VPWR VPWR _01125_ sky130_fd_sc_hd__mux4_2
XFILLER_0_53_694 VGND VGND VPWR VPWR sky130_fd_sc_hd__fill_1
XFILLER_0_13_503 VGND VGND VPWR VPWR sky130_fd_sc_hd__fill_1
XFILLER_0_13_525 VGND VGND VPWR VPWR sky130_fd_sc_hd__decap_3
XFILLER_0_111_722 VGND VGND VPWR VPWR sky130_fd_sc_hd__fill_2
XTAP_TAPCELL_ROW_92_1408 VGND VPWR sky130_fd_sc_hd__tapvpwrvgnd_1
XFILLER_0_13_547 VGND VGND VPWR VPWR sky130_fd_sc_hd__fill_1
X_05132_ mac_inst.i\[5\] mac_inst.i\[4\] VGND VGND VPWR VPWR _04836_ sky130_fd_sc_hd__nand2b_2
XFILLER_0_40_333 VGND VGND VPWR VPWR sky130_fd_sc_hd__fill_1
X_09940_ _04656_ _04657_ VGND VGND VPWR VPWR _04658_ sky130_fd_sc_hd__nand2_2
X_05063_ mac_inst.i\[29\] VGND VGND VPWR VPWR _04787_ sky130_fd_sc_hd__inv_2
XPHY_EDGE_ROW_115_Right_115 VGND VGND VPWR VPWR sky130_fd_sc_hd__decap_3
XFILLER_0_110_243 VGND VGND VPWR VPWR sky130_fd_sc_hd__fill_1
XFILLER_0_0_441 VGND VGND VPWR VPWR sky130_fd_sc_hd__decap_6
XFILLER_0_21_580 VGND VGND VPWR VPWR sky130_fd_sc_hd__decap_6
X_09871_ _04587_ _04590_ VGND VGND VPWR VPWR _04591_ sky130_fd_sc_hd__xnor2_2
X_08822_ _03549_ _03567_ _02023_ VGND VGND VPWR VPWR _03568_ sky130_fd_sc_hd__mux2_1
X_05965_ _00913_ _00921_ VGND VGND VPWR VPWR _00922_ sky130_fd_sc_hd__and2_2
X_08753_ mac_inst.i\[26\] _00968_ VGND VGND VPWR VPWR _00291_ sky130_fd_sc_hd__xor2_2
X_07704_ _02505_ _02506_ VGND VGND VPWR VPWR _02507_ sky130_fd_sc_hd__nand2_2
XFILLER_0_24_3 VPWR VGND VPWR VGND sky130_ef_sc_hd__decap_12
XTAP_TAPCELL_ROW_49_870 VGND VPWR sky130_fd_sc_hd__tapvpwrvgnd_1
X_08684_ _03364_ _03371_ _03421_ _03422_ _03462_ VGND VGND VPWR VPWR _03464_ sky130_fd_sc_hd__o311a_2
X_05896_ mac_inst.z\[15\] _00839_ _00826_ mac_inst.z\[14\] VGND VGND VPWR VPWR _00859_
+ sky130_fd_sc_hd__o211a_2
XFILLER_0_95_517 VPWR VGND VPWR VGND sky130_ef_sc_hd__decap_12
X_07635_ _02214_ _02219_ _02025_ VGND VGND VPWR VPWR _02439_ sky130_fd_sc_hd__mux2_1
X_07566_ _02105_ _02119_ tanh_inst.LOOKUP.index\[2\] VGND VGND VPWR VPWR _02372_ sky130_fd_sc_hd__mux2_1
XFILLER_0_48_433 VGND VGND VPWR VPWR sky130_fd_sc_hd__decap_8
XFILLER_0_118_332 VGND VGND VPWR VPWR sky130_fd_sc_hd__fill_2
X_09305_ _04037_ _04039_ VGND VGND VPWR VPWR _04041_ sky130_fd_sc_hd__nand2b_2
X_06517_ _01392_ _01406_ _01435_ VGND VGND VPWR VPWR _01436_ sky130_fd_sc_hd__and3_2
XTAP_TAPCELL_ROW_101_1526 VGND VPWR sky130_fd_sc_hd__tapvpwrvgnd_1
XFILLER_0_91_712 VPWR VGND VPWR VGND sky130_ef_sc_hd__decap_12
XFILLER_0_75_252 VGND VGND VPWR VPWR sky130_fd_sc_hd__fill_1
XFILLER_0_48_477 VPWR VGND VPWR VGND sky130_ef_sc_hd__decap_12
XFILLER_0_106_505 VGND VGND VPWR VPWR sky130_fd_sc_hd__fill_2
X_09236_ _03971_ _03972_ tanh_inst.z_\[7\] VGND VGND VPWR VPWR _03974_ sky130_fd_sc_hd__a21o_2
XFILLER_0_90_211 VGND VGND VPWR VPWR sky130_fd_sc_hd__decap_4
X_07497_ _02288_ _02303_ VGND VGND VPWR VPWR _02304_ sky130_fd_sc_hd__nor2_2
XFILLER_0_8_563 VGND VGND VPWR VPWR sky130_fd_sc_hd__decap_3
XFILLER_0_35_127 VPWR VGND VPWR VGND sky130_ef_sc_hd__decap_12
X_06448_ _01346_ _01361_ _01362_ VGND VGND VPWR VPWR _01373_ sky130_fd_sc_hd__o21ai_2
XPHY_EDGE_ROW_17_Right_17 VGND VGND VPWR VPWR sky130_fd_sc_hd__decap_3
X_06379_ _01088_ _01307_ _01308_ _01309_ VGND VGND VPWR VPWR _00102_ sky130_fd_sc_hd__a31o_2
X_09167_ _03863_ _03906_ VGND VGND VPWR VPWR _03907_ sky130_fd_sc_hd__nor2_2
XFILLER_0_44_683 VPWR VGND VPWR VGND sky130_ef_sc_hd__decap_12
X_09098_ _03837_ _03838_ VGND VGND VPWR VPWR _03839_ sky130_fd_sc_hd__xnor2_2
XFILLER_0_71_491 VPWR VGND VPWR VGND sky130_ef_sc_hd__decap_12
XFILLER_0_9_81 VPWR VGND VPWR VGND sky130_ef_sc_hd__decap_12
X_08118_ _02911_ VGND VGND VPWR VPWR _02912_ sky130_fd_sc_hd__inv_2
XFILLER_0_101_221 VGND VGND VPWR VPWR sky130_fd_sc_hd__decap_3
X_08049_ _02787_ _02790_ _02842_ VGND VGND VPWR VPWR _02844_ sky130_fd_sc_hd__o21ai_2
XFILLER_0_31_388 VGND VGND VPWR VPWR sky130_fd_sc_hd__decap_4
XTAP_TAPCELL_ROW_112_1666 VGND VPWR sky130_fd_sc_hd__tapvpwrvgnd_1
X_10011_ _04656_ _04691_ _04690_ VGND VGND VPWR VPWR _04727_ sky130_fd_sc_hd__o21bai_2
XPHY_EDGE_ROW_26_Right_26 VGND VGND VPWR VPWR sky130_fd_sc_hd__decap_3
XFILLER_0_98_355 VGND VGND VPWR VPWR sky130_fd_sc_hd__fill_1
XTAP_TAPCELL_ROW_67_1101 VGND VPWR sky130_fd_sc_hd__tapvpwrvgnd_1
XFILLER_0_39_400 VPWR VGND VPWR VGND sky130_ef_sc_hd__decap_12
XFILLER_0_109_332 VGND VGND VPWR VPWR sky130_fd_sc_hd__decap_4
XFILLER_0_82_701 VGND VGND VPWR VPWR sky130_fd_sc_hd__decap_6
XTAP_TAPCELL_ROW_27_597 VGND VPWR sky130_fd_sc_hd__tapvpwrvgnd_1
XFILLER_0_27_617 VGND VGND VPWR VPWR sky130_fd_sc_hd__decap_3
XFILLER_0_27_628 VGND VGND VPWR VPWR sky130_fd_sc_hd__decap_6
XFILLER_0_66_274 VGND VGND VPWR VPWR sky130_fd_sc_hd__fill_2
XFILLER_0_54_447 VGND VGND VPWR VPWR sky130_fd_sc_hd__decap_3
XPHY_EDGE_ROW_35_Right_35 VGND VGND VPWR VPWR sky130_fd_sc_hd__decap_3
XTAP_TAPCELL_ROW_78_1241 VGND VPWR sky130_fd_sc_hd__tapvpwrvgnd_1
XFILLER_0_1_205 VPWR VGND VPWR VGND sky130_ef_sc_hd__decap_12
XFILLER_0_22_333 VPWR VGND VPWR VGND sky130_ef_sc_hd__decap_12
XFILLER_0_1_249 VPWR VGND VPWR VGND sky130_ef_sc_hd__decap_12
XFILLER_0_50_664 VGND VGND VPWR VPWR sky130_fd_sc_hd__decap_4
XFILLER_0_5_39 VPWR VGND VPWR VGND sky130_ef_sc_hd__decap_12
XPHY_EDGE_ROW_44_Right_44 VGND VGND VPWR VPWR sky130_fd_sc_hd__decap_3
XPHY_EDGE_ROW_105_Left_227 VGND VGND VPWR VPWR sky130_fd_sc_hd__decap_3
X_10209_ clknet_leaf_24_clk mac_inst.y\[3\] _00000_ VGND VGND VPWR VPWR mac_y_out[3]
+ sky130_fd_sc_hd__dfrtp_2
X_05750_ _00723_ VGND VGND VPWR VPWR _00724_ sky130_fd_sc_hd__inv_2
XFILLER_0_89_344 VGND VGND VPWR VPWR sky130_fd_sc_hd__decap_4
XTAP_TAPCELL_ROW_89_1370 VGND VPWR sky130_fd_sc_hd__tapvpwrvgnd_1
XFILLER_0_106_53 VPWR VGND VPWR VGND sky130_ef_sc_hd__decap_12
XFILLER_0_77_517 VGND VGND VPWR VPWR sky130_fd_sc_hd__fill_2
X_05681_ _00659_ _00660_ VGND VGND VPWR VPWR _00661_ sky130_fd_sc_hd__xnor2_2
XTAP_TAPCELL_ROW_46_840 VGND VPWR sky130_fd_sc_hd__tapvpwrvgnd_1
XFILLER_0_106_97 VPWR VGND VPWR VGND sky130_ef_sc_hd__decap_12
X_07420_ _02156_ _02158_ VGND VGND VPWR VPWR _02228_ sky130_fd_sc_hd__nand2b_2
XFILLER_0_57_230 VPWR VGND VPWR VGND sky130_ef_sc_hd__decap_12
XFILLER_0_9_305 VPWR VGND VPWR VGND sky130_ef_sc_hd__decap_12
XFILLER_0_15_51 VGND VGND VPWR VPWR sky130_fd_sc_hd__decap_4
XPHY_EDGE_ROW_114_Left_236 VGND VGND VPWR VPWR sky130_fd_sc_hd__decap_3
XFILLER_0_85_561 VGND VGND VPWR VPWR sky130_fd_sc_hd__fill_2
X_07351_ _02101_ _02158_ _02159_ VGND VGND VPWR VPWR _02160_ sky130_fd_sc_hd__and3_2
XPHY_EDGE_ROW_53_Right_53 VGND VGND VPWR VPWR sky130_fd_sc_hd__decap_3
XFILLER_0_9_349 VGND VGND VPWR VPWR sky130_fd_sc_hd__decap_6
X_06302_ tanh_inst.divider.i\[3\] _01120_ _01187_ VGND VGND VPWR VPWR _01238_ sky130_fd_sc_hd__o21ai_2
XFILLER_0_85_594 VGND VGND VPWR VPWR sky130_fd_sc_hd__fill_1
XFILLER_0_17_105 VGND VGND VPWR VPWR sky130_fd_sc_hd__decap_6
X_07282_ tanh_inst.divider.y\[-7\] _02028_ _02029_ VGND VGND VPWR VPWR _02092_ sky130_fd_sc_hd__o21a_2
XFILLER_0_17_149 VPWR VGND VPWR VGND sky130_ef_sc_hd__decap_12
XFILLER_0_45_447 VGND VGND VPWR VPWR sky130_fd_sc_hd__fill_1
XFILLER_0_115_335 VGND VGND VPWR VPWR sky130_fd_sc_hd__fill_1
X_06233_ tanh_inst.divider.i\[2\] _01097_ _01118_ VGND VGND VPWR VPWR _01174_ sky130_fd_sc_hd__o21a_2
X_09021_ tanh_inst.divider.x\[-17\] tanh_inst.divider.x\[-16\] tanh_inst.divider.x\[-15\]
+ tanh_inst.divider.x\[-14\] tanh_inst.LOOKUP.index\[0\] tanh_inst.LOOKUP.index\[1\]
+ VGND VGND VPWR VPWR _03764_ sky130_fd_sc_hd__mux4_2
XFILLER_0_60_406 VPWR VGND VPWR VGND sky130_ef_sc_hd__decap_12
XFILLER_0_31_72 VGND VGND VPWR VPWR sky130_fd_sc_hd__fill_1
XFILLER_0_31_94 VPWR VGND VPWR VGND sky130_ef_sc_hd__decap_12
X_06164_ _01107_ _01108_ VGND VGND VPWR VPWR _01109_ sky130_fd_sc_hd__xnor2_2
XFILLER_0_13_377 VGND VGND VPWR VPWR sky130_fd_sc_hd__fill_1
X_05115_ mac_counter\[7\] _04826_ _04809_ VGND VGND VPWR VPWR _04827_ sky130_fd_sc_hd__a21oi_2
XFILLER_0_40_130 VGND VGND VPWR VPWR sky130_fd_sc_hd__decap_8
XFILLER_0_40_141 VGND VGND VPWR VPWR sky130_fd_sc_hd__decap_8
X_06095_ _01040_ _01041_ tanh_inst.divider.i\[2\] VGND VGND VPWR VPWR _01042_ sky130_fd_sc_hd__mux2_1
XPHY_EDGE_ROW_62_Right_62 VGND VGND VPWR VPWR sky130_fd_sc_hd__decap_3
X_09923_ _04639_ _04640_ VGND VGND VPWR VPWR _04641_ sky130_fd_sc_hd__xnor2_2
X_05046_ tanh_inst.divider.x\[-6\] VGND VGND VPWR VPWR _04770_ sky130_fd_sc_hd__inv_2
XFILLER_0_0_293 VPWR VGND VPWR VGND sky130_ef_sc_hd__decap_12
X_09854_ tanh_inst.z_\[7\] _04565_ _04566_ _04508_ VGND VGND VPWR VPWR _04574_ sky130_fd_sc_hd__o211a_2
X_08805_ tanh_inst.divider.x\[-4\] _02028_ _03508_ VGND VGND VPWR VPWR _03551_ sky130_fd_sc_hd__o21ai_2
X_06997_ _01814_ _01823_ _01825_ _01822_ VGND VGND VPWR VPWR _01836_ sky130_fd_sc_hd__a31o_2
X_09785_ _04757_ _03977_ _04212_ VGND VGND VPWR VPWR _04507_ sky130_fd_sc_hd__a21oi_2
X_05948_ _00883_ _00894_ _00893_ VGND VGND VPWR VPWR _00907_ sky130_fd_sc_hd__a21oi_2
X_08736_ mac_inst.i\[17\] mac_inst.i\[16\] _03495_ VGND VGND VPWR VPWR _03497_ sky130_fd_sc_hd__and3_2
X_08667_ tanh_inst.divider.y\[6\] tanh_inst.divider.x\[6\] VGND VGND VPWR VPWR _03447_
+ sky130_fd_sc_hd__or2_2
X_05879_ _00838_ _00841_ mac_inst.z\[15\] VGND VGND VPWR VPWR _00843_ sky130_fd_sc_hd__a21bo_2
XPHY_EDGE_ROW_71_Right_71 VGND VGND VPWR VPWR sky130_fd_sc_hd__decap_3
X_07618_ _04757_ _02419_ _02420_ _02422_ VGND VGND VPWR VPWR _02423_ sky130_fd_sc_hd__o211a_2
XFILLER_0_95_369 VPWR VGND VPWR VGND sky130_ef_sc_hd__decap_12
XFILLER_0_76_572 VGND VGND VPWR VPWR sky130_fd_sc_hd__decap_4
X_08598_ tanh_inst.divider.y\[4\] tanh_inst.divider.x\[4\] VGND VGND VPWR VPWR _03380_
+ sky130_fd_sc_hd__nand2_2
XFILLER_0_64_701 VPWR VGND VPWR VGND sky130_ef_sc_hd__decap_12
X_07549_ tanh_inst.divider.y\[-20\] tanh_inst.divider.x\[-20\] VGND VGND VPWR VPWR
+ _02355_ sky130_fd_sc_hd__nand2_2
XTAP_TAPCELL_ROW_62_1042 VGND VPWR sky130_fd_sc_hd__tapvpwrvgnd_1
XTAP_TAPCELL_ROW_62_1031 VGND VPWR sky130_fd_sc_hd__tapvpwrvgnd_1
XTAP_TAPCELL_ROW_24_556 VGND VPWR sky130_fd_sc_hd__tapvpwrvgnd_1
XTAP_TAPCELL_ROW_24_567 VGND VPWR sky130_fd_sc_hd__tapvpwrvgnd_1
XFILLER_0_48_274 VGND VGND VPWR VPWR sky130_fd_sc_hd__fill_2
XFILLER_0_118_173 VGND VGND VPWR VPWR sky130_fd_sc_hd__fill_1
X_09219_ tanh_inst.divider.y\[-16\] _03955_ VGND VGND VPWR VPWR _03957_ sky130_fd_sc_hd__nor2_2
XFILLER_0_121_305 VGND VGND VPWR VPWR sky130_fd_sc_hd__decap_3
XPHY_EDGE_ROW_80_Right_80 VGND VGND VPWR VPWR sky130_fd_sc_hd__decap_3
XFILLER_0_32_653 VGND VGND VPWR VPWR sky130_fd_sc_hd__decap_4
XFILLER_0_102_552 VPWR VGND VPWR VGND sky130_ef_sc_hd__decap_12
XTAP_TAPCELL_ROW_73_1171 VGND VPWR sky130_fd_sc_hd__tapvpwrvgnd_1
XFILLER_0_99_653 VGND VGND VPWR VPWR sky130_fd_sc_hd__decap_4
XFILLER_0_67_561 VGND VGND VPWR VPWR sky130_fd_sc_hd__decap_4
XFILLER_0_27_414 VGND VGND VPWR VPWR sky130_fd_sc_hd__fill_2
XFILLER_0_82_564 VGND VGND VPWR VPWR sky130_fd_sc_hd__fill_1
XFILLER_0_112_305 VGND VGND VPWR VPWR sky130_fd_sc_hd__decap_3
XFILLER_0_23_642 VGND VGND VPWR VPWR sky130_fd_sc_hd__decap_6
XFILLER_0_35_491 VPWR VGND VPWR VGND sky130_ef_sc_hd__decap_12
XFILLER_0_22_141 VPWR VGND VPWR VGND sky130_ef_sc_hd__decap_12
XFILLER_0_105_390 VGND VGND VPWR VPWR sky130_fd_sc_hd__fill_2
XFILLER_0_120_382 VGND VGND VPWR VPWR sky130_fd_sc_hd__fill_2
X_06920_ tanh_inst.div_en tanh_inst.divider.z_\[2\] VGND VGND VPWR VPWR _00191_ sky130_fd_sc_hd__and2b_2
X_06851_ _01738_ _01739_ mac_y_out[26] _01469_ VGND VGND VPWR VPWR _00154_ sky130_fd_sc_hd__a2bb2o_2
XFILLER_0_89_141 VGND VGND VPWR VPWR sky130_fd_sc_hd__fill_1
X_06782_ _01660_ _01662_ _01669_ _01678_ VGND VGND VPWR VPWR _01679_ sky130_fd_sc_hd__a31oi_2
X_05802_ _04944_ _00676_ _00760_ VGND VGND VPWR VPWR _00771_ sky130_fd_sc_hd__or3_2
X_09570_ _04228_ _04288_ VGND VGND VPWR VPWR _04298_ sky130_fd_sc_hd__and2_2
X_05733_ _04943_ _00706_ _00692_ _00681_ _00669_ VGND VGND VPWR VPWR _00708_ sky130_fd_sc_hd__a2111oi_2
XFILLER_0_26_72 VPWR VGND VPWR VGND sky130_ef_sc_hd__decap_12
X_08521_ _03303_ _03304_ VGND VGND VPWR VPWR _03305_ sky130_fd_sc_hd__nor2_2
X_08452_ _03236_ _03125_ _03112_ VGND VGND VPWR VPWR _03238_ sky130_fd_sc_hd__nand3b_2
X_07403_ _02024_ _02209_ _02210_ _02023_ VGND VGND VPWR VPWR _02211_ sky130_fd_sc_hd__o31ai_2
XFILLER_0_9_113 VPWR VGND VPWR VGND sky130_ef_sc_hd__decap_12
X_05664_ _00644_ _00645_ VGND VGND VPWR VPWR _00646_ sky130_fd_sc_hd__xnor2_2
XFILLER_0_46_701 VGND VGND VPWR VPWR sky130_fd_sc_hd__decap_4
X_08383_ _03168_ _03169_ VGND VGND VPWR VPWR _03170_ sky130_fd_sc_hd__nand2_2
X_05595_ _00564_ _00573_ VGND VGND VPWR VPWR _00584_ sky130_fd_sc_hd__or2_2
XFILLER_0_42_71 VGND VGND VPWR VPWR sky130_fd_sc_hd__fill_1
X_07334_ _02140_ _02142_ _02025_ VGND VGND VPWR VPWR _02143_ sky130_fd_sc_hd__mux2_1
XFILLER_0_18_469 VGND VGND VPWR VPWR sky130_fd_sc_hd__decap_6
XTAP_TAPCELL_ROW_21_526 VGND VPWR sky130_fd_sc_hd__tapvpwrvgnd_1
XFILLER_0_91_3 VPWR VGND VPWR VGND sky130_ef_sc_hd__decap_12
X_07265_ tanh_inst.divider.y\[0\] _02028_ _02029_ VGND VGND VPWR VPWR _02075_ sky130_fd_sc_hd__o21a_2
X_06216_ tanh_inst.divider.i\[2\] _01071_ _01118_ VGND VGND VPWR VPWR _01158_ sky130_fd_sc_hd__o21a_2
X_09004_ _03687_ _03688_ _03691_ VGND VGND VPWR VPWR _03747_ sky130_fd_sc_hd__a21oi_2
XFILLER_0_26_491 VPWR VGND VPWR VGND sky130_ef_sc_hd__decap_12
X_07196_ _02003_ _02007_ _02009_ _01059_ VGND VGND VPWR VPWR _02011_ sky130_fd_sc_hd__a31o_2
X_06147_ tanh_inst.divider.y\[-23\] tanh_inst.div_en tanh_inst.divider.y_\[-23\] _01092_
+ _01091_ VGND VGND VPWR VPWR _00087_ sky130_fd_sc_hd__a221o_2
XFILLER_0_14_686 VGND VGND VPWR VPWR sky130_fd_sc_hd__fill_1
X_06078_ _01022_ _01024_ tanh_inst.divider.i\[2\] VGND VGND VPWR VPWR _01025_ sky130_fd_sc_hd__mux2_1
X_09906_ _04598_ _04606_ _04624_ VGND VGND VPWR VPWR _04625_ sky130_fd_sc_hd__o21ai_2
X_09837_ _04517_ _04520_ _04557_ VGND VGND VPWR VPWR _04558_ sky130_fd_sc_hd__nor3_2
X_09768_ _04460_ _04468_ _04489_ VGND VGND VPWR VPWR _04491_ sky130_fd_sc_hd__or3_2
XTAP_TAPCELL_ROW_29_626 VGND VPWR sky130_fd_sc_hd__tapvpwrvgnd_1
XTAP_TAPCELL_ROW_57_979 VGND VPWR sky130_fd_sc_hd__tapvpwrvgnd_1
X_08719_ mac_inst.i\[6\] _00957_ VGND VGND VPWR VPWR _00271_ sky130_fd_sc_hd__xnor2_2
XFILLER_0_96_645 VGND VGND VPWR VPWR sky130_fd_sc_hd__decap_4
XTAP_TAPCELL_ROW_1_273 VGND VPWR sky130_fd_sc_hd__tapvpwrvgnd_1
X_09699_ _04418_ _04423_ _04791_ VGND VGND VPWR VPWR _04424_ sky130_fd_sc_hd__mux2_1
XTAP_TAPCELL_ROW_107_1598 VGND VPWR sky130_fd_sc_hd__tapvpwrvgnd_1
XFILLER_0_68_369 VGND VGND VPWR VPWR sky130_fd_sc_hd__fill_1
XFILLER_0_56_509 VPWR VGND VPWR VGND sky130_ef_sc_hd__decap_12
XFILLER_0_49_561 VGND VGND VPWR VPWR sky130_fd_sc_hd__decap_8
XTAP_TAPCELL_ROW_120_1765 VGND VPWR sky130_fd_sc_hd__tapvpwrvgnd_1
XFILLER_0_64_531 VGND VGND VPWR VPWR sky130_fd_sc_hd__fill_1
XFILLER_0_119_493 VGND VGND VPWR VPWR sky130_fd_sc_hd__decap_3
XFILLER_0_106_121 VPWR VGND VPWR VGND sky130_ef_sc_hd__decap_12
XFILLER_0_91_372 VGND VGND VPWR VPWR sky130_fd_sc_hd__fill_2
XFILLER_0_64_597 VGND VGND VPWR VPWR sky130_fd_sc_hd__decap_4
XFILLER_0_64_586 VGND VGND VPWR VPWR sky130_fd_sc_hd__fill_2
XFILLER_0_106_165 VPWR VGND VPWR VGND sky130_ef_sc_hd__decap_12
XFILLER_0_51_225 VGND VGND VPWR VPWR sky130_fd_sc_hd__decap_6
XFILLER_0_121_113 VPWR VGND VPWR VGND sky130_ef_sc_hd__decap_12
X_10474_ clknet_leaf_25_clk _00331_ VGND VGND VPWR VPWR tanh_inst.LOOKUP.index\[2\]
+ sky130_fd_sc_hd__dfxtp_2
XTAP_TAPCELL_ROW_75_1200 VGND VPWR sky130_fd_sc_hd__tapvpwrvgnd_1
XFILLER_0_20_634 VGND VGND VPWR VPWR sky130_fd_sc_hd__fill_2
XTAP_TAPCELL_ROW_9_373 VGND VPWR sky130_fd_sc_hd__tapvpwrvgnd_1
XFILLER_0_47_16 VGND VGND VPWR VPWR sky130_fd_sc_hd__decap_8
XFILLER_0_63_15 VGND VGND VPWR VPWR sky130_fd_sc_hd__decap_8
XFILLER_0_2_29 VPWR VGND VPWR VGND sky130_ef_sc_hd__decap_12
XTAP_TAPCELL_ROW_86_1340 VGND VPWR sky130_fd_sc_hd__tapvpwrvgnd_1
XFILLER_0_59_314 VPWR VGND VPWR VGND sky130_ef_sc_hd__decap_12
XFILLER_0_28_701 VGND VGND VPWR VPWR sky130_fd_sc_hd__fill_1
XFILLER_0_67_380 VPWR VGND VPWR VGND sky130_ef_sc_hd__decap_12
XFILLER_0_28_723 VGND VGND VPWR VPWR sky130_fd_sc_hd__fill_1
XFILLER_0_7_617 VGND VGND VPWR VPWR sky130_fd_sc_hd__decap_3
X_05380_ mac_inst.x\[31\] _04989_ _04992_ _04985_ _04781_ _04782_ VGND VGND VPWR VPWR
+ _00386_ sky130_fd_sc_hd__mux4_2
XFILLER_0_70_512 VGND VGND VPWR VPWR sky130_fd_sc_hd__fill_1
XFILLER_0_12_41 VPWR VGND VPWR VGND sky130_ef_sc_hd__decap_12
X_07050_ _01870_ _01875_ VGND VGND VPWR VPWR _01883_ sky130_fd_sc_hd__or2_2
XFILLER_0_12_85 VPWR VGND VPWR VGND sky130_ef_sc_hd__decap_12
XFILLER_0_42_236 VGND VGND VPWR VPWR sky130_fd_sc_hd__decap_8
XFILLER_0_113_647 VGND VGND VPWR VPWR sky130_fd_sc_hd__fill_1
XFILLER_0_113_625 VGND VGND VPWR VPWR sky130_fd_sc_hd__decap_8
XFILLER_0_70_589 VGND VGND VPWR VPWR sky130_fd_sc_hd__fill_2
XFILLER_0_70_567 VPWR VGND VPWR VGND sky130_ef_sc_hd__decap_12
X_06001_ mac_inst.i\[4\] mac_inst.i\[3\] _00954_ VGND VGND VPWR VPWR _00955_ sky130_fd_sc_hd__and3_2
XFILLER_0_112_146 VPWR VGND VPWR VGND sky130_ef_sc_hd__decap_12
XTAP_TAPCELL_ROW_97_1480 VGND VPWR sky130_fd_sc_hd__tapvpwrvgnd_1
XFILLER_0_2_333 VPWR VGND VPWR VGND sky130_ef_sc_hd__decap_12
XFILLER_0_11_656 VGND VGND VPWR VPWR sky130_fd_sc_hd__decap_4
XFILLER_0_10_133 VGND VGND VPWR VPWR sky130_fd_sc_hd__decap_6
XFILLER_0_2_377 VPWR VGND VPWR VGND sky130_ef_sc_hd__decap_12
XFILLER_0_10_177 VPWR VGND VPWR VGND sky130_ef_sc_hd__decap_12
X_07952_ _02019_ _02732_ _02749_ _02015_ VGND VGND VPWR VPWR _02750_ sky130_fd_sc_hd__a211o_2
X_06903_ tanh_inst.div_en tanh_inst.divider.z_\[-15\] VGND VGND VPWR VPWR _00174_
+ sky130_fd_sc_hd__and2b_2
X_07883_ _02680_ _02681_ VGND VGND VPWR VPWR _02682_ sky130_fd_sc_hd__xnor2_2
X_06834_ _01648_ _01661_ _01693_ _01723_ VGND VGND VPWR VPWR _01725_ sky130_fd_sc_hd__or4bb_2
XFILLER_0_37_93 VGND VGND VPWR VPWR sky130_fd_sc_hd__decap_6
X_09622_ _04347_ _04348_ VGND VGND VPWR VPWR _04349_ sky130_fd_sc_hd__or2_2
X_09553_ _04256_ _04259_ _04280_ VGND VGND VPWR VPWR _04282_ sky130_fd_sc_hd__o21a_2
XFILLER_0_78_634 VGND VGND VPWR VPWR sky130_fd_sc_hd__decap_4
XTAP_TAPCELL_ROW_54_938 VGND VPWR sky130_fd_sc_hd__tapvpwrvgnd_1
X_08504_ tanh_inst.divider.x\[2\] _03285_ VGND VGND VPWR VPWR _03288_ sky130_fd_sc_hd__nor2_2
X_06765_ _01660_ _01662_ VGND VGND VPWR VPWR _01664_ sky130_fd_sc_hd__or2_2
X_06696_ _01600_ _01601_ VGND VGND VPWR VPWR _01602_ sky130_fd_sc_hd__and2b_2
X_05716_ _04923_ _04944_ _04977_ _00690_ VGND VGND VPWR VPWR _00692_ sky130_fd_sc_hd__nor4_2
X_09484_ _04162_ _04163_ tanh_inst.z_\[7\] VGND VGND VPWR VPWR _04215_ sky130_fd_sc_hd__a21oi_2
XFILLER_0_92_125 VGND VGND VPWR VPWR sky130_fd_sc_hd__decap_3
XFILLER_0_19_723 VGND VGND VPWR VPWR sky130_fd_sc_hd__fill_1
X_08435_ _03102_ _03142_ _03173_ _03141_ VGND VGND VPWR VPWR _03221_ sky130_fd_sc_hd__or4b_2
X_05647_ mac_inst.y\[27\] _00629_ VGND VGND VPWR VPWR _00631_ sky130_fd_sc_hd__xnor2_2
XFILLER_0_18_233 VPWR VGND VPWR VGND sky130_ef_sc_hd__decap_12
XTAP_TAPCELL_ROW_34_684 VGND VPWR sky130_fd_sc_hd__tapvpwrvgnd_1
X_08366_ _03037_ _03093_ VGND VGND VPWR VPWR _03154_ sky130_fd_sc_hd__nand2_2
XFILLER_0_80_309 VGND VGND VPWR VPWR sky130_fd_sc_hd__decap_6
X_07317_ tanh_inst.divider.x\[-24\] _02125_ _02126_ VGND VGND VPWR VPWR _00233_ sky130_fd_sc_hd__a21oi_2
XFILLER_0_18_277 VPWR VGND VPWR VGND sky130_ef_sc_hd__decap_12
X_05578_ _00564_ _00568_ VGND VGND VPWR VPWR _05578_/X sky130_fd_sc_hd__xor2_2
XFILLER_0_73_383 VGND VGND VPWR VPWR sky130_fd_sc_hd__decap_8
XFILLER_0_6_672 VGND VGND VPWR VPWR sky130_fd_sc_hd__fill_1
X_08297_ tanh_inst.divider.x\[-3\] _03084_ VGND VGND VPWR VPWR _03086_ sky130_fd_sc_hd__xnor2_2
XFILLER_0_46_597 VGND VGND VPWR VPWR sky130_fd_sc_hd__decap_3
X_07248_ _02055_ _02057_ _02027_ VGND VGND VPWR VPWR _02058_ sky130_fd_sc_hd__mux2_1
X_07179_ tanh_inst.divider.z_\[4\] _01092_ _01996_ _01088_ VGND VGND VPWR VPWR _00225_
+ sky130_fd_sc_hd__a22o_2
XFILLER_0_5_193 VPWR VGND VPWR VGND sky130_ef_sc_hd__decap_12
X_10190_ x_in[16] _00000_ VGND VGND VPWR VPWR mac_inst.x\[16\] sky130_fd_sc_hd__dlxtn_1
XTAP_TAPCELL_ROW_70_1141 VGND VPWR sky130_fd_sc_hd__tapvpwrvgnd_1
XTAP_TAPCELL_ROW_6_343 VGND VPWR sky130_fd_sc_hd__tapvpwrvgnd_1
XTAP_TAPCELL_ROW_6_332 VGND VPWR sky130_fd_sc_hd__tapvpwrvgnd_1
XTAP_TAPCELL_ROW_109_1627 VGND VPWR sky130_fd_sc_hd__tapvpwrvgnd_1
XFILLER_0_69_601 VPWR VGND VPWR VGND sky130_ef_sc_hd__decap_12
XFILLER_0_68_111 VGND VGND VPWR VPWR sky130_fd_sc_hd__fill_1
XTAP_TAPCELL_ROW_81_1270 VGND VPWR sky130_fd_sc_hd__tapvpwrvgnd_1
XFILLER_0_83_169 VGND VGND VPWR VPWR sky130_fd_sc_hd__fill_1
XFILLER_0_71_309 VGND VGND VPWR VPWR sky130_fd_sc_hd__decap_8
XFILLER_0_37_564 VGND VGND VPWR VPWR sky130_fd_sc_hd__decap_4
XFILLER_0_107_496 VGND VGND VPWR VPWR sky130_fd_sc_hd__fill_1
X_10457_ clknet_leaf_0_clk _00314_ VGND VGND VPWR VPWR tanh_inst.divider.y\[-7\] sky130_fd_sc_hd__dfxtp_2
XFILLER_0_103_680 VGND VGND VPWR VPWR sky130_fd_sc_hd__fill_1
X_10388_ clknet_leaf_7_clk _00245_ VGND VGND VPWR VPWR tanh_inst.divider.x\[-12\]
+ sky130_fd_sc_hd__dfxtp_2
XFILLER_0_20_464 VGND VGND VPWR VPWR sky130_fd_sc_hd__fill_2
XFILLER_0_59_111 VGND VGND VPWR VPWR sky130_fd_sc_hd__fill_1
X_06550_ tanh_inst.divider.y\[7\] tanh_inst.div_en tanh_inst.divider.y_\[7\] _01092_
+ VGND VGND VPWR VPWR _01466_ sky130_fd_sc_hd__a22o_2
XFILLER_0_90_35 VGND VGND VPWR VPWR sky130_fd_sc_hd__fill_1
XFILLER_0_118_706 VGND VGND VPWR VPWR sky130_fd_sc_hd__fill_1
X_06481_ _01401_ _01402_ VGND VGND VPWR VPWR _01403_ sky130_fd_sc_hd__xor2_2
XFILLER_0_87_497 VGND VGND VPWR VPWR sky130_fd_sc_hd__decap_6
XFILLER_0_87_475 VGND VGND VPWR VPWR sky130_fd_sc_hd__decap_4
XFILLER_0_74_103 VGND VGND VPWR VPWR sky130_fd_sc_hd__fill_2
XFILLER_0_59_166 VGND VGND VPWR VPWR sky130_fd_sc_hd__fill_2
X_05501_ _00481_ _00489_ VGND VGND VPWR VPWR _00498_ sky130_fd_sc_hd__nand2_2
XFILLER_0_47_306 VGND VGND VPWR VPWR sky130_fd_sc_hd__fill_1
XFILLER_0_114_53 VPWR VGND VPWR VGND sky130_ef_sc_hd__decap_12
XFILLER_0_74_136 VGND VGND VPWR VPWR sky130_fd_sc_hd__decap_4
XFILLER_0_23_51 VGND VGND VPWR VPWR sky130_fd_sc_hd__decap_4
X_05432_ mac_inst.y\[8\] _00433_ VGND VGND VPWR VPWR _00435_ sky130_fd_sc_hd__or2_2
X_08220_ tanh_inst.divider.y\[-5\] _03010_ VGND VGND VPWR VPWR _03011_ sky130_fd_sc_hd__xor2_2
XFILLER_0_114_97 VPWR VGND VPWR VGND sky130_ef_sc_hd__decap_12
XFILLER_0_55_361 VGND VGND VPWR VPWR sky130_fd_sc_hd__fill_1
XFILLER_0_7_447 VGND VGND VPWR VPWR sky130_fd_sc_hd__fill_1
XFILLER_0_28_586 VGND VGND VPWR VPWR sky130_fd_sc_hd__fill_2
XFILLER_0_43_501 VGND VGND VPWR VPWR sky130_fd_sc_hd__decap_3
XFILLER_0_99_55 VGND VGND VPWR VPWR sky130_fd_sc_hd__fill_1
XFILLER_0_15_225 VPWR VGND VPWR VGND sky130_ef_sc_hd__decap_12
X_05363_ mac_inst.i\[2\] _04881_ _00350_ VGND VGND VPWR VPWR _00370_ sky130_fd_sc_hd__o21a_2
XTAP_TAPCELL_ROW_31_654 VGND VPWR sky130_fd_sc_hd__tapvpwrvgnd_1
X_08151_ tanh_inst.LOOKUP.index\[4\] _02185_ _02859_ VGND VGND VPWR VPWR _02944_ sky130_fd_sc_hd__o21a_2
X_07102_ _01926_ _01928_ VGND VGND VPWR VPWR _01929_ sky130_fd_sc_hd__nand2_2
X_08082_ _02874_ _02875_ VGND VGND VPWR VPWR _02876_ sky130_fd_sc_hd__nor2_2
X_05294_ _04986_ _04993_ mac_inst.i\[3\] VGND VGND VPWR VPWR _04994_ sky130_fd_sc_hd__mux2_1
XFILLER_0_43_567 VGND VGND VPWR VPWR sky130_fd_sc_hd__fill_1
X_07033_ _01860_ _01867_ VGND VGND VPWR VPWR _01868_ sky130_fd_sc_hd__xnor2_2
XFILLER_0_30_228 VGND VGND VPWR VPWR sky130_fd_sc_hd__decap_4
XFILLER_0_101_617 VGND VGND VPWR VPWR sky130_fd_sc_hd__decap_4
XFILLER_0_3_686 VGND VGND VPWR VPWR sky130_fd_sc_hd__fill_1
XFILLER_0_2_141 VPWR VGND VPWR VGND sky130_ef_sc_hd__decap_12
X_08984_ _03515_ _03517_ _03519_ _03526_ _04761_ tanh_inst.LOOKUP.index\[1\] VGND
+ VGND VPWR VPWR _03727_ sky130_fd_sc_hd__mux4_2
XFILLER_0_54_3 VGND VGND VPWR VPWR sky130_fd_sc_hd__decap_4
XTAP_TAPCELL_ROW_3_302 VGND VPWR sky130_fd_sc_hd__tapvpwrvgnd_1
X_07935_ tanh_inst.LOOKUP.index\[3\] _02367_ _02509_ VGND VGND VPWR VPWR _02733_ sky130_fd_sc_hd__o21ai_2
X_07866_ _02619_ _02623_ VGND VGND VPWR VPWR _02665_ sky130_fd_sc_hd__or2_2
X_09605_ _02018_ _04305_ _04306_ _02015_ VGND VGND VPWR VPWR _04333_ sky130_fd_sc_hd__a31o_2
X_07797_ _02596_ _02597_ VGND VGND VPWR VPWR _02598_ sky130_fd_sc_hd__xnor2_2
X_06817_ _01706_ _01707_ _01709_ VGND VGND VPWR VPWR _01710_ sky130_fd_sc_hd__or3_2
XTAP_TAPCELL_ROW_39_754 VGND VPWR sky130_fd_sc_hd__tapvpwrvgnd_1
X_09536_ _04247_ _04248_ _04265_ _04791_ VGND VGND VPWR VPWR _04266_ sky130_fd_sc_hd__o2bb2a_2
X_06748_ tanh_inst.z_\[-9\] _01647_ VGND VGND VPWR VPWR _01648_ sky130_fd_sc_hd__nor2_2
XFILLER_0_109_706 VPWR VGND VPWR VGND sky130_ef_sc_hd__decap_12
X_09467_ tanh_inst.divider.y\[-9\] _04196_ VGND VGND VPWR VPWR _04198_ sky130_fd_sc_hd__xnor2_2
XTAP_TAPCELL_ROW_104_1557 VGND VPWR sky130_fd_sc_hd__tapvpwrvgnd_1
XTAP_TAPCELL_ROW_104_1568 VGND VPWR sky130_fd_sc_hd__tapvpwrvgnd_1
X_06679_ _01585_ _01586_ VGND VGND VPWR VPWR _01587_ sky130_fd_sc_hd__nand2_2
XFILLER_0_19_531 VGND VGND VPWR VPWR sky130_fd_sc_hd__decap_8
X_08418_ tanh_inst.divider.y\[0\] _03202_ VGND VGND VPWR VPWR _03204_ sky130_fd_sc_hd__and2_2
X_09398_ tanh_inst.divider.x\[7\] _03831_ _03832_ _03827_ _02023_ _02052_ VGND VGND
+ VPWR VPWR _04131_ sky130_fd_sc_hd__mux4_2
XFILLER_0_65_169 VPWR VGND VPWR VGND sky130_ef_sc_hd__decap_12
XFILLER_0_80_139 VGND VGND VPWR VPWR sky130_fd_sc_hd__fill_1
XFILLER_0_61_320 VGND VGND VPWR VPWR sky130_fd_sc_hd__fill_1
X_08349_ _03056_ _03134_ _03133_ _03096_ VGND VGND VPWR VPWR _03137_ sky130_fd_sc_hd__a211o_2
XFILLER_0_34_523 VGND VGND VPWR VPWR sky130_fd_sc_hd__fill_1
XTAP_TAPCELL_ROW_59_1003 VGND VPWR sky130_fd_sc_hd__tapvpwrvgnd_1
XFILLER_0_34_545 VGND VGND VPWR VPWR sky130_fd_sc_hd__decap_3
X_10311_ clknet_leaf_16_clk _00168_ VGND VGND VPWR VPWR tanh_out[3] sky130_fd_sc_hd__dfxtp_2
XFILLER_0_21_217 VGND VGND VPWR VPWR sky130_fd_sc_hd__decap_6
XFILLER_0_104_477 VGND VGND VPWR VPWR sky130_fd_sc_hd__decap_3
X_10242_ clknet_leaf_31_clk mac_inst.x\[4\] _00000_ VGND VGND VPWR VPWR mac_x_out[4]
+ sky130_fd_sc_hd__dfrtp_2
XTAP_TAPCELL_ROW_115_1697 VGND VPWR sky130_fd_sc_hd__tapvpwrvgnd_1
XFILLER_0_28_29 VPWR VGND VPWR VGND sky130_ef_sc_hd__decap_12
XFILLER_0_44_39 VGND VGND VPWR VPWR sky130_fd_sc_hd__fill_2
XFILLER_0_29_317 VGND VGND VPWR VPWR sky130_fd_sc_hd__fill_2
XFILLER_0_96_294 VPWR VGND VPWR VGND sky130_ef_sc_hd__decap_12
XFILLER_0_96_283 VGND VGND VPWR VPWR sky130_fd_sc_hd__decap_4
XFILLER_0_60_27 VGND VGND VPWR VPWR sky130_fd_sc_hd__fill_1
XFILLER_0_71_106 VGND VGND VPWR VPWR sky130_fd_sc_hd__decap_6
XFILLER_0_60_49 VGND VGND VPWR VPWR sky130_fd_sc_hd__decap_4
XFILLER_0_13_707 VPWR VGND VPWR VGND sky130_ef_sc_hd__decap_12
XFILLER_0_52_331 VGND VGND VPWR VPWR sky130_fd_sc_hd__decap_8
XFILLER_0_0_601 VPWR VGND VPWR VGND sky130_ef_sc_hd__decap_12
XFILLER_0_110_447 VGND VGND VPWR VPWR sky130_fd_sc_hd__decap_8
XFILLER_0_110_425 VGND VGND VPWR VPWR sky130_fd_sc_hd__fill_1
XFILLER_0_0_645 VGND VGND VPWR VPWR sky130_fd_sc_hd__decap_4
XFILLER_0_0_689 VGND VGND VPWR VPWR sky130_fd_sc_hd__fill_1
XFILLER_0_85_46 VGND VGND VPWR VPWR sky130_fd_sc_hd__decap_3
X_07720_ _02521_ _02522_ VGND VGND VPWR VPWR _02523_ sky130_fd_sc_hd__xor2_2
X_05981_ _04781_ _04933_ _04976_ _00846_ VGND VGND VPWR VPWR _00936_ sky130_fd_sc_hd__and4_2
X_07651_ tanh_inst.divider.y\[-18\] tanh_inst.divider.x\[-18\] VGND VGND VPWR VPWR
+ _02455_ sky130_fd_sc_hd__or2_2
X_07582_ _02025_ _02142_ _02386_ _02023_ VGND VGND VPWR VPWR _02387_ sky130_fd_sc_hd__o211a_2
X_06602_ tanh_inst.LOOKUP.index\[0\] _01473_ VGND VGND VPWR VPWR _01515_ sky130_fd_sc_hd__nand2_2
XTAP_TAPCELL_ROW_36_713 VGND VPWR sky130_fd_sc_hd__tapvpwrvgnd_1
X_06533_ _01448_ _01449_ _01450_ VGND VGND VPWR VPWR _01451_ sky130_fd_sc_hd__a21oi_2
X_09321_ _02019_ _04043_ _04056_ _02015_ VGND VGND VPWR VPWR _04057_ sky130_fd_sc_hd__a211o_2
XFILLER_0_75_401 VGND VGND VPWR VPWR sky130_fd_sc_hd__fill_1
XFILLER_0_8_701 VGND VGND VPWR VPWR sky130_fd_sc_hd__fill_2
X_06464_ _04793_ _01386_ _01385_ VGND VGND VPWR VPWR _01387_ sky130_fd_sc_hd__a21oi_2
X_09252_ _02022_ _03606_ _03916_ VGND VGND VPWR VPWR _03989_ sky130_fd_sc_hd__o21a_2
XFILLER_0_47_169 VGND VGND VPWR VPWR sky130_fd_sc_hd__fill_2
X_06395_ _04792_ _01323_ VGND VGND VPWR VPWR _01324_ sky130_fd_sc_hd__nor2_2
X_09183_ tanh_inst.divider.x\[-17\] _03921_ VGND VGND VPWR VPWR _03922_ sky130_fd_sc_hd__and2b_2
XFILLER_0_90_448 VGND VGND VPWR VPWR sky130_fd_sc_hd__fill_1
X_05415_ _04836_ _00414_ _00418_ _05021_ VGND VGND VPWR VPWR _00419_ sky130_fd_sc_hd__o211ai_2
XFILLER_0_43_320 VPWR VGND VPWR VGND sky130_ef_sc_hd__decap_12
X_08203_ _02992_ _02994_ VGND VGND VPWR VPWR _02995_ sky130_fd_sc_hd__nand2_2
X_05346_ _04836_ _00353_ VGND VGND VPWR VPWR _00354_ sky130_fd_sc_hd__nor2_2
XFILLER_0_50_93 VPWR VGND VPWR VGND sky130_ef_sc_hd__decap_12
X_08134_ _02925_ _02926_ VGND VGND VPWR VPWR _02927_ sky130_fd_sc_hd__nand2b_2
XFILLER_0_71_673 VPWR VGND VPWR VGND sky130_ef_sc_hd__decap_12
X_08065_ _01525_ _02510_ _02513_ _01477_ _02859_ VGND VGND VPWR VPWR _02860_ sky130_fd_sc_hd__o221a_2
X_05277_ mac_inst.i\[3\] _04933_ VGND VGND VPWR VPWR _04978_ sky130_fd_sc_hd__nand2_2
XFILLER_0_31_559 VGND VGND VPWR VPWR sky130_fd_sc_hd__fill_1
X_07016_ _01059_ _01851_ _01852_ _01088_ _00174_ VGND VGND VPWR VPWR _00206_ sky130_fd_sc_hd__o32a_2
XFILLER_0_113_296 VGND VGND VPWR VPWR sky130_fd_sc_hd__fill_2
XFILLER_0_101_447 VGND VGND VPWR VPWR sky130_fd_sc_hd__fill_1
XFILLER_0_11_261 VPWR VGND VPWR VGND sky130_ef_sc_hd__decap_12
X_08967_ _03709_ _03710_ tanh_inst.LOOKUP.index\[2\] VGND VGND VPWR VPWR _03711_ sky130_fd_sc_hd__mux2_1
X_07918_ _02626_ _02667_ _02715_ VGND VGND VPWR VPWR _02716_ sky130_fd_sc_hd__a21o_2
X_08898_ _03641_ _03642_ tanh_inst.LOOKUP.index\[2\] VGND VGND VPWR VPWR _03643_ sky130_fd_sc_hd__mux2_1
X_07849_ tanh_inst.divider.x\[-14\] _02647_ VGND VGND VPWR VPWR _02649_ sky130_fd_sc_hd__xnor2_2
X_09519_ _04179_ _04203_ VGND VGND VPWR VPWR _04249_ sky130_fd_sc_hd__nand2b_2
XFILLER_0_78_261 VGND VGND VPWR VPWR sky130_fd_sc_hd__decap_6
XFILLER_0_66_401 VGND VGND VPWR VPWR sky130_fd_sc_hd__decap_8
XFILLER_0_109_503 VGND VGND VPWR VPWR sky130_fd_sc_hd__fill_1
XTAP_TAPCELL_ROW_65_1073 VGND VPWR sky130_fd_sc_hd__tapvpwrvgnd_1
XFILLER_0_39_637 VPWR VGND VPWR VGND sky130_ef_sc_hd__decap_12
XFILLER_0_66_489 VGND VGND VPWR VPWR sky130_fd_sc_hd__decap_4
XFILLER_0_54_629 VGND VGND VPWR VPWR sky130_fd_sc_hd__fill_2
XFILLER_0_26_309 VPWR VGND VPWR VGND sky130_ef_sc_hd__decap_12
XFILLER_0_81_437 VGND VGND VPWR VPWR sky130_fd_sc_hd__decap_8
XFILLER_0_62_640 VGND VGND VPWR VPWR sky130_fd_sc_hd__decap_4
XTAP_TAPCELL_ROW_117_1726 VGND VPWR sky130_fd_sc_hd__tapvpwrvgnd_1
XFILLER_0_22_537 VGND VGND VPWR VPWR sky130_fd_sc_hd__fill_1
XPHY_EDGE_ROW_18_Left_140 VGND VGND VPWR VPWR sky130_fd_sc_hd__decap_3
XFILLER_0_39_28 VGND VGND VPWR VPWR sky130_fd_sc_hd__fill_2
X_10225_ clknet_leaf_28_clk mac_inst.y\[19\] _00000_ VGND VGND VPWR VPWR mac_y_out[19]
+ sky130_fd_sc_hd__dfrtp_2
X_10087_ clknet_leaf_4_clk _00104_ VGND VGND VPWR VPWR tanh_inst.divider.y_\[-6\]
+ sky130_fd_sc_hd__dfxtp_2
XFILLER_0_89_515 VGND VGND VPWR VPWR sky130_fd_sc_hd__decap_8
XFILLER_0_71_15 VPWR VGND VPWR VGND sky130_ef_sc_hd__decap_12
XFILLER_0_69_272 VGND VGND VPWR VPWR sky130_fd_sc_hd__decap_8
XFILLER_0_57_423 VGND VGND VPWR VPWR sky130_fd_sc_hd__fill_1
XFILLER_0_29_125 VGND VGND VPWR VPWR sky130_fd_sc_hd__fill_1
XFILLER_0_84_253 VPWR VGND VPWR VGND sky130_ef_sc_hd__decap_12
XFILLER_0_57_467 VPWR VGND VPWR VGND sky130_ef_sc_hd__decap_12
XFILLER_0_44_128 VPWR VGND VPWR VGND sky130_ef_sc_hd__decap_12
XFILLER_0_112_3 VPWR VGND VPWR VGND sky130_ef_sc_hd__decap_12
XFILLER_0_53_640 VGND VGND VPWR VPWR sky130_fd_sc_hd__fill_1
X_05200_ mac_inst.i\[0\] mac_inst.x\[3\] _04852_ VGND VGND VPWR VPWR _04904_ sky130_fd_sc_hd__and3_2
XTAP_TAPCELL_ROW_41_771 VGND VPWR sky130_fd_sc_hd__tapvpwrvgnd_1
X_06180_ _01122_ _01123_ _04777_ VGND VGND VPWR VPWR _01124_ sky130_fd_sc_hd__mux2_1
XFILLER_0_20_41 VPWR VGND VPWR VGND sky130_ef_sc_hd__decap_12
XTAP_TAPCELL_ROW_92_1409 VGND VPWR sky130_fd_sc_hd__tapvpwrvgnd_1
XFILLER_0_20_85 VPWR VGND VPWR VGND sky130_ef_sc_hd__decap_12
X_05131_ mac_inst.i\[5\] mac_inst.i\[4\] VGND VGND VPWR VPWR _04835_ sky130_fd_sc_hd__and2b_2
XFILLER_0_52_183 VGND VGND VPWR VPWR sky130_fd_sc_hd__decap_4
XFILLER_0_52_194 VGND VGND VPWR VPWR sky130_fd_sc_hd__fill_2
X_05062_ mac_inst.i\[24\] VGND VGND VPWR VPWR _04786_ sky130_fd_sc_hd__inv_2
XFILLER_0_96_45 VGND VGND VPWR VPWR sky130_fd_sc_hd__fill_1
XFILLER_0_21_592 VGND VGND VPWR VPWR sky130_fd_sc_hd__fill_1
X_09870_ _04541_ _04589_ _04547_ VGND VGND VPWR VPWR _04590_ sky130_fd_sc_hd__a21o_2
X_08821_ _03557_ _03566_ _02025_ VGND VGND VPWR VPWR _03567_ sky130_fd_sc_hd__mux2_1
X_05964_ _00717_ _00730_ _00847_ VGND VGND VPWR VPWR _00921_ sky130_fd_sc_hd__or3_2
X_08752_ _00968_ _03504_ VGND VGND VPWR VPWR _00290_ sky130_fd_sc_hd__nor2_2
X_07703_ _02491_ _02504_ VGND VGND VPWR VPWR _02506_ sky130_fd_sc_hd__nand2_2
X_08683_ _03364_ _03371_ _03421_ _03422_ VGND VGND VPWR VPWR _03463_ sky130_fd_sc_hd__o31a_2
X_07634_ tanh_inst.divider.y\[7\] _02213_ _02025_ VGND VGND VPWR VPWR _02438_ sky130_fd_sc_hd__mux2_1
X_05895_ _00804_ _00819_ _00857_ _00807_ VGND VGND VPWR VPWR _00858_ sky130_fd_sc_hd__or4b_2
XFILLER_0_17_3 VPWR VGND VPWR VGND sky130_ef_sc_hd__decap_12
XTAP_TAPCELL_ROW_49_871 VGND VPWR sky130_fd_sc_hd__tapvpwrvgnd_1
XFILLER_0_95_529 VPWR VGND VPWR VGND sky130_ef_sc_hd__decap_12
X_07565_ _01486_ _02104_ _02107_ _01480_ VGND VGND VPWR VPWR _02371_ sky130_fd_sc_hd__o22a_2
X_09304_ _03992_ _04035_ _04036_ VGND VGND VPWR VPWR _04040_ sky130_fd_sc_hd__nand3_2
X_06516_ _01425_ _01426_ _01415_ VGND VGND VPWR VPWR _01435_ sky130_fd_sc_hd__nor3b_2
XTAP_TAPCELL_ROW_101_1527 VGND VPWR sky130_fd_sc_hd__tapvpwrvgnd_1
X_07496_ _02301_ _02302_ VGND VGND VPWR VPWR _02303_ sky130_fd_sc_hd__xnor2_2
XFILLER_0_8_531 VGND VGND VPWR VPWR sky130_fd_sc_hd__fill_1
X_06447_ _01370_ _01371_ VGND VGND VPWR VPWR _01372_ sky130_fd_sc_hd__nor2_2
X_09235_ _03887_ _03891_ _03933_ _03971_ _03931_ VGND VGND VPWR VPWR _03973_ sky130_fd_sc_hd__a311oi_2
XFILLER_0_61_81 VGND VGND VPWR VPWR sky130_fd_sc_hd__fill_1
XFILLER_0_29_670 VGND VGND VPWR VPWR sky130_fd_sc_hd__fill_2
XFILLER_0_48_489 VPWR VGND VPWR VGND sky130_ef_sc_hd__decap_12
XFILLER_0_90_234 VGND VGND VPWR VPWR sky130_fd_sc_hd__fill_1
XFILLER_0_8_586 VGND VGND VPWR VPWR sky130_fd_sc_hd__fill_2
XFILLER_0_35_139 VGND VGND VPWR VPWR sky130_fd_sc_hd__decap_4
X_06378_ tanh_inst.divider.y\[-8\] tanh_inst.div_en tanh_inst.divider.y_\[-8\] _01092_
+ VGND VGND VPWR VPWR _01309_ sky130_fd_sc_hd__a22o_2
XFILLER_0_90_278 VPWR VGND VPWR VGND sky130_ef_sc_hd__decap_12
X_09166_ _03821_ _03822_ _03862_ _03819_ VGND VGND VPWR VPWR _03906_ sky130_fd_sc_hd__a211oi_2
X_09097_ _03801_ _03805_ VGND VGND VPWR VPWR _03838_ sky130_fd_sc_hd__and2_2
XFILLER_0_9_93 VPWR VGND VPWR VGND sky130_ef_sc_hd__decap_12
X_05329_ _04908_ _05025_ _05026_ _05027_ _04922_ VGND VGND VPWR VPWR _05028_ sky130_fd_sc_hd__a32o_2
XFILLER_0_31_345 VGND VGND VPWR VPWR sky130_fd_sc_hd__fill_1
X_08117_ tanh_inst.LOOKUP.index\[4\] _02121_ _02859_ VGND VGND VPWR VPWR _02911_ sky130_fd_sc_hd__o21a_2
X_08048_ _02787_ _02790_ _02842_ VGND VGND VPWR VPWR _02843_ sky130_fd_sc_hd__nor3_2
XTAP_TAPCELL_ROW_112_1667 VGND VPWR sky130_fd_sc_hd__tapvpwrvgnd_1
XTAP_TAPCELL_ROW_112_1656 VGND VPWR sky130_fd_sc_hd__tapvpwrvgnd_1
XFILLER_0_101_277 VGND VGND VPWR VPWR sky130_fd_sc_hd__decap_3
X_10010_ _04660_ _04661_ _04690_ _04691_ _04658_ VGND VGND VPWR VPWR _04726_ sky130_fd_sc_hd__a2111oi_2
X_09999_ _03450_ _04713_ VGND VGND VPWR VPWR _04715_ sky130_fd_sc_hd__xnor2_2
XTAP_TAPCELL_ROW_67_1102 VGND VPWR sky130_fd_sc_hd__tapvpwrvgnd_1
XFILLER_0_39_412 VPWR VGND VPWR VGND sky130_ef_sc_hd__decap_12
XFILLER_0_54_404 VGND VGND VPWR VPWR sky130_fd_sc_hd__fill_1
XTAP_TAPCELL_ROW_27_598 VGND VPWR sky130_fd_sc_hd__tapvpwrvgnd_1
XFILLER_0_109_344 VGND VGND VPWR VPWR sky130_fd_sc_hd__fill_2
XFILLER_0_94_584 VGND VGND VPWR VPWR sky130_fd_sc_hd__decap_4
XFILLER_0_81_201 VGND VGND VPWR VPWR sky130_fd_sc_hd__fill_1
XFILLER_0_54_459 VGND VGND VPWR VPWR sky130_fd_sc_hd__decap_6
XFILLER_0_26_139 VGND VGND VPWR VPWR sky130_fd_sc_hd__fill_1
XFILLER_0_22_301 VGND VGND VPWR VPWR sky130_fd_sc_hd__decap_6
XFILLER_0_35_673 VGND VGND VPWR VPWR sky130_fd_sc_hd__fill_2
XFILLER_0_105_561 VGND VGND VPWR VPWR sky130_fd_sc_hd__fill_2
XTAP_TAPCELL_ROW_78_1242 VGND VPWR sky130_fd_sc_hd__tapvpwrvgnd_1
XTAP_TAPCELL_ROW_78_1231 VGND VPWR sky130_fd_sc_hd__tapvpwrvgnd_1
XFILLER_0_1_217 VGND VGND VPWR VPWR sky130_fd_sc_hd__decap_6
XFILLER_0_22_345 VGND VGND VPWR VPWR sky130_fd_sc_hd__decap_3
XFILLER_0_50_698 VGND VGND VPWR VPWR sky130_fd_sc_hd__fill_2
XFILLER_0_66_26 VGND VGND VPWR VPWR sky130_fd_sc_hd__fill_2
XFILLER_0_66_15 VGND VGND VPWR VPWR sky130_fd_sc_hd__decap_3
X_10208_ clknet_leaf_24_clk mac_inst.y\[2\] _00000_ VGND VGND VPWR VPWR mac_y_out[2]
+ sky130_fd_sc_hd__dfrtp_2
XTAP_TAPCELL_ROW_89_1371 VGND VPWR sky130_fd_sc_hd__tapvpwrvgnd_1
X_05680_ mac_inst.x\[31\] mac_inst.y\[31\] VGND VGND VPWR VPWR _00660_ sky130_fd_sc_hd__xor2_2
XTAP_TAPCELL_ROW_46_841 VGND VPWR sky130_fd_sc_hd__tapvpwrvgnd_1
XFILLER_0_106_65 VPWR VGND VPWR VGND sky130_ef_sc_hd__decap_12
X_07350_ _02156_ _02157_ tanh_inst.divider.y\[-23\] VGND VGND VPWR VPWR _02159_ sky130_fd_sc_hd__o21ai_2
XFILLER_0_57_242 VPWR VGND VPWR VGND sky130_ef_sc_hd__decap_12
XFILLER_0_9_317 VPWR VGND VPWR VGND sky130_ef_sc_hd__decap_12
X_06301_ tanh_inst.divider.y\[-14\] tanh_inst.div_en tanh_inst.divider.y_\[-14\] _01092_
+ _01237_ VGND VGND VPWR VPWR _00096_ sky130_fd_sc_hd__a221o_2
X_07281_ tanh_inst.divider.y\[-6\] _02028_ _02029_ VGND VGND VPWR VPWR _02091_ sky130_fd_sc_hd__o21ai_2
XFILLER_0_26_640 VGND VGND VPWR VPWR sky130_fd_sc_hd__decap_4
X_09020_ _03759_ _03762_ tanh_inst.LOOKUP.index\[3\] VGND VGND VPWR VPWR _03763_ sky130_fd_sc_hd__mux2_1
X_06232_ _01094_ _01096_ tanh_inst.divider.i\[2\] VGND VGND VPWR VPWR _01173_ sky130_fd_sc_hd__mux2_1
XFILLER_0_60_418 VGND VGND VPWR VPWR sky130_fd_sc_hd__fill_2
XFILLER_0_31_84 VGND VGND VPWR VPWR sky130_fd_sc_hd__decap_4
XFILLER_0_53_470 VPWR VGND VPWR VGND sky130_ef_sc_hd__decap_12
X_06163_ _01044_ _01083_ tanh_inst.divider.y_\[7\] VGND VGND VPWR VPWR _01108_ sky130_fd_sc_hd__a21oi_2
X_05114_ mac_counter\[6\] mac_counter\[5\] _04825_ VGND VGND VPWR VPWR _04826_ sky130_fd_sc_hd__and3_2
XFILLER_0_111_564 VGND VGND VPWR VPWR sky130_fd_sc_hd__fill_1
XFILLER_0_111_553 VGND VGND VPWR VPWR sky130_fd_sc_hd__decap_6
X_06094_ tanh_inst.divider.x\[-12\] tanh_inst.divider.x\[-11\] tanh_inst.divider.x\[-10\]
+ tanh_inst.divider.x\[-9\] tanh_inst.divider.i\[0\] tanh_inst.divider.i\[1\] VGND
+ VGND VPWR VPWR _01041_ sky130_fd_sc_hd__mux4_2
X_05045_ tanh_inst.divider.x\[7\] VGND VGND VPWR VPWR _04769_ sky130_fd_sc_hd__inv_2
X_09922_ _04757_ _04114_ _04212_ VGND VGND VPWR VPWR _04640_ sky130_fd_sc_hd__a21oi_2
X_09853_ _04757_ _04044_ _04212_ VGND VGND VPWR VPWR _04573_ sky130_fd_sc_hd__a21o_2
X_08804_ tanh_inst.divider.x\[-4\] _02028_ _03508_ VGND VGND VPWR VPWR _03550_ sky130_fd_sc_hd__o21a_2
X_09784_ _04375_ _04503_ _04504_ _04505_ _04497_ VGND VGND VPWR VPWR _04506_ sky130_fd_sc_hd__o2111a_2
X_06996_ _01833_ _01834_ VGND VGND VPWR VPWR _01835_ sky130_fd_sc_hd__nand2b_2
X_08735_ mac_inst.i\[16\] _03495_ mac_inst.i\[17\] VGND VGND VPWR VPWR _03496_ sky130_fd_sc_hd__a21oi_2
X_05947_ _00905_ VGND VGND VPWR VPWR _00906_ sky130_fd_sc_hd__inv_2
X_08666_ tanh_inst.divider.y\[6\] tanh_inst.divider.x\[6\] VGND VGND VPWR VPWR _03446_
+ sky130_fd_sc_hd__nand2_2
X_05878_ mac_inst.z\[15\] _00839_ VGND VGND VPWR VPWR _00842_ sky130_fd_sc_hd__nor2_2
X_07617_ _01525_ _02421_ VGND VGND VPWR VPWR _02422_ sky130_fd_sc_hd__or2_2
X_08597_ _03376_ _03378_ VGND VGND VPWR VPWR _03379_ sky130_fd_sc_hd__nor2_2
X_07548_ _02337_ _02352_ _02353_ VGND VGND VPWR VPWR _02354_ sky130_fd_sc_hd__a21oi_2
XFILLER_0_48_253 VGND VGND VPWR VPWR sky130_fd_sc_hd__fill_2
XFILLER_0_118_141 VPWR VGND VPWR VGND sky130_ef_sc_hd__decap_12
XFILLER_0_64_713 VGND VGND VPWR VPWR sky130_fd_sc_hd__decap_8
XTAP_TAPCELL_ROW_62_1043 VGND VPWR sky130_fd_sc_hd__tapvpwrvgnd_1
XTAP_TAPCELL_ROW_62_1032 VGND VPWR sky130_fd_sc_hd__tapvpwrvgnd_1
XTAP_TAPCELL_ROW_24_557 VGND VPWR sky130_fd_sc_hd__tapvpwrvgnd_1
XTAP_TAPCELL_ROW_24_568 VGND VPWR sky130_fd_sc_hd__tapvpwrvgnd_1
X_07479_ tanh_inst.divider.y\[7\] _02280_ _02282_ _02284_ _02025_ _02023_ VGND VGND
+ VPWR VPWR _02286_ sky130_fd_sc_hd__mux4_2
X_09218_ tanh_inst.divider.y\[-16\] _03955_ VGND VGND VPWR VPWR _03956_ sky130_fd_sc_hd__and2_2
X_09149_ _03887_ _03888_ VGND VGND VPWR VPWR _03889_ sky130_fd_sc_hd__nand2_2
XFILLER_0_32_643 VGND VGND VPWR VPWR sky130_fd_sc_hd__fill_1
XFILLER_0_102_564 VGND VGND VPWR VPWR sky130_fd_sc_hd__fill_1
XFILLER_0_102_542 VGND VGND VPWR VPWR sky130_fd_sc_hd__fill_2
XFILLER_0_102_531 VGND VGND VPWR VPWR sky130_fd_sc_hd__fill_1
XFILLER_0_31_186 VGND VGND VPWR VPWR sky130_fd_sc_hd__fill_2
XFILLER_0_6_3 VPWR VGND VPWR VGND sky130_ef_sc_hd__decap_12
XTAP_TAPCELL_ROW_73_1172 VGND VPWR sky130_fd_sc_hd__tapvpwrvgnd_1
XFILLER_0_99_621 VGND VGND VPWR VPWR sky130_fd_sc_hd__fill_1
XFILLER_0_36_29 VPWR VGND VPWR VGND sky130_ef_sc_hd__decap_12
XFILLER_0_98_120 VGND VGND VPWR VPWR sky130_fd_sc_hd__decap_8
XFILLER_0_99_698 VGND VGND VPWR VPWR sky130_fd_sc_hd__fill_1
XFILLER_0_98_197 VGND VGND VPWR VPWR sky130_fd_sc_hd__fill_1
XTAP_TAPCELL_ROW_43_800 VGND VPWR sky130_fd_sc_hd__tapvpwrvgnd_1
XFILLER_0_94_370 VPWR VGND VPWR VGND sky130_ef_sc_hd__decap_12
XFILLER_0_82_510 VGND VGND VPWR VPWR sky130_fd_sc_hd__decap_3
XFILLER_0_109_152 VGND VGND VPWR VPWR sky130_fd_sc_hd__decap_3
XFILLER_0_94_392 VGND VGND VPWR VPWR sky130_fd_sc_hd__decap_6
XFILLER_0_6_309 VPWR VGND VPWR VGND sky130_ef_sc_hd__decap_12
XFILLER_0_109_185 VPWR VGND VPWR VGND sky130_ef_sc_hd__decap_12
XFILLER_0_14_109 VPWR VGND VPWR VGND sky130_ef_sc_hd__decap_12
XFILLER_0_22_153 VPWR VGND VPWR VGND sky130_ef_sc_hd__decap_12
XFILLER_0_23_665 VGND VGND VPWR VPWR sky130_fd_sc_hd__decap_6
XFILLER_0_50_440 VPWR VGND VPWR VGND sky130_ef_sc_hd__decap_12
XFILLER_0_77_36 VPWR VGND VPWR VGND sky130_ef_sc_hd__decap_12
XFILLER_0_50_495 VPWR VGND VPWR VGND sky130_ef_sc_hd__decap_12
XFILLER_0_22_197 VPWR VGND VPWR VGND sky130_ef_sc_hd__decap_12
X_06850_ _01734_ _01737_ _01502_ VGND VGND VPWR VPWR _01739_ sky130_fd_sc_hd__o21ai_2
X_05801_ _00769_ _00770_ VGND VGND VPWR VPWR _05801_/Y sky130_fd_sc_hd__xnor2_2
X_06781_ tanh_inst.z_\[-7\] _01668_ _01677_ VGND VGND VPWR VPWR _01678_ sky130_fd_sc_hd__o21a_2
X_05732_ _04943_ _00706_ VGND VGND VPWR VPWR _00707_ sky130_fd_sc_hd__nand2_2
X_08520_ _03296_ _03302_ VGND VGND VPWR VPWR _03304_ sky130_fd_sc_hd__and2_2
X_08451_ _03075_ _03114_ _03236_ VGND VGND VPWR VPWR _03237_ sky130_fd_sc_hd__or3_2
X_05663_ _04912_ _00488_ _00510_ VGND VGND VPWR VPWR _00645_ sky130_fd_sc_hd__o21a_2
X_07402_ _02027_ _02060_ VGND VGND VPWR VPWR _02210_ sky130_fd_sc_hd__nor2_2
XFILLER_0_9_125 VPWR VGND VPWR VGND sky130_ef_sc_hd__decap_12
X_08382_ _03130_ _03137_ _03167_ VGND VGND VPWR VPWR _03169_ sky130_fd_sc_hd__a21o_2
X_05594_ _00564_ _00573_ VGND VGND VPWR VPWR _00583_ sky130_fd_sc_hd__nor2_2
X_07333_ _02036_ _02042_ _02044_ _02040_ _04760_ _04761_ VGND VGND VPWR VPWR _02142_
+ sky130_fd_sc_hd__mux4_2
XFILLER_0_9_169 VPWR VGND VPWR VGND sky130_ef_sc_hd__decap_12
XTAP_TAPCELL_ROW_21_527 VGND VPWR sky130_fd_sc_hd__tapvpwrvgnd_1
XFILLER_0_115_111 VGND VGND VPWR VPWR sky130_fd_sc_hd__fill_1
X_07264_ tanh_inst.divider.y\[1\] _02028_ _02029_ VGND VGND VPWR VPWR _02074_ sky130_fd_sc_hd__o21ai_2
XFILLER_0_45_256 VGND VGND VPWR VPWR sky130_fd_sc_hd__fill_1
X_06215_ _01065_ _01069_ tanh_inst.divider.i\[2\] VGND VGND VPWR VPWR _01157_ sky130_fd_sc_hd__mux2_1
X_09003_ _03742_ _03743_ VGND VGND VPWR VPWR _03746_ sky130_fd_sc_hd__xnor2_2
XFILLER_0_84_3 VPWR VGND VPWR VGND sky130_ef_sc_hd__decap_12
XFILLER_0_26_470 VGND VGND VPWR VPWR sky130_fd_sc_hd__decap_6
X_07195_ _02003_ _02007_ _02009_ VGND VGND VPWR VPWR _02010_ sky130_fd_sc_hd__a21oi_2
XFILLER_0_60_248 VGND VGND VPWR VPWR sky130_fd_sc_hd__decap_4
X_06146_ tanh_inst.div_en _01060_ VGND VGND VPWR VPWR _01092_ sky130_fd_sc_hd__nor2_2
X_06077_ tanh_inst.divider.x\[4\] tanh_inst.divider.x\[5\] tanh_inst.divider.x\[6\]
+ tanh_inst.divider.x\[7\] tanh_inst.divider.i\[0\] tanh_inst.divider.i\[1\] VGND
+ VGND VPWR VPWR _01024_ sky130_fd_sc_hd__mux4_2
XFILLER_0_6_83 VGND VGND VPWR VPWR sky130_fd_sc_hd__fill_1
X_09905_ _04622_ _04623_ VGND VGND VPWR VPWR _04624_ sky130_fd_sc_hd__nor2_2
X_09836_ _04555_ _04556_ VGND VGND VPWR VPWR _04557_ sky130_fd_sc_hd__nor2_2
X_06979_ _01776_ _01818_ VGND VGND VPWR VPWR _01819_ sky130_fd_sc_hd__or2_2
X_09767_ _04460_ _04468_ _04489_ VGND VGND VPWR VPWR _04490_ sky130_fd_sc_hd__o21ai_2
XTAP_TAPCELL_ROW_29_627 VGND VPWR sky130_fd_sc_hd__tapvpwrvgnd_1
XTAP_TAPCELL_ROW_57_969 VGND VPWR sky130_fd_sc_hd__tapvpwrvgnd_1
X_08718_ _00957_ _03490_ VGND VGND VPWR VPWR _00270_ sky130_fd_sc_hd__and2_2
X_09698_ _04421_ _04422_ VGND VGND VPWR VPWR _04423_ sky130_fd_sc_hd__xor2_2
X_08649_ tanh_inst.divider.x\[5\] _03429_ VGND VGND VPWR VPWR _03430_ sky130_fd_sc_hd__nand2_2
XTAP_TAPCELL_ROW_1_274 VGND VPWR sky130_fd_sc_hd__tapvpwrvgnd_1
XTAP_TAPCELL_ROW_107_1599 VGND VPWR sky130_fd_sc_hd__tapvpwrvgnd_1
XFILLER_0_49_540 VGND VGND VPWR VPWR sky130_fd_sc_hd__fill_1
XTAP_TAPCELL_ROW_120_1766 VGND VPWR sky130_fd_sc_hd__tapvpwrvgnd_1
XFILLER_0_106_133 VGND VGND VPWR VPWR sky130_fd_sc_hd__fill_1
XFILLER_0_51_215 VGND VGND VPWR VPWR sky130_fd_sc_hd__decap_8
XFILLER_0_121_125 VPWR VGND VPWR VGND sky130_ef_sc_hd__decap_12
XFILLER_0_106_177 VGND VGND VPWR VPWR sky130_fd_sc_hd__fill_1
X_10473_ clknet_leaf_25_clk _00330_ VGND VGND VPWR VPWR tanh_inst.LOOKUP.index\[1\]
+ sky130_fd_sc_hd__dfxtp_2
XTAP_TAPCELL_ROW_75_1201 VGND VPWR sky130_fd_sc_hd__tapvpwrvgnd_1
XFILLER_0_20_602 VGND VGND VPWR VPWR sky130_fd_sc_hd__fill_1
XFILLER_0_32_462 VPWR VGND VPWR VGND sky130_ef_sc_hd__decap_12
XFILLER_0_121_169 VPWR VGND VPWR VGND sky130_ef_sc_hd__decap_12
XTAP_TAPCELL_ROW_9_374 VGND VPWR sky130_fd_sc_hd__tapvpwrvgnd_1
XTAP_TAPCELL_ROW_86_1341 VGND VPWR sky130_fd_sc_hd__tapvpwrvgnd_1
XFILLER_0_59_337 VGND VGND VPWR VPWR sky130_fd_sc_hd__decap_8
XFILLER_0_59_326 VGND VGND VPWR VPWR sky130_fd_sc_hd__decap_8
XFILLER_0_27_201 VGND VGND VPWR VPWR sky130_fd_sc_hd__fill_2
XFILLER_0_103_55 VGND VGND VPWR VPWR sky130_fd_sc_hd__fill_1
XFILLER_0_12_53 VPWR VGND VPWR VGND sky130_ef_sc_hd__decap_12
XFILLER_0_6_139 VGND VGND VPWR VPWR sky130_fd_sc_hd__fill_1
XFILLER_0_27_278 VGND VGND VPWR VPWR sky130_fd_sc_hd__fill_2
XFILLER_0_103_88 VGND VGND VPWR VPWR sky130_fd_sc_hd__fill_2
XFILLER_0_12_97 VPWR VGND VPWR VGND sky130_ef_sc_hd__decap_12
XFILLER_0_70_579 VGND VGND VPWR VPWR sky130_fd_sc_hd__fill_1
XFILLER_0_2_301 VGND VGND VPWR VPWR sky130_fd_sc_hd__decap_6
X_06000_ _04942_ _00664_ _04980_ mac_inst.i\[2\] VGND VGND VPWR VPWR _00954_ sky130_fd_sc_hd__and4bb_2
XFILLER_0_112_158 VPWR VGND VPWR VGND sky130_ef_sc_hd__decap_12
XTAP_TAPCELL_ROW_97_1470 VGND VPWR sky130_fd_sc_hd__tapvpwrvgnd_1
XFILLER_0_2_345 VPWR VGND VPWR VGND sky130_ef_sc_hd__decap_12
XFILLER_0_23_462 VGND VGND VPWR VPWR sky130_fd_sc_hd__decap_6
XFILLER_0_100_309 VPWR VGND VPWR VGND sky130_ef_sc_hd__decap_12
XFILLER_0_2_389 VPWR VGND VPWR VGND sky130_ef_sc_hd__decap_12
XFILLER_0_50_292 VPWR VGND VPWR VGND sky130_ef_sc_hd__decap_12
X_07951_ _02018_ _02747_ _02748_ VGND VGND VPWR VPWR _02749_ sky130_fd_sc_hd__and3_2
X_06902_ tanh_inst.div_en tanh_inst.divider.z_\[-16\] VGND VGND VPWR VPWR _00173_
+ sky130_fd_sc_hd__and2b_2
XFILLER_0_10_189 VGND VGND VPWR VPWR sky130_fd_sc_hd__decap_6
X_07882_ _02643_ _02645_ tanh_inst.z_\[7\] VGND VGND VPWR VPWR _02681_ sky130_fd_sc_hd__a21oi_2
XFILLER_0_37_50 VGND VGND VPWR VPWR sky130_fd_sc_hd__fill_1
X_06833_ _01692_ _01723_ _01722_ _01721_ _01715_ VGND VGND VPWR VPWR _01724_ sky130_fd_sc_hd__a2111oi_2
X_09621_ _03001_ _03002_ _04334_ VGND VGND VPWR VPWR _04348_ sky130_fd_sc_hd__and3_2
X_09552_ _04256_ _04259_ _04280_ VGND VGND VPWR VPWR _04281_ sky130_fd_sc_hd__nor3_2
X_06764_ _01660_ _01662_ VGND VGND VPWR VPWR _01663_ sky130_fd_sc_hd__nand2_2
X_05715_ _04977_ _00690_ VGND VGND VPWR VPWR _00691_ sky130_fd_sc_hd__or2_2
X_08503_ _03286_ VGND VGND VPWR VPWR _03287_ sky130_fd_sc_hd__inv_2
X_06695_ tanh_inst.z_\[-15\] _01599_ VGND VGND VPWR VPWR _01601_ sky130_fd_sc_hd__or2_2
XTAP_TAPCELL_ROW_54_939 VGND VPWR sky130_fd_sc_hd__tapvpwrvgnd_1
X_09483_ _01525_ _03939_ _03942_ _01477_ _04213_ VGND VGND VPWR VPWR _04214_ sky130_fd_sc_hd__o221a_2
XFILLER_0_93_627 VGND VGND VPWR VPWR sky130_fd_sc_hd__decap_8
XFILLER_0_92_115 VGND VGND VPWR VPWR sky130_fd_sc_hd__decap_3
XFILLER_0_77_167 VGND VGND VPWR VPWR sky130_fd_sc_hd__fill_1
X_08434_ _03062_ _03064_ _03219_ _03060_ VGND VGND VPWR VPWR _03220_ sky130_fd_sc_hd__o211ai_2
X_05646_ mac_inst.y\[27\] _00629_ VGND VGND VPWR VPWR _00630_ sky130_fd_sc_hd__nand2_2
XFILLER_0_92_137 VGND VGND VPWR VPWR sky130_fd_sc_hd__decap_3
X_08365_ _03151_ _03152_ VGND VGND VPWR VPWR _03153_ sky130_fd_sc_hd__and2_2
XTAP_TAPCELL_ROW_34_685 VGND VPWR sky130_fd_sc_hd__tapvpwrvgnd_1
X_05577_ _00530_ _00567_ _00566_ VGND VGND VPWR VPWR _00568_ sky130_fd_sc_hd__o21ba_2
XFILLER_0_46_521 VGND VGND VPWR VPWR sky130_fd_sc_hd__fill_1
X_07316_ tanh_inst.divider.x\[-24\] _02125_ _01470_ VGND VGND VPWR VPWR _02126_ sky130_fd_sc_hd__o21ai_2
XFILLER_0_18_245 VGND VGND VPWR VPWR sky130_fd_sc_hd__decap_6
XFILLER_0_46_587 VGND VGND VPWR VPWR sky130_fd_sc_hd__fill_1
XFILLER_0_61_513 VPWR VGND VPWR VGND sky130_ef_sc_hd__decap_12
XFILLER_0_18_289 VPWR VGND VPWR VGND sky130_ef_sc_hd__decap_12
X_08296_ tanh_inst.divider.x\[-3\] _03084_ VGND VGND VPWR VPWR _03085_ sky130_fd_sc_hd__and2_2
XFILLER_0_116_486 VGND VGND VPWR VPWR sky130_fd_sc_hd__decap_4
X_07247_ _02028_ _02056_ _02029_ VGND VGND VPWR VPWR _02057_ sky130_fd_sc_hd__o21ai_2
XFILLER_0_61_568 VGND VGND VPWR VPWR sky130_fd_sc_hd__decap_8
XFILLER_0_6_695 VGND VGND VPWR VPWR sky130_fd_sc_hd__decap_4
XFILLER_0_5_161 VGND VGND VPWR VPWR sky130_fd_sc_hd__decap_6
X_07178_ _01992_ _01995_ VGND VGND VPWR VPWR _01996_ sky130_fd_sc_hd__xnor2_2
XFILLER_0_103_169 VPWR VGND VPWR VGND sky130_ef_sc_hd__decap_12
X_06129_ tanh_inst.divider.x\[-21\] tanh_inst.divider.x\[-20\] tanh_inst.divider.i\[0\]
+ VGND VGND VPWR VPWR _01075_ sky130_fd_sc_hd__mux2_1
XFILLER_0_112_681 VGND VGND VPWR VPWR sky130_fd_sc_hd__fill_1
XTAP_TAPCELL_ROW_70_1131 VGND VPWR sky130_fd_sc_hd__tapvpwrvgnd_1
XTAP_TAPCELL_ROW_6_333 VGND VPWR sky130_fd_sc_hd__tapvpwrvgnd_1
XTAP_TAPCELL_ROW_70_1142 VGND VPWR sky130_fd_sc_hd__tapvpwrvgnd_1
XTAP_TAPCELL_ROW_109_1628 VGND VPWR sky130_fd_sc_hd__tapvpwrvgnd_1
X_09819_ _04534_ _04535_ _04537_ _04540_ VGND VGND VPWR VPWR _04541_ sky130_fd_sc_hd__a31o_2
XFILLER_0_96_421 VGND VGND VPWR VPWR sky130_fd_sc_hd__fill_2
XFILLER_0_69_613 VGND VGND VPWR VPWR sky130_fd_sc_hd__decap_3
XFILLER_0_56_307 VGND VGND VPWR VPWR sky130_fd_sc_hd__fill_1
XTAP_TAPCELL_ROW_81_1271 VGND VPWR sky130_fd_sc_hd__tapvpwrvgnd_1
XFILLER_0_64_340 VPWR VGND VPWR VGND sky130_ef_sc_hd__decap_12
XFILLER_0_52_513 VPWR VGND VPWR VGND sky130_ef_sc_hd__decap_12
X_10456_ clknet_leaf_1_clk _00313_ VGND VGND VPWR VPWR tanh_inst.divider.y\[-8\] sky130_fd_sc_hd__dfxtp_2
XFILLER_0_110_618 VGND VGND VPWR VPWR sky130_fd_sc_hd__fill_2
XFILLER_0_20_421 VGND VGND VPWR VPWR sky130_fd_sc_hd__decap_3
X_10387_ clknet_leaf_7_clk _00244_ VGND VGND VPWR VPWR tanh_inst.divider.x\[-13\]
+ sky130_fd_sc_hd__dfxtp_2
XFILLER_0_74_15 VGND VGND VPWR VPWR sky130_fd_sc_hd__decap_8
XFILLER_0_99_281 VGND VGND VPWR VPWR sky130_fd_sc_hd__decap_4
XFILLER_0_75_605 VGND VGND VPWR VPWR sky130_fd_sc_hd__decap_8
X_06480_ _01385_ _01386_ _04793_ VGND VGND VPWR VPWR _01402_ sky130_fd_sc_hd__o21a_2
XFILLER_0_90_47 VGND VGND VPWR VPWR sky130_fd_sc_hd__decap_6
X_05500_ _04836_ _00496_ _00495_ _05021_ VGND VGND VPWR VPWR _00497_ sky130_fd_sc_hd__o211a_2
XFILLER_0_114_65 VPWR VGND VPWR VGND sky130_ef_sc_hd__decap_12
XFILLER_0_74_148 VGND VGND VPWR VPWR sky130_fd_sc_hd__decap_3
X_05431_ mac_inst.y\[8\] _00433_ VGND VGND VPWR VPWR _00434_ sky130_fd_sc_hd__nand2_2
XFILLER_0_83_671 VGND VGND VPWR VPWR sky130_fd_sc_hd__fill_1
X_08150_ _02931_ _02932_ _02942_ _04791_ VGND VGND VPWR VPWR _02943_ sky130_fd_sc_hd__o22a_2
XFILLER_0_28_554 VPWR VGND VPWR VGND sky130_ef_sc_hd__decap_12
XTAP_TAPCELL_ROW_31_644 VGND VPWR sky130_fd_sc_hd__tapvpwrvgnd_1
X_07101_ tanh_inst.divider.z_\[-5\] _01924_ _01925_ VGND VGND VPWR VPWR _01928_ sky130_fd_sc_hd__nand3_2
XFILLER_0_55_384 VGND VGND VPWR VPWR sky130_fd_sc_hd__decap_8
XTAP_TAPCELL_ROW_31_655 VGND VPWR sky130_fd_sc_hd__tapvpwrvgnd_1
XFILLER_0_43_513 VGND VGND VPWR VPWR sky130_fd_sc_hd__decap_8
X_05362_ _00367_ _00369_ VGND VGND VPWR VPWR _05362_/Y sky130_fd_sc_hd__xnor2_2
X_08081_ _02838_ _02840_ _02873_ VGND VGND VPWR VPWR _02875_ sky130_fd_sc_hd__nor3_2
XFILLER_0_3_621 VGND VGND VPWR VPWR sky130_fd_sc_hd__fill_1
XFILLER_0_15_237 VPWR VGND VPWR VGND sky130_ef_sc_hd__decap_12
X_05293_ mac_inst.x\[31\] _04988_ _04991_ _04987_ _04782_ _04789_ VGND VGND VPWR VPWR
+ _04993_ sky130_fd_sc_hd__mux4_2
X_07032_ _01864_ _01866_ VGND VGND VPWR VPWR _01867_ sky130_fd_sc_hd__nand2_2
XFILLER_0_70_365 VPWR VGND VPWR VGND sky130_ef_sc_hd__decap_12
XFILLER_0_2_153 VPWR VGND VPWR VGND sky130_ef_sc_hd__decap_12
XFILLER_0_23_281 VPWR VGND VPWR VGND sky130_ef_sc_hd__decap_12
XFILLER_0_2_197 VPWR VGND VPWR VGND sky130_ef_sc_hd__decap_12
X_08983_ _03724_ _03725_ _02025_ VGND VGND VPWR VPWR _03726_ sky130_fd_sc_hd__mux2_1
X_07934_ tanh_inst.z_\[7\] _02708_ _02710_ _02730_ _02731_ VGND VGND VPWR VPWR _02732_
+ sky130_fd_sc_hd__a32o_2
X_07865_ _02662_ _02663_ VGND VGND VPWR VPWR _02664_ sky130_fd_sc_hd__xor2_2
XTAP_TAPCELL_ROW_3_303 VGND VPWR sky130_fd_sc_hd__tapvpwrvgnd_1
X_09604_ _04316_ _04331_ _02018_ VGND VGND VPWR VPWR _04332_ sky130_fd_sc_hd__a21oi_2
XFILLER_0_3_51 VGND VGND VPWR VPWR sky130_fd_sc_hd__decap_4
XTAP_TAPCELL_ROW_39_744 VGND VPWR sky130_fd_sc_hd__tapvpwrvgnd_1
X_07796_ _02542_ _02544_ _02541_ VGND VGND VPWR VPWR _02597_ sky130_fd_sc_hd__a21boi_2
XFILLER_0_78_421 VGND VGND VPWR VPWR sky130_fd_sc_hd__decap_6
X_06816_ tanh_inst.z_\[-3\] _01698_ _01708_ VGND VGND VPWR VPWR _01709_ sky130_fd_sc_hd__o21a_2
XTAP_TAPCELL_ROW_39_755 VGND VPWR sky130_fd_sc_hd__tapvpwrvgnd_1
X_09535_ _04255_ _04264_ VGND VGND VPWR VPWR _04265_ sky130_fd_sc_hd__xnor2_2
X_06747_ _01571_ _01646_ VGND VGND VPWR VPWR _01647_ sky130_fd_sc_hd__xnor2_2
XTAP_TAPCELL_ROW_104_1558 VGND VPWR sky130_fd_sc_hd__tapvpwrvgnd_1
X_06678_ _01565_ _01575_ _01577_ _01574_ VGND VGND VPWR VPWR _01586_ sky130_fd_sc_hd__a31o_2
X_09466_ tanh_inst.divider.y\[-9\] _04196_ VGND VGND VPWR VPWR _04197_ sky130_fd_sc_hd__and2_2
XFILLER_0_65_104 VGND VGND VPWR VPWR sky130_fd_sc_hd__decap_8
XFILLER_0_109_718 VGND VGND VPWR VPWR sky130_fd_sc_hd__decap_6
X_05629_ _00609_ _00613_ mac_inst.y\[25\] VGND VGND VPWR VPWR _00615_ sky130_fd_sc_hd__o21ba_2
X_08417_ tanh_inst.divider.y\[0\] _03202_ VGND VGND VPWR VPWR _03203_ sky130_fd_sc_hd__nor2_2
XFILLER_0_108_239 VGND VGND VPWR VPWR sky130_fd_sc_hd__decap_4
X_09397_ _02022_ _03831_ _03916_ VGND VGND VPWR VPWR _04130_ sky130_fd_sc_hd__o21a_2
XFILLER_0_80_107 VPWR VGND VPWR VGND sky130_ef_sc_hd__decap_12
XFILLER_0_46_340 VPWR VGND VPWR VGND sky130_ef_sc_hd__decap_12
X_08348_ _03056_ _03134_ _03096_ VGND VGND VPWR VPWR _03136_ sky130_fd_sc_hd__a21o_2
XTAP_TAPCELL_ROW_59_1004 VGND VPWR sky130_fd_sc_hd__tapvpwrvgnd_1
X_08279_ _02822_ _02913_ _03018_ _03019_ VGND VGND VPWR VPWR _03069_ sky130_fd_sc_hd__nand4_2
X_10310_ clknet_leaf_16_clk _00167_ VGND VGND VPWR VPWR tanh_out[2] sky130_fd_sc_hd__dfxtp_2
XFILLER_0_104_434 VGND VGND VPWR VPWR sky130_fd_sc_hd__decap_4
XFILLER_0_34_579 VGND VGND VPWR VPWR sky130_fd_sc_hd__decap_4
XFILLER_0_104_467 VGND VGND VPWR VPWR sky130_fd_sc_hd__decap_8
X_10241_ clknet_leaf_31_clk mac_inst.x\[3\] _00000_ VGND VGND VPWR VPWR mac_x_out[3]
+ sky130_fd_sc_hd__dfrtp_2
XTAP_TAPCELL_ROW_115_1698 VGND VPWR sky130_fd_sc_hd__tapvpwrvgnd_1
XFILLER_0_88_218 VPWR VGND VPWR VGND sky130_ef_sc_hd__decap_12
XFILLER_0_69_421 VGND VGND VPWR VPWR sky130_fd_sc_hd__decap_8
XFILLER_0_44_29 VGND VGND VPWR VPWR sky130_fd_sc_hd__decap_3
XTAP_TAPCELL_ROW_83_1300 VGND VPWR sky130_fd_sc_hd__tapvpwrvgnd_1
XFILLER_0_56_159 VPWR VGND VPWR VGND sky130_ef_sc_hd__decap_12
XFILLER_0_65_671 VGND VGND VPWR VPWR sky130_fd_sc_hd__fill_1
XFILLER_0_4_407 VGND VGND VPWR VPWR sky130_fd_sc_hd__decap_6
XFILLER_0_8_29 VPWR VGND VPWR VGND sky130_ef_sc_hd__decap_12
XFILLER_0_13_719 VGND VGND VPWR VPWR sky130_fd_sc_hd__decap_4
XFILLER_0_52_365 VPWR VGND VPWR VGND sky130_ef_sc_hd__decap_12
XFILLER_0_110_404 VGND VGND VPWR VPWR sky130_fd_sc_hd__fill_2
XTAP_TAPCELL_ROW_94_1440 VGND VPWR sky130_fd_sc_hd__tapvpwrvgnd_1
XFILLER_0_0_613 VGND VGND VPWR VPWR sky130_fd_sc_hd__decap_3
XFILLER_0_20_251 VGND VGND VPWR VPWR sky130_fd_sc_hd__fill_1
X_10439_ clknet_leaf_35_clk _00296_ _00000_ VGND VGND VPWR VPWR mac_inst.i\[31\] sky130_fd_sc_hd__dfrtp_2
X_05980_ _00934_ _00935_ VGND VGND VPWR VPWR _05980_/X sky130_fd_sc_hd__xor2_2
XFILLER_0_18_41 VPWR VGND VPWR VGND sky130_ef_sc_hd__decap_12
XFILLER_0_18_85 VPWR VGND VPWR VGND sky130_ef_sc_hd__decap_12
X_07650_ tanh_inst.divider.y\[-18\] tanh_inst.divider.x\[-18\] VGND VGND VPWR VPWR
+ _02454_ sky130_fd_sc_hd__and2_2
X_07581_ _02024_ _02147_ _02148_ VGND VGND VPWR VPWR _02386_ sky130_fd_sc_hd__or3_2
X_06601_ _04759_ _01513_ VGND VGND VPWR VPWR _01514_ sky130_fd_sc_hd__nor2_2
XTAP_TAPCELL_ROW_36_714 VGND VPWR sky130_fd_sc_hd__tapvpwrvgnd_1
X_06532_ _01448_ _01449_ _01088_ VGND VGND VPWR VPWR _01450_ sky130_fd_sc_hd__o21ai_2
X_09320_ _02018_ _04054_ _04055_ VGND VGND VPWR VPWR _04056_ sky130_fd_sc_hd__and3_2
X_09251_ tanh_inst.divider.y\[-16\] _02014_ _03988_ _01470_ VGND VGND VPWR VPWR _00305_
+ sky130_fd_sc_hd__o211a_2
XTAP_TAPCELL_ROW_16_460 VGND VPWR sky130_fd_sc_hd__tapvpwrvgnd_1
X_06463_ _01357_ _01358_ _01367_ _01378_ VGND VGND VPWR VPWR _01386_ sky130_fd_sc_hd__or4_2
XFILLER_0_90_405 VPWR VGND VPWR VGND sky130_ef_sc_hd__decap_12
XFILLER_0_7_223 VGND VGND VPWR VPWR sky130_fd_sc_hd__fill_1
X_08202_ _02920_ _02993_ _02948_ VGND VGND VPWR VPWR _02994_ sky130_fd_sc_hd__a21o_2
X_06394_ _01320_ _01322_ VGND VGND VPWR VPWR _01323_ sky130_fd_sc_hd__xnor2_2
X_09182_ _04767_ _03919_ VGND VGND VPWR VPWR _03921_ sky130_fd_sc_hd__xnor2_2
X_05414_ mac_inst.i\[3\] _00416_ _00417_ _04912_ VGND VGND VPWR VPWR _00418_ sky130_fd_sc_hd__a211o_2
XFILLER_0_28_362 VGND VGND VPWR VPWR sky130_fd_sc_hd__fill_2
XFILLER_0_71_641 VPWR VGND VPWR VGND sky130_ef_sc_hd__decap_12
X_08133_ tanh_inst.divider.y\[-7\] tanh_inst.divider.x\[-7\] VGND VGND VPWR VPWR _02926_
+ sky130_fd_sc_hd__nand2_2
XFILLER_0_16_568 VGND VGND VPWR VPWR sky130_fd_sc_hd__fill_1
X_05345_ mac_inst.x\[31\] _00348_ _00351_ _00347_ _04781_ _04782_ VGND VGND VPWR VPWR
+ _00353_ sky130_fd_sc_hd__mux4_2
XFILLER_0_43_332 VGND VGND VPWR VPWR sky130_fd_sc_hd__decap_4
XFILLER_0_113_231 VGND VGND VPWR VPWR sky130_fd_sc_hd__decap_4
XFILLER_0_71_685 VGND VGND VPWR VPWR sky130_fd_sc_hd__decap_3
X_08064_ tanh_inst.LOOKUP.index\[4\] _04762_ VGND VGND VPWR VPWR _02859_ sky130_fd_sc_hd__nand2_2
X_07015_ _01839_ _01844_ _01848_ _01849_ VGND VGND VPWR VPWR _01852_ sky130_fd_sc_hd__nor4_2
X_05276_ _04955_ _04975_ VGND VGND VPWR VPWR _04977_ sky130_fd_sc_hd__or2_2
XFILLER_0_31_538 VGND VGND VPWR VPWR sky130_fd_sc_hd__decap_8
XFILLER_0_11_273 VGND VGND VPWR VPWR sky130_fd_sc_hd__decap_6
X_08966_ tanh_inst.divider.x\[-10\] tanh_inst.divider.x\[-9\] tanh_inst.divider.x\[-8\]
+ tanh_inst.divider.x\[-7\] tanh_inst.LOOKUP.index\[0\] tanh_inst.LOOKUP.index\[1\]
+ VGND VGND VPWR VPWR _03710_ sky130_fd_sc_hd__mux4_2
X_07917_ _02581_ _02628_ _02714_ tanh_inst.divider.x\[-13\] tanh_inst.divider.y\[-13\]
+ VGND VGND VPWR VPWR _02715_ sky130_fd_sc_hd__a32o_2
XFILLER_0_75_80 VPWR VGND VPWR VGND sky130_ef_sc_hd__decap_12
X_08897_ tanh_inst.divider.x\[-11\] tanh_inst.divider.x\[-10\] tanh_inst.divider.x\[-9\]
+ tanh_inst.divider.x\[-8\] tanh_inst.LOOKUP.index\[0\] tanh_inst.LOOKUP.index\[1\]
+ VGND VGND VPWR VPWR _03642_ sky130_fd_sc_hd__mux4_2
X_07848_ tanh_inst.divider.x\[-14\] _02647_ VGND VGND VPWR VPWR _02648_ sky130_fd_sc_hd__nand2_2
X_07779_ tanh_inst.divider.y\[-15\] tanh_inst.divider.x\[-15\] VGND VGND VPWR VPWR
+ _02580_ sky130_fd_sc_hd__nand2_2
X_09518_ _04239_ _04242_ _04246_ tanh_inst.z_\[7\] VGND VGND VPWR VPWR _04248_ sky130_fd_sc_hd__a31oi_2
XTAP_TAPCELL_ROW_65_1074 VGND VPWR sky130_fd_sc_hd__tapvpwrvgnd_1
XFILLER_0_39_649 VGND VGND VPWR VPWR sky130_fd_sc_hd__decap_4
X_09449_ _04103_ _04137_ _04138_ VGND VGND VPWR VPWR _04181_ sky130_fd_sc_hd__o21a_2
XFILLER_0_109_537 VGND VGND VPWR VPWR sky130_fd_sc_hd__fill_2
XTAP_TAPCELL_ROW_117_1727 VGND VPWR sky130_fd_sc_hd__tapvpwrvgnd_1
XFILLER_0_61_162 VGND VGND VPWR VPWR sky130_fd_sc_hd__decap_6
XFILLER_0_34_365 VGND VGND VPWR VPWR sky130_fd_sc_hd__fill_1
XFILLER_0_61_184 VGND VGND VPWR VPWR sky130_fd_sc_hd__decap_8
XFILLER_0_34_387 VGND VGND VPWR VPWR sky130_fd_sc_hd__fill_2
X_10224_ clknet_leaf_27_clk mac_inst.y\[18\] _00000_ VGND VGND VPWR VPWR mac_y_out[18]
+ sky130_fd_sc_hd__dfrtp_2
X_10086_ clknet_leaf_4_clk _00103_ VGND VGND VPWR VPWR tanh_inst.divider.y_\[-7\]
+ sky130_fd_sc_hd__dfxtp_2
XFILLER_0_55_39 VGND VGND VPWR VPWR sky130_fd_sc_hd__fill_1
XFILLER_0_71_27 VGND VGND VPWR VPWR sky130_fd_sc_hd__fill_1
XFILLER_0_84_221 VGND VGND VPWR VPWR sky130_fd_sc_hd__decap_8
XFILLER_0_84_265 VPWR VGND VPWR VGND sky130_ef_sc_hd__decap_12
XFILLER_0_57_479 VGND VGND VPWR VPWR sky130_fd_sc_hd__decap_8
XTAP_TAPCELL_ROW_13_430 VGND VPWR sky130_fd_sc_hd__tapvpwrvgnd_1
XFILLER_0_115_518 VGND VGND VPWR VPWR sky130_fd_sc_hd__fill_2
XTAP_TAPCELL_ROW_41_772 VGND VPWR sky130_fd_sc_hd__tapvpwrvgnd_1
XFILLER_0_111_55 VGND VGND VPWR VPWR sky130_fd_sc_hd__fill_1
XFILLER_0_105_3 VPWR VGND VPWR VGND sky130_ef_sc_hd__decap_12
Xclkbuf_leaf_10_clk clknet_2_2__leaf_clk VGND VGND VPWR VPWR clknet_leaf_10_clk sky130_fd_sc_hd__clkbuf_8
X_05130_ mac_counter\[0\] _04818_ _04832_ VGND VGND VPWR VPWR _00118_ sky130_fd_sc_hd__o21ba_2
XFILLER_0_52_162 VPWR VGND VPWR VGND sky130_ef_sc_hd__decap_12
XFILLER_0_20_53 VPWR VGND VPWR VGND sky130_ef_sc_hd__decap_12
XFILLER_0_20_97 VPWR VGND VPWR VGND sky130_ef_sc_hd__decap_12
X_05061_ mac_inst.i\[20\] VGND VGND VPWR VPWR _04785_ sky130_fd_sc_hd__inv_2
X_08820_ _03558_ _03562_ _03564_ _03560_ _04760_ tanh_inst.LOOKUP.index\[0\] VGND
+ VGND VPWR VPWR _03566_ sky130_fd_sc_hd__mux4_2
XFILLER_0_29_51 VGND VGND VPWR VPWR sky130_fd_sc_hd__decap_4
X_05963_ mac_inst.i\[2\] _00676_ _00717_ _00847_ VGND VGND VPWR VPWR _00920_ sky130_fd_sc_hd__or4_2
X_08751_ mac_inst.i\[25\] _00967_ VGND VGND VPWR VPWR _03504_ sky130_fd_sc_hd__nor2_2
X_07702_ _02491_ _02504_ VGND VGND VPWR VPWR _02505_ sky130_fd_sc_hd__or2_2
X_08682_ _03459_ _03460_ VGND VGND VPWR VPWR _03462_ sky130_fd_sc_hd__xnor2_2
X_05894_ _00830_ _00844_ VGND VGND VPWR VPWR _00857_ sky130_fd_sc_hd__nand2_2
X_07633_ _02023_ _02433_ _02435_ _02436_ VGND VGND VPWR VPWR _02437_ sky130_fd_sc_hd__a2bb2o_2
XTAP_TAPCELL_ROW_49_872 VGND VPWR sky130_fd_sc_hd__tapvpwrvgnd_1
XFILLER_0_0_41 VPWR VGND VPWR VGND sky130_ef_sc_hd__decap_12
X_07564_ tanh_inst.LOOKUP.index\[4\] _02369_ VGND VGND VPWR VPWR _02370_ sky130_fd_sc_hd__nand2_2
X_06515_ _01413_ _01425_ VGND VGND VPWR VPWR _01434_ sky130_fd_sc_hd__nor2_2
X_09303_ _03969_ _03973_ _03991_ _03992_ VGND VGND VPWR VPWR _04039_ sky130_fd_sc_hd__o31a_2
XTAP_TAPCELL_ROW_101_1528 VGND VPWR sky130_fd_sc_hd__tapvpwrvgnd_1
X_07495_ _02235_ _02236_ _02233_ VGND VGND VPWR VPWR _02302_ sky130_fd_sc_hd__o21a_2
XFILLER_0_63_405 VGND VGND VPWR VPWR sky130_fd_sc_hd__decap_8
XFILLER_0_0_85 VPWR VGND VPWR VGND sky130_ef_sc_hd__decap_12
XFILLER_0_48_468 VGND VGND VPWR VPWR sky130_fd_sc_hd__decap_8
X_06446_ tanh_inst.divider.y_\[-2\] _01369_ VGND VGND VPWR VPWR _01371_ sky130_fd_sc_hd__and2b_2
X_09234_ _03887_ _03891_ _03933_ _03931_ VGND VGND VPWR VPWR _03972_ sky130_fd_sc_hd__a31o_2
XPHY_EDGE_ROW_3_Right_3 VGND VGND VPWR VPWR sky130_fd_sc_hd__decap_3
XFILLER_0_35_107 VGND VGND VPWR VPWR sky130_fd_sc_hd__decap_4
X_09165_ _03903_ _03904_ VGND VGND VPWR VPWR _03905_ sky130_fd_sc_hd__nand2_2
XFILLER_0_63_449 VPWR VGND VPWR VGND sky130_ef_sc_hd__decap_12
XFILLER_0_16_321 VPWR VGND VPWR VGND sky130_ef_sc_hd__decap_12
XFILLER_0_44_641 VGND VGND VPWR VPWR sky130_fd_sc_hd__decap_3
X_06377_ _01305_ _01306_ VGND VGND VPWR VPWR _01308_ sky130_fd_sc_hd__nand2_2
X_08116_ _02779_ _02825_ _02827_ _02863_ _02909_ VGND VGND VPWR VPWR _02910_ sky130_fd_sc_hd__o41a_2
XFILLER_0_16_365 VGND VGND VPWR VPWR sky130_fd_sc_hd__decap_4
XFILLER_0_44_663 VPWR VGND VPWR VGND sky130_ef_sc_hd__decap_12
X_09096_ _03835_ _03836_ VGND VGND VPWR VPWR _03837_ sky130_fd_sc_hd__nand2b_2
X_05328_ _04885_ _04887_ _04920_ _04918_ _04783_ _04789_ VGND VGND VPWR VPWR _05027_
+ sky130_fd_sc_hd__mux4_2
X_08047_ _02840_ _02841_ VGND VGND VPWR VPWR _02842_ sky130_fd_sc_hd__nor2_2
XFILLER_0_3_281 VPWR VGND VPWR VGND sky130_ef_sc_hd__decap_12
X_05259_ mac_inst.i\[27\] mac_inst.i\[29\] VGND VGND VPWR VPWR _04960_ sky130_fd_sc_hd__nand2_2
XTAP_TAPCELL_ROW_112_1668 VGND VPWR sky130_fd_sc_hd__tapvpwrvgnd_1
XTAP_TAPCELL_ROW_112_1657 VGND VPWR sky130_fd_sc_hd__tapvpwrvgnd_1
X_09998_ _03450_ _04713_ VGND VGND VPWR VPWR _04714_ sky130_fd_sc_hd__or2_2
X_08949_ _02238_ _03684_ VGND VGND VPWR VPWR _03693_ sky130_fd_sc_hd__nor2_2
XTAP_TAPCELL_ROW_67_1103 VGND VPWR sky130_fd_sc_hd__tapvpwrvgnd_1
XFILLER_0_67_700 VPWR VGND VPWR VGND sky130_ef_sc_hd__decap_12
XFILLER_0_39_424 VPWR VGND VPWR VGND sky130_ef_sc_hd__decap_12
XTAP_TAPCELL_ROW_27_599 VGND VPWR sky130_fd_sc_hd__tapvpwrvgnd_1
XFILLER_0_26_118 VGND VGND VPWR VPWR sky130_fd_sc_hd__fill_1
XFILLER_0_19_181 VPWR VGND VPWR VGND sky130_ef_sc_hd__decap_12
XFILLER_0_47_490 VPWR VGND VPWR VGND sky130_ef_sc_hd__decap_12
XFILLER_0_81_279 VGND VGND VPWR VPWR sky130_fd_sc_hd__fill_1
XTAP_TAPCELL_ROW_78_1243 VGND VPWR sky130_fd_sc_hd__tapvpwrvgnd_1
XTAP_TAPCELL_ROW_78_1232 VGND VPWR sky130_fd_sc_hd__tapvpwrvgnd_1
XFILLER_0_34_173 VGND VGND VPWR VPWR sky130_fd_sc_hd__decap_4
X_10207_ clknet_leaf_28_clk mac_inst.y\[1\] _00000_ VGND VGND VPWR VPWR mac_y_out[1]
+ sky130_fd_sc_hd__dfrtp_2
X_10069_ clknet_leaf_19_clk _00086_ VGND VGND VPWR VPWR tanh_inst.divider.y_\[-24\]
+ sky130_fd_sc_hd__dfxtp_2
XFILLER_0_89_335 VGND VGND VPWR VPWR sky130_fd_sc_hd__fill_1
XTAP_TAPCELL_ROW_89_1372 VGND VPWR sky130_fd_sc_hd__tapvpwrvgnd_1
XTAP_TAPCELL_ROW_46_831 VGND VPWR sky130_fd_sc_hd__tapvpwrvgnd_1
XTAP_TAPCELL_ROW_46_842 VGND VPWR sky130_fd_sc_hd__tapvpwrvgnd_1
XFILLER_0_106_77 VGND VGND VPWR VPWR sky130_fd_sc_hd__decap_6
XFILLER_0_57_254 VGND VGND VPWR VPWR sky130_fd_sc_hd__decap_6
XFILLER_0_9_329 VGND VGND VPWR VPWR sky130_fd_sc_hd__decap_6
X_06300_ _01233_ _01235_ _01236_ VGND VGND VPWR VPWR _01237_ sky130_fd_sc_hd__a21oi_2
X_07280_ tanh_inst.divider.y\[-6\] _02028_ _02029_ VGND VGND VPWR VPWR _02090_ sky130_fd_sc_hd__o21a_2
XFILLER_0_45_405 VPWR VGND VPWR VGND sky130_ef_sc_hd__decap_12
X_06231_ tanh_inst.divider.y\[-19\] tanh_inst.div_en tanh_inst.divider.y_\[-19\] _01092_
+ _01172_ VGND VGND VPWR VPWR _00091_ sky130_fd_sc_hd__a221o_2
XFILLER_0_115_337 VGND VGND VPWR VPWR sky130_fd_sc_hd__fill_1
XFILLER_0_25_151 VPWR VGND VPWR VGND sky130_ef_sc_hd__decap_12
X_06162_ _04776_ _01099_ _01106_ VGND VGND VPWR VPWR _01107_ sky130_fd_sc_hd__o21ai_2
XFILLER_0_13_335 VGND VGND VPWR VPWR sky130_fd_sc_hd__fill_1
XFILLER_0_25_184 VGND VGND VPWR VPWR sky130_fd_sc_hd__fill_2
XFILLER_0_53_482 VGND VGND VPWR VPWR sky130_fd_sc_hd__decap_4
X_06093_ tanh_inst.divider.x\[-16\] tanh_inst.divider.x\[-15\] tanh_inst.divider.x\[-14\]
+ tanh_inst.divider.x\[-13\] tanh_inst.divider.i\[0\] tanh_inst.divider.i\[1\] VGND
+ VGND VPWR VPWR _01040_ sky130_fd_sc_hd__mux4_2
X_05113_ mac_counter\[4\] mac_counter\[3\] _04822_ VGND VGND VPWR VPWR _04825_ sky130_fd_sc_hd__and3_2
XFILLER_0_40_121 VGND VGND VPWR VPWR sky130_fd_sc_hd__fill_2
X_05044_ tanh_inst.divider.y\[-23\] VGND VGND VPWR VPWR _04768_ sky130_fd_sc_hd__inv_2
X_09921_ _04791_ _04631_ VGND VGND VPWR VPWR _04639_ sky130_fd_sc_hd__and2_2
X_09852_ tanh_inst.divider.y\[1\] _02014_ _04564_ _04572_ _01470_ VGND VGND VPWR VPWR
+ _00322_ sky130_fd_sc_hd__o221a_2
X_08803_ _03543_ _03548_ _02025_ VGND VGND VPWR VPWR _03549_ sky130_fd_sc_hd__mux2_1
XPHY_EDGE_ROW_0_Left_122 VGND VGND VPWR VPWR sky130_fd_sc_hd__decap_3
X_09783_ _04496_ _04439_ VGND VGND VPWR VPWR _04505_ sky130_fd_sc_hd__nand2b_2
XPHY_EDGE_ROW_37_Left_159 VGND VGND VPWR VPWR sky130_fd_sc_hd__decap_3
X_06995_ _01829_ _01832_ tanh_inst.divider.z_\[-17\] VGND VGND VPWR VPWR _01834_ sky130_fd_sc_hd__a21o_2
XFILLER_0_56_71 VGND VGND VPWR VPWR sky130_fd_sc_hd__fill_1
X_08734_ mac_inst.i\[16\] _03495_ VGND VGND VPWR VPWR _00281_ sky130_fd_sc_hd__xor2_2
X_05946_ _00885_ _00904_ VGND VGND VPWR VPWR _00905_ sky130_fd_sc_hd__nand2_2
X_08665_ _02052_ _02785_ _02833_ VGND VGND VPWR VPWR _03445_ sky130_fd_sc_hd__a21oi_2
XFILLER_0_68_519 VPWR VGND VPWR VGND sky130_ef_sc_hd__decap_12
X_05877_ _00799_ _00840_ mac_inst.z\[31\] VGND VGND VPWR VPWR _00841_ sky130_fd_sc_hd__a21o_2
X_07616_ _02178_ _02190_ _04759_ VGND VGND VPWR VPWR _02421_ sky130_fd_sc_hd__mux2_1
XFILLER_0_49_722 VGND VGND VPWR VPWR sky130_fd_sc_hd__fill_2
X_08596_ _03326_ _03342_ _03377_ VGND VGND VPWR VPWR _03378_ sky130_fd_sc_hd__a21oi_2
X_07547_ _02337_ _02352_ tanh_inst.z_\[7\] VGND VGND VPWR VPWR _02353_ sky130_fd_sc_hd__o21ai_2
XFILLER_0_76_530 VGND VGND VPWR VPWR sky130_fd_sc_hd__fill_2
XFILLER_0_91_500 VGND VGND VPWR VPWR sky130_fd_sc_hd__decap_4
XTAP_TAPCELL_ROW_62_1033 VGND VPWR sky130_fd_sc_hd__tapvpwrvgnd_1
XTAP_TAPCELL_ROW_24_558 VGND VPWR sky130_fd_sc_hd__tapvpwrvgnd_1
XFILLER_0_118_153 VPWR VGND VPWR VGND sky130_ef_sc_hd__decap_12
X_07478_ _02282_ _02284_ _02025_ VGND VGND VPWR VPWR _02285_ sky130_fd_sc_hd__mux2_1
XPHY_EDGE_ROW_46_Left_168 VGND VGND VPWR VPWR sky130_fd_sc_hd__decap_3
X_06429_ _01089_ _01355_ VGND VGND VPWR VPWR _01356_ sky130_fd_sc_hd__nor2_2
X_09217_ tanh_inst.divider.x\[7\] _03549_ _03567_ _03522_ _02023_ _02052_ VGND VGND
+ VPWR VPWR _03955_ sky130_fd_sc_hd__mux4_2
XFILLER_0_91_566 VGND VGND VPWR VPWR sky130_fd_sc_hd__decap_8
XFILLER_0_63_279 VGND VGND VPWR VPWR sky130_fd_sc_hd__fill_1
XFILLER_0_51_408 VGND VGND VPWR VPWR sky130_fd_sc_hd__fill_1
X_09148_ _02459_ _03876_ VGND VGND VPWR VPWR _03888_ sky130_fd_sc_hd__nand2_2
X_09079_ _03820_ VGND VGND VPWR VPWR _03821_ sky130_fd_sc_hd__inv_2
XFILLER_0_16_195 VGND VGND VPWR VPWR sky130_fd_sc_hd__fill_1
XFILLER_0_31_121 VGND VGND VPWR VPWR sky130_fd_sc_hd__decap_8
XFILLER_0_31_165 VGND VGND VPWR VPWR sky130_fd_sc_hd__decap_3
XTAP_TAPCELL_ROW_73_1173 VGND VPWR sky130_fd_sc_hd__tapvpwrvgnd_1
XPHY_EDGE_ROW_55_Left_177 VGND VGND VPWR VPWR sky130_fd_sc_hd__decap_3
XTAP_TAPCELL_ROW_43_801 VGND VPWR sky130_fd_sc_hd__tapvpwrvgnd_1
XFILLER_0_67_585 VGND VGND VPWR VPWR sky130_fd_sc_hd__fill_1
XPHY_EDGE_ROW_64_Left_186 VGND VGND VPWR VPWR sky130_fd_sc_hd__decap_3
XFILLER_0_27_427 VGND VGND VPWR VPWR sky130_fd_sc_hd__fill_2
XFILLER_0_94_382 VGND VGND VPWR VPWR sky130_fd_sc_hd__decap_4
XFILLER_0_82_533 VGND VGND VPWR VPWR sky130_fd_sc_hd__fill_1
XFILLER_0_54_213 VGND VGND VPWR VPWR sky130_fd_sc_hd__fill_1
XFILLER_0_109_197 VPWR VGND VPWR VGND sky130_ef_sc_hd__decap_12
XFILLER_0_70_706 VGND VGND VPWR VPWR sky130_fd_sc_hd__fill_1
XFILLER_0_54_257 VGND VGND VPWR VPWR sky130_fd_sc_hd__fill_1
XFILLER_0_112_318 VGND VGND VPWR VPWR sky130_fd_sc_hd__fill_1
XFILLER_0_2_516 VGND VGND VPWR VPWR sky130_fd_sc_hd__fill_2
XFILLER_0_22_121 VPWR VGND VPWR VGND sky130_ef_sc_hd__decap_12
XFILLER_0_23_655 VGND VGND VPWR VPWR sky130_fd_sc_hd__fill_2
XFILLER_0_50_452 VGND VGND VPWR VPWR sky130_fd_sc_hd__decap_8
XFILLER_0_22_165 VPWR VGND VPWR VGND sky130_ef_sc_hd__decap_12
XFILLER_0_120_373 VGND VGND VPWR VPWR sky130_fd_sc_hd__fill_2
XPHY_EDGE_ROW_73_Left_195 VGND VGND VPWR VPWR sky130_fd_sc_hd__decap_3
XFILLER_0_93_47 VGND VGND VPWR VPWR sky130_fd_sc_hd__fill_1
X_05800_ _00755_ _00756_ _00753_ VGND VGND VPWR VPWR _00770_ sky130_fd_sc_hd__o21ai_2
X_06780_ tanh_inst.z_\[-7\] _01668_ _01658_ VGND VGND VPWR VPWR _01677_ sky130_fd_sc_hd__a21bo_2
XFILLER_0_26_41 VPWR VGND VPWR VGND sky130_ef_sc_hd__decap_12
X_05731_ _04781_ mac_inst.i\[2\] _04932_ _04976_ VGND VGND VPWR VPWR _00706_ sky130_fd_sc_hd__and4_2
XFILLER_0_26_85 VGND VGND VPWR VPWR sky130_fd_sc_hd__decap_8
X_08450_ _03193_ _03194_ _03124_ VGND VGND VPWR VPWR _03236_ sky130_fd_sc_hd__nand3b_2
X_05662_ _00634_ _00635_ mac_inst.z\[31\] VGND VGND VPWR VPWR _00644_ sky130_fd_sc_hd__a21o_2
X_07401_ _02026_ _02055_ VGND VGND VPWR VPWR _02209_ sky130_fd_sc_hd__nor2_2
X_08381_ _03130_ _03137_ _03167_ VGND VGND VPWR VPWR _03168_ sky130_fd_sc_hd__nand3_2
X_07332_ _02042_ _02044_ _04761_ VGND VGND VPWR VPWR _02141_ sky130_fd_sc_hd__mux2_1
XFILLER_0_73_500 VGND VGND VPWR VPWR sky130_fd_sc_hd__decap_4
XFILLER_0_9_137 VPWR VGND VPWR VGND sky130_ef_sc_hd__decap_12
XFILLER_0_18_405 VGND VGND VPWR VPWR sky130_fd_sc_hd__fill_2
X_05593_ mac_inst.y\[21\] _00572_ _00581_ VGND VGND VPWR VPWR _00582_ sky130_fd_sc_hd__a21oi_2
XFILLER_0_42_51 VGND VGND VPWR VPWR sky130_fd_sc_hd__decap_6
XTAP_TAPCELL_ROW_21_528 VGND VPWR sky130_fd_sc_hd__tapvpwrvgnd_1
X_07263_ tanh_inst.divider.y\[1\] _02028_ _02029_ VGND VGND VPWR VPWR _02073_ sky130_fd_sc_hd__o21a_2
X_07194_ tanh_inst.divider.z_\[7\] _01975_ VGND VGND VPWR VPWR _02009_ sky130_fd_sc_hd__xor2_2
X_06214_ _01088_ _01154_ _01155_ _01156_ VGND VGND VPWR VPWR _00090_ sky130_fd_sc_hd__a31o_2
X_09002_ _03742_ _03744_ VGND VGND VPWR VPWR _03745_ sky130_fd_sc_hd__and2_2
XFILLER_0_14_633 VGND VGND VPWR VPWR sky130_fd_sc_hd__decap_8
X_06145_ _01063_ _01087_ _01090_ VGND VGND VPWR VPWR _01091_ sky130_fd_sc_hd__o21a_2
XFILLER_0_77_3 VGND VGND VPWR VPWR sky130_fd_sc_hd__decap_6
XFILLER_0_14_699 VGND VGND VPWR VPWR sky130_fd_sc_hd__fill_1
X_06076_ tanh_inst.divider.x\[6\] tanh_inst.divider.x\[7\] tanh_inst.divider.i\[0\]
+ VGND VGND VPWR VPWR _01023_ sky130_fd_sc_hd__mux2_1
XFILLER_0_111_384 VGND VGND VPWR VPWR sky130_fd_sc_hd__decap_8
X_09904_ _04592_ _04595_ _04620_ VGND VGND VPWR VPWR _04623_ sky130_fd_sc_hd__nor3_2
XFILLER_0_67_70 VGND VGND VPWR VPWR sky130_fd_sc_hd__fill_1
X_09835_ tanh_inst.divider.x\[1\] _04554_ VGND VGND VPWR VPWR _04556_ sky130_fd_sc_hd__and2_2
X_06978_ tanh_inst.divider.i\[2\] _04778_ tanh_inst.divider.i\[0\] VGND VGND VPWR
+ VPWR _01818_ sky130_fd_sc_hd__or3_2
X_09766_ _04486_ _04488_ VGND VGND VPWR VPWR _04489_ sky130_fd_sc_hd__nor2_2
XTAP_TAPCELL_ROW_29_628 VGND VPWR sky130_fd_sc_hd__tapvpwrvgnd_1
X_05929_ _04923_ _00691_ _00847_ VGND VGND VPWR VPWR _00889_ sky130_fd_sc_hd__or3_2
X_08717_ mac_inst.i\[5\] _00955_ VGND VGND VPWR VPWR _03490_ sky130_fd_sc_hd__or2_2
X_09697_ _04379_ _04386_ VGND VGND VPWR VPWR _04422_ sky130_fd_sc_hd__nand2_2
XFILLER_0_95_113 VPWR VGND VPWR VGND sky130_ef_sc_hd__decap_12
X_08648_ _03427_ _03428_ VGND VGND VPWR VPWR _03429_ sky130_fd_sc_hd__xnor2_2
XTAP_TAPCELL_ROW_1_275 VGND VPWR sky130_fd_sc_hd__tapvpwrvgnd_1
X_08579_ tanh_inst.divider.y\[4\] _03360_ VGND VGND VPWR VPWR _03361_ sky130_fd_sc_hd__nor2_2
XFILLER_0_36_202 VGND VGND VPWR VPWR sky130_fd_sc_hd__fill_1
XTAP_TAPCELL_ROW_120_1767 VGND VPWR sky130_fd_sc_hd__tapvpwrvgnd_1
XTAP_TAPCELL_ROW_120_1756 VGND VPWR sky130_fd_sc_hd__tapvpwrvgnd_1
XFILLER_0_64_533 VPWR VGND VPWR VGND sky130_ef_sc_hd__decap_12
XFILLER_0_9_671 VGND VGND VPWR VPWR sky130_fd_sc_hd__fill_1
XFILLER_0_9_682 VGND VGND VPWR VPWR sky130_fd_sc_hd__fill_2
XFILLER_0_36_268 VGND VGND VPWR VPWR sky130_fd_sc_hd__fill_1
XFILLER_0_51_238 VGND VGND VPWR VPWR sky130_fd_sc_hd__decap_8
X_10472_ clknet_leaf_25_clk _00329_ VGND VGND VPWR VPWR tanh_inst.LOOKUP.index\[0\]
+ sky130_fd_sc_hd__dfxtp_2
XTAP_TAPCELL_ROW_75_1202 VGND VPWR sky130_fd_sc_hd__tapvpwrvgnd_1
XFILLER_0_121_137 VGND VGND VPWR VPWR sky130_fd_sc_hd__decap_3
XFILLER_0_32_474 VGND VGND VPWR VPWR sky130_fd_sc_hd__fill_2
XFILLER_0_102_351 VGND VGND VPWR VPWR sky130_fd_sc_hd__decap_4
XFILLER_0_102_373 VGND VGND VPWR VPWR sky130_fd_sc_hd__fill_2
XTAP_TAPCELL_ROW_9_375 VGND VPWR sky130_fd_sc_hd__tapvpwrvgnd_1
XTAP_TAPCELL_ROW_86_1331 VGND VPWR sky130_fd_sc_hd__tapvpwrvgnd_1
XTAP_TAPCELL_ROW_86_1342 VGND VPWR sky130_fd_sc_hd__tapvpwrvgnd_1
XFILLER_0_95_680 VGND VGND VPWR VPWR sky130_fd_sc_hd__decap_3
XFILLER_0_67_371 VGND VGND VPWR VPWR sky130_fd_sc_hd__fill_1
XFILLER_0_67_360 VGND VGND VPWR VPWR sky130_fd_sc_hd__fill_1
XFILLER_0_12_65 VPWR VGND VPWR VGND sky130_ef_sc_hd__decap_12
XTAP_TAPCELL_ROW_97_1471 VGND VPWR sky130_fd_sc_hd__tapvpwrvgnd_1
XFILLER_0_88_58 VGND VGND VPWR VPWR sky130_fd_sc_hd__decap_4
XPHY_EDGE_ROW_81_Left_203 VGND VGND VPWR VPWR sky130_fd_sc_hd__decap_3
XFILLER_0_2_357 VGND VGND VPWR VPWR sky130_fd_sc_hd__decap_6
X_07950_ _02741_ _02746_ VGND VGND VPWR VPWR _02748_ sky130_fd_sc_hd__or2_2
X_06901_ tanh_inst.div_en tanh_inst.divider.z_\[-17\] VGND VGND VPWR VPWR _00172_
+ sky130_fd_sc_hd__and2b_2
X_07881_ _01525_ _02312_ _02678_ _04757_ _02679_ VGND VGND VPWR VPWR _02680_ sky130_fd_sc_hd__o221a_2
X_06832_ _01689_ _01699_ _01706_ _01716_ VGND VGND VPWR VPWR _01723_ sky130_fd_sc_hd__and4_2
X_09620_ _03001_ _03002_ _04334_ VGND VGND VPWR VPWR _04347_ sky130_fd_sc_hd__a21oi_2
XPHY_EDGE_ROW_90_Left_212 VGND VGND VPWR VPWR sky130_fd_sc_hd__decap_3
X_09551_ _04278_ _04279_ VGND VGND VPWR VPWR _04280_ sky130_fd_sc_hd__nor2_2
X_06763_ _01648_ _01661_ VGND VGND VPWR VPWR _01662_ sky130_fd_sc_hd__nor2_2
X_05714_ mac_inst.i\[0\] _04789_ VGND VGND VPWR VPWR _00690_ sky130_fd_sc_hd__nand2_2
X_08502_ tanh_inst.divider.x\[2\] _03285_ VGND VGND VPWR VPWR _03286_ sky130_fd_sc_hd__and2_2
X_06694_ tanh_inst.z_\[-15\] _01599_ VGND VGND VPWR VPWR _01600_ sky130_fd_sc_hd__and2_2
X_09482_ tanh_inst.LOOKUP.index\[4\] _04769_ VGND VGND VPWR VPWR _04213_ sky130_fd_sc_hd__nand2_2
XFILLER_0_93_617 VGND VGND VPWR VPWR sky130_fd_sc_hd__decap_4
X_08433_ _03104_ _03172_ _03141_ _03171_ VGND VGND VPWR VPWR _03219_ sky130_fd_sc_hd__and4bb_2
X_05645_ _00627_ _00628_ VGND VGND VPWR VPWR _00629_ sky130_fd_sc_hd__xnor2_2
XFILLER_0_92_149 VGND VGND VPWR VPWR sky130_fd_sc_hd__decap_4
X_08364_ _03085_ _03087_ _03149_ VGND VGND VPWR VPWR _03152_ sky130_fd_sc_hd__or3_2
XTAP_TAPCELL_ROW_34_686 VGND VPWR sky130_fd_sc_hd__tapvpwrvgnd_1
X_05576_ _00527_ _00537_ _00546_ _00559_ VGND VGND VPWR VPWR _00567_ sky130_fd_sc_hd__or4bb_2
X_07315_ _02018_ _02103_ _02124_ _02014_ VGND VGND VPWR VPWR _02125_ sky130_fd_sc_hd__o211a_2
XFILLER_0_61_503 VGND VGND VPWR VPWR sky130_fd_sc_hd__fill_1
XFILLER_0_46_566 VGND VGND VPWR VPWR sky130_fd_sc_hd__decap_4
X_08295_ _02053_ _02391_ _02834_ VGND VGND VPWR VPWR _03084_ sky130_fd_sc_hd__o21a_2
XFILLER_0_61_525 VPWR VGND VPWR VGND sky130_ef_sc_hd__decap_12
XFILLER_0_33_205 VGND VGND VPWR VPWR sky130_fd_sc_hd__decap_6
XFILLER_0_103_104 VGND VGND VPWR VPWR sky130_fd_sc_hd__decap_8
X_07246_ tanh_inst.divider.y\[-18\] tanh_inst.divider.y\[-17\] tanh_inst.LOOKUP.index\[0\]
+ VGND VGND VPWR VPWR _02056_ sky130_fd_sc_hd__mux2_1
XFILLER_0_33_249 VGND VGND VPWR VPWR sky130_fd_sc_hd__decap_4
X_07177_ _01993_ _01994_ VGND VGND VPWR VPWR _01995_ sky130_fd_sc_hd__nor2_2
X_06128_ tanh_inst.divider.x\[-19\] tanh_inst.divider.x\[-18\] tanh_inst.divider.x\[-17\]
+ tanh_inst.divider.x\[-16\] tanh_inst.divider.i\[0\] tanh_inst.divider.i\[1\] VGND
+ VGND VPWR VPWR _01074_ sky130_fd_sc_hd__mux4_2
X_06059_ _01007_ _01008_ VGND VGND VPWR VPWR _06059_/Y sky130_fd_sc_hd__xnor2_2
XTAP_TAPCELL_ROW_70_1132 VGND VPWR sky130_fd_sc_hd__tapvpwrvgnd_1
XTAP_TAPCELL_ROW_6_334 VGND VPWR sky130_fd_sc_hd__tapvpwrvgnd_1
XTAP_TAPCELL_ROW_70_1143 VGND VPWR sky130_fd_sc_hd__tapvpwrvgnd_1
X_09818_ _04538_ _04539_ VGND VGND VPWR VPWR _04540_ sky130_fd_sc_hd__nand2_2
XTAP_TAPCELL_ROW_109_1629 VGND VPWR sky130_fd_sc_hd__tapvpwrvgnd_1
X_09749_ _02015_ _04471_ _04472_ _01470_ VGND VGND VPWR VPWR _00319_ sky130_fd_sc_hd__o211a_2
XFILLER_0_119_281 VPWR VGND VPWR VGND sky130_ef_sc_hd__decap_12
XTAP_TAPCELL_ROW_81_1272 VGND VPWR sky130_fd_sc_hd__tapvpwrvgnd_1
XFILLER_0_64_352 VGND VGND VPWR VPWR sky130_fd_sc_hd__decap_3
XFILLER_0_37_555 VGND VGND VPWR VPWR sky130_fd_sc_hd__decap_4
XFILLER_0_52_525 VGND VGND VPWR VPWR sky130_fd_sc_hd__decap_6
XFILLER_0_91_182 VGND VGND VPWR VPWR sky130_fd_sc_hd__fill_1
X_10455_ clknet_leaf_8_clk _00312_ VGND VGND VPWR VPWR tanh_inst.divider.y\[-9\] sky130_fd_sc_hd__dfxtp_2
XFILLER_0_58_17 VGND VGND VPWR VPWR sky130_fd_sc_hd__decap_4
X_10386_ clknet_leaf_7_clk _00243_ VGND VGND VPWR VPWR tanh_inst.divider.x\[-14\]
+ sky130_fd_sc_hd__dfxtp_2
XFILLER_0_20_477 VGND VGND VPWR VPWR sky130_fd_sc_hd__decap_8
XFILLER_0_59_113 VPWR VGND VPWR VGND sky130_ef_sc_hd__decap_12
XFILLER_0_99_293 VPWR VGND VPWR VGND sky130_ef_sc_hd__decap_12
XFILLER_0_90_15 VPWR VGND VPWR VGND sky130_ef_sc_hd__decap_12
XFILLER_0_117_207 VGND VGND VPWR VPWR sky130_fd_sc_hd__fill_1
XFILLER_0_114_77 VGND VGND VPWR VPWR sky130_fd_sc_hd__decap_6
XFILLER_0_28_533 VPWR VGND VPWR VGND sky130_ef_sc_hd__decap_12
X_05430_ _00431_ _00432_ VGND VGND VPWR VPWR _00433_ sky130_fd_sc_hd__xnor2_2
XTAP_TAPCELL_ROW_99_1500 VGND VPWR sky130_fd_sc_hd__tapvpwrvgnd_1
XFILLER_0_55_330 VGND VGND VPWR VPWR sky130_fd_sc_hd__decap_6
XFILLER_0_7_449 VGND VGND VPWR VPWR sky130_fd_sc_hd__decap_8
XFILLER_0_28_566 VPWR VGND VPWR VGND sky130_ef_sc_hd__decap_12
X_05361_ _00344_ _00346_ _00343_ VGND VGND VPWR VPWR _00369_ sky130_fd_sc_hd__a21bo_2
X_07100_ _01926_ VGND VGND VPWR VPWR _01927_ sky130_fd_sc_hd__inv_2
XFILLER_0_70_300 VGND VGND VPWR VPWR sky130_fd_sc_hd__decap_8
XFILLER_0_15_205 VPWR VGND VPWR VGND sky130_ef_sc_hd__decap_12
XTAP_TAPCELL_ROW_31_645 VGND VPWR sky130_fd_sc_hd__tapvpwrvgnd_1
X_08080_ _02838_ _02840_ _02873_ VGND VGND VPWR VPWR _02874_ sky130_fd_sc_hd__o21a_2
XFILLER_0_3_600 VPWR VGND VPWR VGND sky130_ef_sc_hd__decap_12
XFILLER_0_15_249 VPWR VGND VPWR VGND sky130_ef_sc_hd__decap_12
X_05292_ mac_inst.x\[31\] _04991_ _04789_ VGND VGND VPWR VPWR _04992_ sky130_fd_sc_hd__mux2_1
XFILLER_0_113_446 VGND VGND VPWR VPWR sky130_fd_sc_hd__fill_2
X_07031_ _01865_ VGND VGND VPWR VPWR _01866_ sky130_fd_sc_hd__inv_2
XFILLER_0_70_377 VGND VGND VPWR VPWR sky130_fd_sc_hd__decap_4
XFILLER_0_3_644 VGND VGND VPWR VPWR sky130_fd_sc_hd__decap_6
XFILLER_0_2_121 VPWR VGND VPWR VGND sky130_ef_sc_hd__decap_12
XFILLER_0_11_422 VGND VGND VPWR VPWR sky130_fd_sc_hd__decap_6
XFILLER_0_2_165 VPWR VGND VPWR VGND sky130_ef_sc_hd__decap_12
XFILLER_0_23_293 VPWR VGND VPWR VGND sky130_ef_sc_hd__decap_12
X_08982_ _03509_ _03510_ _03511_ _03520_ _04761_ tanh_inst.LOOKUP.index\[1\] VGND
+ VGND VPWR VPWR _03725_ sky130_fd_sc_hd__mux4_2
XFILLER_0_11_488 VGND VGND VPWR VPWR sky130_fd_sc_hd__fill_2
X_07933_ _02724_ _02729_ _04791_ VGND VGND VPWR VPWR _02731_ sky130_fd_sc_hd__o21a_2
X_07864_ tanh_inst.divider.y\[-14\] _02616_ _02614_ VGND VGND VPWR VPWR _02663_ sky130_fd_sc_hd__o21ai_2
XTAP_TAPCELL_ROW_3_304 VGND VPWR sky130_fd_sc_hd__tapvpwrvgnd_1
X_09603_ _04324_ _04326_ _04328_ _04330_ VGND VGND VPWR VPWR _04331_ sky130_fd_sc_hd__a31o_2
X_06815_ tanh_inst.z_\[-4\] _01688_ _01698_ tanh_inst.z_\[-3\] VGND VGND VPWR VPWR
+ _01708_ sky130_fd_sc_hd__a22o_2
X_07795_ _02594_ _02595_ VGND VGND VPWR VPWR _02596_ sky130_fd_sc_hd__and2b_2
XFILLER_0_64_82 VGND VGND VPWR VPWR sky130_fd_sc_hd__fill_2
XTAP_TAPCELL_ROW_39_745 VGND VPWR sky130_fd_sc_hd__tapvpwrvgnd_1
XFILLER_0_78_433 VPWR VGND VPWR VGND sky130_ef_sc_hd__decap_12
X_09534_ _04262_ _04263_ VGND VGND VPWR VPWR _04264_ sky130_fd_sc_hd__nor2_2
X_06746_ _01519_ _01534_ tanh_inst.z_\[7\] VGND VGND VPWR VPWR _01646_ sky130_fd_sc_hd__a21o_2
X_09465_ _02053_ _04194_ _04195_ _04193_ VGND VGND VPWR VPWR _04196_ sky130_fd_sc_hd__o31a_2
X_06677_ _01583_ _01584_ VGND VGND VPWR VPWR _01585_ sky130_fd_sc_hd__and2_2
XTAP_TAPCELL_ROW_104_1559 VGND VPWR sky130_fd_sc_hd__tapvpwrvgnd_1
XFILLER_0_93_425 VGND VGND VPWR VPWR sky130_fd_sc_hd__fill_1
XFILLER_0_19_511 VGND VGND VPWR VPWR sky130_fd_sc_hd__fill_1
X_05628_ _00609_ _00613_ mac_inst.y\[25\] VGND VGND VPWR VPWR _00614_ sky130_fd_sc_hd__nor3b_2
X_08416_ _03200_ _03201_ VGND VGND VPWR VPWR _03202_ sky130_fd_sc_hd__or2_2
X_09396_ tanh_inst.divider.y\[-12\] _02014_ _04113_ _04129_ _01470_ VGND VGND VPWR
+ VPWR _00309_ sky130_fd_sc_hd__o221a_2
XFILLER_0_74_650 VGND VGND VPWR VPWR sky130_fd_sc_hd__decap_8
XFILLER_0_65_149 VPWR VGND VPWR VGND sky130_ef_sc_hd__decap_12
XFILLER_0_46_352 VPWR VGND VPWR VGND sky130_ef_sc_hd__decap_12
XFILLER_0_80_119 VPWR VGND VPWR VGND sky130_ef_sc_hd__decap_12
X_05559_ _04911_ _00353_ VGND VGND VPWR VPWR _00551_ sky130_fd_sc_hd__nand2_2
X_08347_ _03050_ _03052_ _03054_ _03098_ _03048_ VGND VGND VPWR VPWR _03135_ sky130_fd_sc_hd__a311o_2
XTAP_TAPCELL_ROW_59_1005 VGND VPWR sky130_fd_sc_hd__tapvpwrvgnd_1
X_08278_ _04757_ _02369_ _02858_ VGND VGND VPWR VPWR _03068_ sky130_fd_sc_hd__a21oi_2
X_07229_ _02030_ _02034_ _02036_ _02032_ _04760_ _04761_ VGND VGND VPWR VPWR _02039_
+ sky130_fd_sc_hd__mux4_2
XFILLER_0_61_355 VGND VGND VPWR VPWR sky130_fd_sc_hd__fill_1
X_10240_ clknet_leaf_31_clk mac_inst.x\[2\] _00000_ VGND VGND VPWR VPWR mac_x_out[2]
+ sky130_fd_sc_hd__dfrtp_2
XTAP_TAPCELL_ROW_115_1699 VGND VPWR sky130_fd_sc_hd__tapvpwrvgnd_1
XPHY_EDGE_ROW_110_Right_110 VGND VGND VPWR VPWR sky130_fd_sc_hd__decap_3
XFILLER_0_97_720 VGND VGND VPWR VPWR sky130_fd_sc_hd__decap_4
XFILLER_0_88_208 VGND VGND VPWR VPWR sky130_fd_sc_hd__fill_1
XTAP_TAPCELL_ROW_83_1301 VGND VPWR sky130_fd_sc_hd__tapvpwrvgnd_1
XFILLER_0_57_617 VGND VGND VPWR VPWR sky130_fd_sc_hd__fill_1
XFILLER_0_60_29 VGND VGND VPWR VPWR sky130_fd_sc_hd__fill_1
XFILLER_0_49_190 VPWR VGND VPWR VGND sky130_ef_sc_hd__decap_12
XFILLER_0_25_503 VGND VGND VPWR VPWR sky130_fd_sc_hd__fill_1
XFILLER_0_80_642 VGND VGND VPWR VPWR sky130_fd_sc_hd__fill_2
XFILLER_0_52_377 VGND VGND VPWR VPWR sky130_fd_sc_hd__decap_6
XTAP_TAPCELL_ROW_94_1441 VGND VPWR sky130_fd_sc_hd__tapvpwrvgnd_1
X_10438_ clknet_leaf_35_clk _00295_ _00000_ VGND VGND VPWR VPWR mac_inst.i\[30\] sky130_fd_sc_hd__dfrtp_2
X_10369_ clknet_leaf_16_clk _00226_ VGND VGND VPWR VPWR tanh_inst.divider.z_\[5\]
+ sky130_fd_sc_hd__dfxtp_2
XFILLER_0_109_55 VGND VGND VPWR VPWR sky130_fd_sc_hd__fill_1
XFILLER_0_18_53 VPWR VGND VPWR VGND sky130_ef_sc_hd__decap_12
XFILLER_0_18_97 VPWR VGND VPWR VGND sky130_ef_sc_hd__decap_12
X_07580_ _02135_ _02140_ _02025_ VGND VGND VPWR VPWR _02385_ sky130_fd_sc_hd__mux2_1
X_06600_ tanh_inst.LOOKUP.index\[1\] tanh_inst.LOOKUP.index\[0\] VGND VGND VPWR VPWR
+ _01513_ sky130_fd_sc_hd__nand2_2
XTAP_TAPCELL_ROW_36_715 VGND VPWR sky130_fd_sc_hd__tapvpwrvgnd_1
X_06531_ tanh_inst.divider.y_\[4\] _01432_ _01433_ _01438_ VGND VGND VPWR VPWR _01449_
+ sky130_fd_sc_hd__a22o_2
X_09250_ _03975_ _03987_ _02015_ VGND VGND VPWR VPWR _03988_ sky130_fd_sc_hd__a21o_2
XFILLER_0_34_85 VGND VGND VPWR VPWR sky130_fd_sc_hd__decap_6
X_06462_ _04776_ _01204_ _01289_ VGND VGND VPWR VPWR _01385_ sky130_fd_sc_hd__a21boi_2
XTAP_TAPCELL_ROW_16_461 VGND VPWR sky130_fd_sc_hd__tapvpwrvgnd_1
X_08201_ _02917_ _02947_ VGND VGND VPWR VPWR _02993_ sky130_fd_sc_hd__and2_2
X_06393_ _04793_ _01321_ _01301_ VGND VGND VPWR VPWR _01322_ sky130_fd_sc_hd__a21bo_2
X_09181_ tanh_inst.divider.y\[-17\] _03919_ VGND VGND VPWR VPWR _03920_ sky130_fd_sc_hd__and2_2
XFILLER_0_90_417 VGND VGND VPWR VPWR sky130_fd_sc_hd__decap_3
XFILLER_0_62_108 VPWR VGND VPWR VGND sky130_ef_sc_hd__decap_12
X_05413_ _04923_ _00355_ _00360_ _04908_ VGND VGND VPWR VPWR _00417_ sky130_fd_sc_hd__a2bb2o_2
XFILLER_0_71_653 VGND VGND VPWR VPWR sky130_fd_sc_hd__decap_8
XFILLER_0_7_279 VGND VGND VPWR VPWR sky130_fd_sc_hd__fill_1
X_05344_ mac_inst.i\[2\] _00351_ _00350_ VGND VGND VPWR VPWR _00352_ sky130_fd_sc_hd__o21a_2
X_08132_ tanh_inst.divider.y\[-7\] tanh_inst.divider.x\[-7\] VGND VGND VPWR VPWR _02925_
+ sky130_fd_sc_hd__nor2_2
XFILLER_0_113_221 VGND VGND VPWR VPWR sky130_fd_sc_hd__decap_3
XFILLER_0_70_141 VPWR VGND VPWR VGND sky130_ef_sc_hd__decap_12
X_05275_ _04955_ _04975_ VGND VGND VPWR VPWR _04976_ sky130_fd_sc_hd__nor2_2
X_08063_ _04757_ tanh_inst.divider.y\[7\] VGND VGND VPWR VPWR _02858_ sky130_fd_sc_hd__nor2_2
X_07014_ _01839_ _01844_ _01848_ _01849_ VGND VGND VPWR VPWR _01851_ sky130_fd_sc_hd__o22a_2
XFILLER_0_3_441 VGND VGND VPWR VPWR sky130_fd_sc_hd__decap_6
XFILLER_0_59_93 VGND VGND VPWR VPWR sky130_fd_sc_hd__fill_1
X_08965_ tanh_inst.divider.x\[-14\] tanh_inst.divider.x\[-13\] tanh_inst.divider.x\[-12\]
+ tanh_inst.divider.x\[-11\] tanh_inst.LOOKUP.index\[0\] tanh_inst.LOOKUP.index\[1\]
+ VGND VGND VPWR VPWR _03709_ sky130_fd_sc_hd__mux4_2
X_07916_ _02627_ _02667_ _02668_ VGND VGND VPWR VPWR _02714_ sky130_fd_sc_hd__and3_2
XFILLER_0_75_70 VGND VGND VPWR VPWR sky130_fd_sc_hd__decap_3
X_08896_ tanh_inst.divider.x\[-15\] tanh_inst.divider.x\[-14\] tanh_inst.divider.x\[-13\]
+ tanh_inst.divider.x\[-12\] tanh_inst.LOOKUP.index\[0\] tanh_inst.LOOKUP.index\[1\]
+ VGND VGND VPWR VPWR _03641_ sky130_fd_sc_hd__mux4_2
XFILLER_0_79_720 VGND VGND VPWR VPWR sky130_fd_sc_hd__decap_4
XFILLER_0_75_92 VPWR VGND VPWR VGND sky130_ef_sc_hd__decap_12
X_07847_ _02644_ _02646_ VGND VGND VPWR VPWR _02647_ sky130_fd_sc_hd__xnor2_2
X_07778_ tanh_inst.divider.y\[7\] _02133_ _02136_ _02143_ _02023_ _02052_ VGND VGND
+ VPWR VPWR _02579_ sky130_fd_sc_hd__mux4_2
XFILLER_0_94_701 VGND VGND VPWR VPWR sky130_fd_sc_hd__decap_6
X_09517_ _04239_ _04242_ _04246_ VGND VGND VPWR VPWR _04247_ sky130_fd_sc_hd__a21o_2
XFILLER_0_39_617 VGND VGND VPWR VPWR sky130_fd_sc_hd__decap_3
X_06729_ tanh_inst.z_\[-11\] _01630_ VGND VGND VPWR VPWR _01631_ sky130_fd_sc_hd__and2_2
XFILLER_0_109_505 VPWR VGND VPWR VGND sky130_ef_sc_hd__decap_12
X_09448_ _04110_ _04139_ VGND VGND VPWR VPWR _04180_ sky130_fd_sc_hd__or2_2
XTAP_TAPCELL_ROW_65_1075 VGND VPWR sky130_fd_sc_hd__tapvpwrvgnd_1
X_09379_ _04098_ _04112_ _02018_ VGND VGND VPWR VPWR _04113_ sky130_fd_sc_hd__a21oi_2
XFILLER_0_117_582 VGND VGND VPWR VPWR sky130_fd_sc_hd__decap_8
XTAP_TAPCELL_ROW_117_1728 VGND VPWR sky130_fd_sc_hd__tapvpwrvgnd_1
XFILLER_0_105_722 VGND VGND VPWR VPWR sky130_fd_sc_hd__fill_2
XFILLER_0_34_355 VGND VGND VPWR VPWR sky130_fd_sc_hd__decap_8
XFILLER_0_104_298 VGND VGND VPWR VPWR sky130_fd_sc_hd__decap_4
X_10223_ clknet_leaf_27_clk mac_inst.y\[17\] _00000_ VGND VGND VPWR VPWR mac_y_out[17]
+ sky130_fd_sc_hd__dfrtp_2
X_10085_ clknet_leaf_4_clk _00102_ VGND VGND VPWR VPWR tanh_inst.divider.y_\[-8\]
+ sky130_fd_sc_hd__dfxtp_2
XFILLER_0_89_539 VGND VGND VPWR VPWR sky130_fd_sc_hd__decap_4
XFILLER_0_97_550 VGND VGND VPWR VPWR sky130_fd_sc_hd__decap_4
XFILLER_0_85_723 VGND VGND VPWR VPWR sky130_fd_sc_hd__fill_1
XFILLER_0_84_277 VGND VGND VPWR VPWR sky130_fd_sc_hd__decap_8
XTAP_TAPCELL_ROW_13_420 VGND VPWR sky130_fd_sc_hd__tapvpwrvgnd_1
XFILLER_0_37_182 VGND VGND VPWR VPWR sky130_fd_sc_hd__decap_3
XTAP_TAPCELL_ROW_41_773 VGND VPWR sky130_fd_sc_hd__tapvpwrvgnd_1
XFILLER_0_52_141 VPWR VGND VPWR VGND sky130_ef_sc_hd__decap_12
XFILLER_0_111_703 VGND VGND VPWR VPWR sky130_fd_sc_hd__fill_2
XFILLER_0_13_539 VGND VGND VPWR VPWR sky130_fd_sc_hd__decap_8
XFILLER_0_20_65 VPWR VGND VPWR VGND sky130_ef_sc_hd__decap_12
XFILLER_0_52_174 VGND VGND VPWR VPWR sky130_fd_sc_hd__fill_2
XFILLER_0_21_550 VGND VGND VPWR VPWR sky130_fd_sc_hd__decap_8
X_05060_ mac_inst.i\[13\] VGND VGND VPWR VPWR _04784_ sky130_fd_sc_hd__inv_2
X_05962_ _00918_ _00919_ VGND VGND VPWR VPWR _05962_/X sky130_fd_sc_hd__xor2_2
X_08750_ _00967_ _03503_ VGND VGND VPWR VPWR _00289_ sky130_fd_sc_hd__nor2_2
X_07701_ _02503_ VGND VGND VPWR VPWR _02504_ sky130_fd_sc_hd__inv_2
X_08681_ _03460_ _03459_ VGND VGND VPWR VPWR _03461_ sky130_fd_sc_hd__and2b_2
X_05893_ _00853_ _00855_ VGND VGND VPWR VPWR _00856_ sky130_fd_sc_hd__and2_2
X_07632_ _02024_ _02205_ _02022_ VGND VGND VPWR VPWR _02436_ sky130_fd_sc_hd__a21oi_2
XFILLER_0_45_73 VPWR VGND VPWR VGND sky130_ef_sc_hd__decap_12
XTAP_TAPCELL_ROW_49_873 VGND VPWR sky130_fd_sc_hd__tapvpwrvgnd_1
XFILLER_0_76_701 VGND VGND VPWR VPWR sky130_fd_sc_hd__fill_2
X_09302_ _03969_ _03991_ VGND VGND VPWR VPWR _04038_ sky130_fd_sc_hd__nor2_2
XFILLER_0_75_200 VPWR VGND VPWR VGND sky130_ef_sc_hd__decap_12
X_07563_ _04758_ _02366_ _02368_ VGND VGND VPWR VPWR _02369_ sky130_fd_sc_hd__a21oi_2
XFILLER_0_48_414 VGND VGND VPWR VPWR sky130_fd_sc_hd__decap_6
X_06514_ tanh_inst.divider.y_\[4\] _01432_ VGND VGND VPWR VPWR _01433_ sky130_fd_sc_hd__xor2_2
XTAP_TAPCELL_ROW_101_1529 VGND VPWR sky130_fd_sc_hd__tapvpwrvgnd_1
X_07494_ _02299_ _02300_ VGND VGND VPWR VPWR _02301_ sky130_fd_sc_hd__nand2_2
XFILLER_0_0_53 VGND VGND VPWR VPWR sky130_fd_sc_hd__decap_3
X_06445_ _01369_ tanh_inst.divider.y_\[-2\] VGND VGND VPWR VPWR _01370_ sky130_fd_sc_hd__and2b_2
X_09233_ _03969_ _03970_ VGND VGND VPWR VPWR _03971_ sky130_fd_sc_hd__or2_2
XFILLER_0_61_94 VGND VGND VPWR VPWR sky130_fd_sc_hd__fill_1
XFILLER_0_8_555 VGND VGND VPWR VPWR sky130_fd_sc_hd__decap_8
XFILLER_0_0_97 VPWR VGND VPWR VGND sky130_ef_sc_hd__decap_12
X_09164_ tanh_inst.divider.y\[-18\] _03902_ VGND VGND VPWR VPWR _03904_ sky130_fd_sc_hd__or2_2
XFILLER_0_16_333 VPWR VGND VPWR VGND sky130_ef_sc_hd__decap_12
XFILLER_0_28_182 VGND VGND VPWR VPWR sky130_fd_sc_hd__decap_6
X_06376_ _01305_ _01306_ VGND VGND VPWR VPWR _01307_ sky130_fd_sc_hd__or2_2
X_08115_ tanh_inst.divider.x\[-9\] _02862_ _02908_ VGND VGND VPWR VPWR _02909_ sky130_fd_sc_hd__o21ai_2
XFILLER_0_9_51 VGND VGND VPWR VPWR sky130_fd_sc_hd__decap_4
XFILLER_0_43_152 VGND VGND VPWR VPWR sky130_fd_sc_hd__fill_1
XFILLER_0_44_675 VGND VGND VPWR VPWR sky130_fd_sc_hd__decap_3
XFILLER_0_114_541 VGND VGND VPWR VPWR sky130_fd_sc_hd__decap_3
X_09095_ _02408_ _03834_ VGND VGND VPWR VPWR _03836_ sky130_fd_sc_hd__or2_2
X_05327_ _04914_ _04916_ _04789_ VGND VGND VPWR VPWR _05026_ sky130_fd_sc_hd__a21o_2
XFILLER_0_101_213 VGND VGND VPWR VPWR sky130_fd_sc_hd__fill_1
X_08046_ tanh_inst.divider.y\[-9\] _02839_ VGND VGND VPWR VPWR _02841_ sky130_fd_sc_hd__and2_2
X_05258_ mac_inst.i\[19\] mac_inst.i\[21\] VGND VGND VPWR VPWR _04959_ sky130_fd_sc_hd__xor2_2
XFILLER_0_12_550 VGND VGND VPWR VPWR sky130_fd_sc_hd__fill_1
XFILLER_0_3_293 VPWR VGND VPWR VGND sky130_ef_sc_hd__decap_12
X_05189_ mac_inst.x\[13\] _04852_ _04853_ VGND VGND VPWR VPWR _04893_ sky130_fd_sc_hd__a21oi_2
XTAP_TAPCELL_ROW_112_1658 VGND VPWR sky130_fd_sc_hd__tapvpwrvgnd_1
X_09997_ _02053_ _04172_ _04193_ VGND VGND VPWR VPWR _04713_ sky130_fd_sc_hd__o21a_2
X_08948_ _03689_ _03690_ VGND VGND VPWR VPWR _03692_ sky130_fd_sc_hd__nor2_2
X_08879_ _03612_ _03613_ _02168_ VGND VGND VPWR VPWR _03624_ sky130_fd_sc_hd__a21o_2
XTAP_TAPCELL_ROW_67_1104 VGND VPWR sky130_fd_sc_hd__tapvpwrvgnd_1
XFILLER_0_67_712 VPWR VGND VPWR VGND sky130_ef_sc_hd__decap_12
XFILLER_0_39_436 VPWR VGND VPWR VGND sky130_ef_sc_hd__decap_12
XFILLER_0_109_313 VGND VGND VPWR VPWR sky130_fd_sc_hd__fill_2
XFILLER_0_27_609 VGND VGND VPWR VPWR sky130_fd_sc_hd__decap_6
XFILLER_0_66_288 VGND VGND VPWR VPWR sky130_fd_sc_hd__fill_1
XFILLER_0_66_266 VGND VGND VPWR VPWR sky130_fd_sc_hd__decap_8
XFILLER_0_81_225 VPWR VGND VPWR VGND sky130_ef_sc_hd__decap_12
XFILLER_0_54_439 VGND VGND VPWR VPWR sky130_fd_sc_hd__decap_8
XFILLER_0_19_193 VPWR VGND VPWR VGND sky130_ef_sc_hd__decap_12
XFILLER_0_47_480 VGND VGND VPWR VPWR sky130_fd_sc_hd__fill_1
XTAP_TAPCELL_ROW_78_1233 VGND VPWR sky130_fd_sc_hd__tapvpwrvgnd_1
XFILLER_0_50_645 VGND VGND VPWR VPWR sky130_fd_sc_hd__fill_2
XFILLER_0_120_533 VGND VGND VPWR VPWR sky130_fd_sc_hd__decap_6
XTAP_TAPCELL_ROW_91_1400 VGND VPWR sky130_fd_sc_hd__tapvpwrvgnd_1
XFILLER_0_30_391 VGND VGND VPWR VPWR sky130_fd_sc_hd__fill_1
X_10206_ clknet_leaf_28_clk mac_inst.y\[0\] _00000_ VGND VGND VPWR VPWR mac_y_out[0]
+ sky130_fd_sc_hd__dfrtp_2
X_10068_ clknet_leaf_33_clk next_state\[0\] _00067_ VGND VGND VPWR VPWR current_state\[0\]
+ sky130_fd_sc_hd__dfrtp_2
XPHY_EDGE_ROW_13_Right_13 VGND VGND VPWR VPWR sky130_fd_sc_hd__decap_3
XTAP_TAPCELL_ROW_89_1373 VGND VPWR sky130_fd_sc_hd__tapvpwrvgnd_1
XFILLER_0_58_701 VGND VGND VPWR VPWR sky130_fd_sc_hd__fill_2
XTAP_TAPCELL_ROW_46_832 VGND VPWR sky130_fd_sc_hd__tapvpwrvgnd_1
XTAP_TAPCELL_ROW_46_843 VGND VPWR sky130_fd_sc_hd__tapvpwrvgnd_1
XFILLER_0_85_586 VGND VGND VPWR VPWR sky130_fd_sc_hd__decap_8
XFILLER_0_45_417 VGND VGND VPWR VPWR sky130_fd_sc_hd__decap_4
X_06230_ _01169_ _01170_ _01171_ VGND VGND VPWR VPWR _01172_ sky130_fd_sc_hd__a21oi_2
XFILLER_0_31_42 VGND VGND VPWR VPWR sky130_fd_sc_hd__decap_8
XFILLER_0_45_439 VGND VGND VPWR VPWR sky130_fd_sc_hd__decap_8
XFILLER_0_115_327 VGND VGND VPWR VPWR sky130_fd_sc_hd__decap_8
XPHY_EDGE_ROW_22_Right_22 VGND VGND VPWR VPWR sky130_fd_sc_hd__decap_3
XFILLER_0_26_675 VGND VGND VPWR VPWR sky130_fd_sc_hd__decap_3
XFILLER_0_31_64 VGND VGND VPWR VPWR sky130_fd_sc_hd__decap_8
X_06161_ _01031_ _01102_ _01105_ _01039_ VGND VGND VPWR VPWR _01106_ sky130_fd_sc_hd__o22a_2
XFILLER_0_5_558 VGND VGND VPWR VPWR sky130_fd_sc_hd__fill_2
XFILLER_0_25_163 VGND VGND VPWR VPWR sky130_fd_sc_hd__decap_4
X_06092_ _04776_ tanh_inst.divider.i\[3\] VGND VGND VPWR VPWR _01039_ sky130_fd_sc_hd__nand2_2
X_05112_ mac_counter\[3\] _04822_ VGND VGND VPWR VPWR _04824_ sky130_fd_sc_hd__and2_2
X_05043_ tanh_inst.divider.y\[-17\] VGND VGND VPWR VPWR _04767_ sky130_fd_sc_hd__inv_2
X_09920_ tanh_inst.divider.y\[3\] _02014_ _04628_ _04638_ _01470_ VGND VGND VPWR VPWR
+ _00324_ sky130_fd_sc_hd__o221a_2
XFILLER_0_21_391 VGND VGND VPWR VPWR sky130_fd_sc_hd__fill_1
X_09851_ _04570_ _04571_ _02014_ VGND VGND VPWR VPWR _04572_ sky130_fd_sc_hd__o21ai_2
X_06994_ tanh_inst.divider.z_\[-17\] _01829_ _01832_ VGND VGND VPWR VPWR _01833_ sky130_fd_sc_hd__and3_2
X_08802_ _03544_ _03546_ _03547_ _03545_ _04760_ tanh_inst.LOOKUP.index\[0\] VGND
+ VGND VPWR VPWR _03548_ sky130_fd_sc_hd__mux4_2
XPHY_EDGE_ROW_31_Right_31 VGND VGND VPWR VPWR sky130_fd_sc_hd__decap_3
X_09782_ _04502_ _04442_ _04430_ VGND VGND VPWR VPWR _04504_ sky130_fd_sc_hd__nand3b_2
X_05945_ _00884_ _00896_ VGND VGND VPWR VPWR _00904_ sky130_fd_sc_hd__and2_2
X_08733_ _03494_ _03495_ VGND VGND VPWR VPWR _00280_ sky130_fd_sc_hd__nor2_2
XFILLER_0_22_3 VPWR VGND VPWR VGND sky130_ef_sc_hd__decap_12
X_08664_ _03442_ _03443_ VGND VGND VPWR VPWR _03444_ sky130_fd_sc_hd__xnor2_2
X_05876_ _00795_ _00813_ _00821_ VGND VGND VPWR VPWR _00840_ sky130_fd_sc_hd__and3_2
XFILLER_0_95_317 VGND VGND VPWR VPWR sky130_fd_sc_hd__fill_1
XFILLER_0_72_60 VGND VGND VPWR VPWR sky130_fd_sc_hd__fill_1
X_07615_ _01480_ _02186_ _02189_ _01486_ VGND VGND VPWR VPWR _02420_ sky130_fd_sc_hd__o22a_2
XFILLER_0_48_211 VGND VGND VPWR VPWR sky130_fd_sc_hd__decap_8
X_08595_ _03326_ _03342_ _03303_ VGND VGND VPWR VPWR _03377_ sky130_fd_sc_hd__o21ba_2
X_07546_ _02349_ _02350_ VGND VGND VPWR VPWR _02352_ sky130_fd_sc_hd__xor2_2
XFILLER_0_72_82 VGND VGND VPWR VPWR sky130_fd_sc_hd__fill_2
XFILLER_0_118_121 VPWR VGND VPWR VGND sky130_ef_sc_hd__decap_12
XTAP_TAPCELL_ROW_62_1034 VGND VPWR sky130_fd_sc_hd__tapvpwrvgnd_1
XTAP_TAPCELL_ROW_24_559 VGND VPWR sky130_fd_sc_hd__tapvpwrvgnd_1
XFILLER_0_36_417 VGND VGND VPWR VPWR sky130_fd_sc_hd__decap_3
XFILLER_0_118_165 VGND VGND VPWR VPWR sky130_fd_sc_hd__decap_8
XPHY_EDGE_ROW_101_Left_223 VGND VGND VPWR VPWR sky130_fd_sc_hd__decap_3
X_09216_ _02022_ _03549_ _03916_ VGND VGND VPWR VPWR _03954_ sky130_fd_sc_hd__o21a_2
X_07477_ _02081_ _02085_ _02088_ _02083_ _04760_ _04761_ VGND VGND VPWR VPWR _02284_
+ sky130_fd_sc_hd__mux4_2
XFILLER_0_76_597 VGND VGND VPWR VPWR sky130_fd_sc_hd__fill_1
XFILLER_0_8_363 VGND VGND VPWR VPWR sky130_fd_sc_hd__fill_1
XPHY_EDGE_ROW_40_Right_40 VGND VGND VPWR VPWR sky130_fd_sc_hd__decap_3
XFILLER_0_118_187 VGND VGND VPWR VPWR sky130_fd_sc_hd__fill_2
X_06428_ _01348_ _01354_ VGND VGND VPWR VPWR _01355_ sky130_fd_sc_hd__xor2_2
XFILLER_0_16_141 VPWR VGND VPWR VGND sky130_ef_sc_hd__decap_12
X_06359_ _01266_ _01267_ _01279_ _04793_ VGND VGND VPWR VPWR _01291_ sky130_fd_sc_hd__o31a_2
X_09147_ _02459_ _03876_ VGND VGND VPWR VPWR _03887_ sky130_fd_sc_hd__or2_2
X_09078_ tanh_inst.divider.y\[-20\] _03818_ VGND VGND VPWR VPWR _03820_ sky130_fd_sc_hd__xnor2_2
X_08029_ tanh_inst.divider.x\[-10\] _02824_ VGND VGND VPWR VPWR _02825_ sky130_fd_sc_hd__xnor2_2
XTAP_TAPCELL_ROW_73_1174 VGND VPWR sky130_fd_sc_hd__tapvpwrvgnd_1
XPHY_EDGE_ROW_110_Left_232 VGND VGND VPWR VPWR sky130_fd_sc_hd__decap_3
XFILLER_0_98_166 VGND VGND VPWR VPWR sky130_fd_sc_hd__decap_8
XTAP_TAPCELL_ROW_43_802 VGND VPWR sky130_fd_sc_hd__tapvpwrvgnd_1
XFILLER_0_79_391 VGND VGND VPWR VPWR sky130_fd_sc_hd__fill_1
XFILLER_0_39_222 VGND VGND VPWR VPWR sky130_fd_sc_hd__fill_2
XFILLER_0_94_361 VGND VGND VPWR VPWR sky130_fd_sc_hd__decap_3
XFILLER_0_67_575 VGND VGND VPWR VPWR sky130_fd_sc_hd__fill_1
XFILLER_0_109_143 VGND VGND VPWR VPWR sky130_fd_sc_hd__decap_3
XFILLER_0_82_589 VGND VGND VPWR VPWR sky130_fd_sc_hd__fill_2
XFILLER_0_82_578 VGND VGND VPWR VPWR sky130_fd_sc_hd__decap_3
XFILLER_0_22_133 VGND VGND VPWR VPWR sky130_fd_sc_hd__decap_6
XFILLER_0_22_177 VPWR VGND VPWR VGND sky130_ef_sc_hd__decap_12
XFILLER_0_50_475 VGND VGND VPWR VPWR sky130_fd_sc_hd__fill_1
XFILLER_0_120_363 VGND VGND VPWR VPWR sky130_fd_sc_hd__fill_1
XFILLER_0_93_15 VPWR VGND VPWR VGND sky130_ef_sc_hd__decap_12
XFILLER_0_117_55 VGND VGND VPWR VPWR sky130_fd_sc_hd__fill_1
XFILLER_0_89_111 VGND VGND VPWR VPWR sky130_fd_sc_hd__fill_1
X_05730_ _04944_ _00704_ VGND VGND VPWR VPWR _00705_ sky130_fd_sc_hd__nor2_2
XFILLER_0_26_53 VGND VGND VPWR VPWR sky130_fd_sc_hd__decap_6
XFILLER_0_77_328 VGND VGND VPWR VPWR sky130_fd_sc_hd__fill_1
X_05661_ _00639_ _00643_ VGND VGND VPWR VPWR _05661_/X sky130_fd_sc_hd__xor2_2
X_07400_ _02027_ _02048_ _02207_ _02025_ VGND VGND VPWR VPWR _02208_ sky130_fd_sc_hd__a211oi_2
XFILLER_0_58_531 VGND VGND VPWR VPWR sky130_fd_sc_hd__fill_1
XFILLER_0_9_105 VGND VGND VPWR VPWR sky130_fd_sc_hd__decap_6
X_08380_ _03164_ _03166_ VGND VGND VPWR VPWR _03167_ sky130_fd_sc_hd__nand2_2
X_07331_ _02030_ _02032_ _02034_ _02094_ tanh_inst.LOOKUP.index\[0\] tanh_inst.LOOKUP.index\[1\]
+ VGND VGND VPWR VPWR _02140_ sky130_fd_sc_hd__mux4_2
XFILLER_0_9_149 VPWR VGND VPWR VGND sky130_ef_sc_hd__decap_12
X_05592_ mac_inst.y\[21\] _00572_ _00562_ mac_inst.y\[20\] VGND VGND VPWR VPWR _00581_
+ sky130_fd_sc_hd__o211a_2
XFILLER_0_18_428 VGND VGND VPWR VPWR sky130_fd_sc_hd__fill_1
XFILLER_0_45_236 VGND VGND VPWR VPWR sky130_fd_sc_hd__fill_1
XFILLER_0_116_625 VPWR VGND VPWR VGND sky130_ef_sc_hd__decap_12
XFILLER_0_115_113 VPWR VGND VPWR VGND sky130_ef_sc_hd__decap_12
XFILLER_0_73_578 VGND VGND VPWR VPWR sky130_fd_sc_hd__decap_4
X_07262_ tanh_inst.divider.y\[2\] _02028_ _02029_ VGND VGND VPWR VPWR _02072_ sky130_fd_sc_hd__o21a_2
XTAP_TAPCELL_ROW_21_529 VGND VPWR sky130_fd_sc_hd__tapvpwrvgnd_1
X_07193_ tanh_inst.divider.z_\[6\] _01092_ _02008_ VGND VGND VPWR VPWR _00227_ sky130_fd_sc_hd__a21o_2
XFILLER_0_116_669 VGND VGND VPWR VPWR sky130_fd_sc_hd__fill_2
X_06213_ tanh_inst.divider.y\[-20\] tanh_inst.div_en tanh_inst.divider.y_\[-20\] _01092_
+ VGND VGND VPWR VPWR _01156_ sky130_fd_sc_hd__a22o_2
X_09001_ _04773_ _03686_ _03685_ VGND VGND VPWR VPWR _03744_ sky130_fd_sc_hd__a21o_2
XFILLER_0_103_319 VGND VGND VPWR VPWR sky130_fd_sc_hd__fill_1
X_06144_ _01063_ _01087_ _01089_ VGND VGND VPWR VPWR _01090_ sky130_fd_sc_hd__a21oi_2
XFILLER_0_13_111 VGND VGND VPWR VPWR sky130_fd_sc_hd__fill_1
XFILLER_0_14_645 VGND VGND VPWR VPWR sky130_fd_sc_hd__decap_3
X_06075_ tanh_inst.divider.x\[0\] tanh_inst.divider.x\[1\] tanh_inst.divider.x\[2\]
+ tanh_inst.divider.x\[3\] tanh_inst.divider.i\[0\] tanh_inst.divider.i\[1\] VGND
+ VGND VPWR VPWR _01022_ sky130_fd_sc_hd__mux4_2
XFILLER_0_6_41 VPWR VGND VPWR VGND sky130_ef_sc_hd__decap_12
XFILLER_0_1_550 VGND VGND VPWR VPWR sky130_fd_sc_hd__fill_2
X_09903_ _04621_ VGND VGND VPWR VPWR _04622_ sky130_fd_sc_hd__inv_2
XFILLER_0_6_85 VPWR VGND VPWR VGND sky130_ef_sc_hd__decap_12
X_09834_ tanh_inst.divider.x\[1\] _04554_ VGND VGND VPWR VPWR _04555_ sky130_fd_sc_hd__nor2_2
X_06977_ _01088_ _01816_ _01817_ _01092_ tanh_inst.divider.z_\[-19\] VGND VGND VPWR
+ VPWR _00202_ sky130_fd_sc_hd__a32o_2
X_09765_ _04454_ _04457_ _04485_ VGND VGND VPWR VPWR _04488_ sky130_fd_sc_hd__nor3_2
X_05928_ _00884_ _00887_ VGND VGND VPWR VPWR _05928_/X sky130_fd_sc_hd__xor2_2
X_08716_ _00955_ _03489_ VGND VGND VPWR VPWR _00269_ sky130_fd_sc_hd__nor2_2
XTAP_TAPCELL_ROW_29_629 VGND VPWR sky130_fd_sc_hd__tapvpwrvgnd_1
X_09696_ _04419_ _04420_ VGND VGND VPWR VPWR _04421_ sky130_fd_sc_hd__or2_2
XFILLER_0_83_81 VGND VGND VPWR VPWR sky130_fd_sc_hd__decap_6
X_05859_ _00797_ _00823_ VGND VGND VPWR VPWR _00824_ sky130_fd_sc_hd__and2_2
XTAP_TAPCELL_ROW_1_276 VGND VPWR sky130_fd_sc_hd__tapvpwrvgnd_1
X_08647_ tanh_inst.z_\[7\] _03392_ _03391_ VGND VGND VPWR VPWR _03428_ sky130_fd_sc_hd__o21ai_2
XFILLER_0_95_125 VGND VGND VPWR VPWR sky130_fd_sc_hd__decap_6
XFILLER_0_95_169 VPWR VGND VPWR VGND sky130_ef_sc_hd__decap_12
X_08578_ _03358_ _03359_ VGND VGND VPWR VPWR _03360_ sky130_fd_sc_hd__or2_2
XFILLER_0_64_501 VPWR VGND VPWR VGND sky130_ef_sc_hd__decap_12
XTAP_TAPCELL_ROW_120_1768 VGND VPWR sky130_fd_sc_hd__tapvpwrvgnd_1
XTAP_TAPCELL_ROW_120_1757 VGND VPWR sky130_fd_sc_hd__tapvpwrvgnd_1
X_07529_ _01469_ _02335_ VGND VGND VPWR VPWR _00236_ sky130_fd_sc_hd__nor2_2
XFILLER_0_64_545 VPWR VGND VPWR VGND sky130_ef_sc_hd__decap_12
X_10471_ clknet_leaf_2_clk _00328_ VGND VGND VPWR VPWR tanh_inst.divider.y\[7\] sky130_fd_sc_hd__dfxtp_2
XTAP_TAPCELL_ROW_75_1203 VGND VPWR sky130_fd_sc_hd__tapvpwrvgnd_1
XFILLER_0_102_363 VGND VGND VPWR VPWR sky130_fd_sc_hd__fill_1
XTAP_TAPCELL_ROW_9_376 VGND VPWR sky130_fd_sc_hd__tapvpwrvgnd_1
XTAP_TAPCELL_ROW_86_1343 VGND VPWR sky130_fd_sc_hd__tapvpwrvgnd_1
XTAP_TAPCELL_ROW_86_1332 VGND VPWR sky130_fd_sc_hd__tapvpwrvgnd_1
XTAP_TAPCELL_ROW_56_960 VGND VPWR sky130_fd_sc_hd__tapvpwrvgnd_1
XFILLER_0_74_309 VGND VGND VPWR VPWR sky130_fd_sc_hd__decap_4
XFILLER_0_27_225 VGND VGND VPWR VPWR sky130_fd_sc_hd__decap_8
XFILLER_0_103_57 VGND VGND VPWR VPWR sky130_fd_sc_hd__decap_6
XFILLER_0_12_77 VGND VGND VPWR VPWR sky130_fd_sc_hd__decap_6
XFILLER_0_88_37 VGND VGND VPWR VPWR sky130_fd_sc_hd__decap_4
XFILLER_0_88_15 VPWR VGND VPWR VGND sky130_ef_sc_hd__decap_12
XFILLER_0_23_420 VGND VGND VPWR VPWR sky130_fd_sc_hd__fill_1
XTAP_TAPCELL_ROW_97_1472 VGND VPWR sky130_fd_sc_hd__tapvpwrvgnd_1
XFILLER_0_11_615 VGND VGND VPWR VPWR sky130_fd_sc_hd__fill_1
XFILLER_0_105_190 VGND VGND VPWR VPWR sky130_fd_sc_hd__fill_2
X_06900_ tanh_inst.div_en tanh_inst.divider.z_\[-18\] VGND VGND VPWR VPWR _00171_
+ sky130_fd_sc_hd__and2b_2
X_07880_ _01477_ _02322_ VGND VGND VPWR VPWR _02679_ sky130_fd_sc_hd__or2_2
X_06831_ _01706_ _01709_ _01716_ VGND VGND VPWR VPWR _01722_ sky130_fd_sc_hd__and3_2
X_09550_ tanh_inst.divider.x\[-7\] _04277_ VGND VGND VPWR VPWR _04279_ sky130_fd_sc_hd__and2_2
X_06762_ _01641_ _01643_ _01649_ _01640_ VGND VGND VPWR VPWR _01661_ sky130_fd_sc_hd__o211a_2
X_05713_ _00687_ _00688_ VGND VGND VPWR VPWR _05713_/Y sky130_fd_sc_hd__xnor2_2
X_09481_ _04757_ tanh_inst.divider.x\[7\] VGND VGND VPWR VPWR _04212_ sky130_fd_sc_hd__nor2_2
X_08501_ _03283_ _03284_ VGND VGND VPWR VPWR _03285_ sky130_fd_sc_hd__xnor2_2
XFILLER_0_77_147 VPWR VGND VPWR VGND sky130_ef_sc_hd__decap_12
X_06693_ _01547_ tanh_inst.z_\[7\] _01555_ VGND VGND VPWR VPWR _01599_ sky130_fd_sc_hd__mux2_1
X_08432_ _03209_ _03217_ VGND VGND VPWR VPWR _03218_ sky130_fd_sc_hd__xor2_2
XTAP_TAPCELL_ROW_106_1590 VGND VPWR sky130_fd_sc_hd__tapvpwrvgnd_1
XFILLER_0_86_670 VGND VGND VPWR VPWR sky130_fd_sc_hd__fill_1
XFILLER_0_58_361 VGND VGND VPWR VPWR sky130_fd_sc_hd__decap_3
X_05644_ mac_inst.z\[31\] _00618_ _00612_ VGND VGND VPWR VPWR _00628_ sky130_fd_sc_hd__o21ai_2
X_08363_ _03150_ VGND VGND VPWR VPWR _03151_ sky130_fd_sc_hd__inv_2
X_05575_ _00546_ _00548_ _00559_ _00565_ _00558_ VGND VGND VPWR VPWR _00566_ sky130_fd_sc_hd__a311o_2
XFILLER_0_116_411 VGND VGND VPWR VPWR sky130_fd_sc_hd__decap_8
X_07314_ _02018_ _02113_ VGND VGND VPWR VPWR _02124_ sky130_fd_sc_hd__nand2_2
XTAP_TAPCELL_ROW_34_687 VGND VPWR sky130_fd_sc_hd__tapvpwrvgnd_1
X_08294_ tanh_inst.divider.x\[-4\] _02014_ _03083_ _01470_ VGND VGND VPWR VPWR _00253_
+ sky130_fd_sc_hd__o211a_2
XFILLER_0_46_545 VGND VGND VPWR VPWR sky130_fd_sc_hd__decap_4
X_07245_ _02028_ _02054_ _02029_ VGND VGND VPWR VPWR _02055_ sky130_fd_sc_hd__o21ai_2
XFILLER_0_61_537 VPWR VGND VPWR VGND sky130_ef_sc_hd__decap_12
XFILLER_0_6_631 VGND VGND VPWR VPWR sky130_fd_sc_hd__fill_1
XFILLER_0_116_477 VGND VGND VPWR VPWR sky130_fd_sc_hd__decap_4
XFILLER_0_61_559 VGND VGND VPWR VPWR sky130_fd_sc_hd__fill_1
XFILLER_0_6_664 VGND VGND VPWR VPWR sky130_fd_sc_hd__fill_2
X_07176_ tanh_inst.divider.z_\[4\] _01975_ VGND VGND VPWR VPWR _01994_ sky130_fd_sc_hd__nor2_2
XFILLER_0_14_464 VPWR VGND VPWR VGND sky130_ef_sc_hd__decap_12
X_06127_ _01066_ _01072_ tanh_inst.divider.i\[3\] VGND VGND VPWR VPWR _01073_ sky130_fd_sc_hd__mux2_1
XFILLER_0_112_672 VGND VGND VPWR VPWR sky130_fd_sc_hd__decap_3
XFILLER_0_78_92 VGND VGND VPWR VPWR sky130_fd_sc_hd__decap_6
X_06058_ _00998_ _01001_ _00997_ VGND VGND VPWR VPWR _01008_ sky130_fd_sc_hd__o21ai_2
XTAP_TAPCELL_ROW_6_335 VGND VPWR sky130_fd_sc_hd__tapvpwrvgnd_1
XFILLER_0_1_391 VGND VGND VPWR VPWR sky130_fd_sc_hd__fill_1
XTAP_TAPCELL_ROW_70_1133 VGND VPWR sky130_fd_sc_hd__tapvpwrvgnd_1
XTAP_TAPCELL_ROW_109_1619 VGND VPWR sky130_fd_sc_hd__tapvpwrvgnd_1
X_09817_ _03228_ _04516_ VGND VGND VPWR VPWR _04539_ sky130_fd_sc_hd__nand2_2
X_09748_ tanh_inst.divider.y\[-2\] _02014_ VGND VGND VPWR VPWR _04472_ sky130_fd_sc_hd__or2_2
XFILLER_0_68_103 VGND VGND VPWR VPWR sky130_fd_sc_hd__decap_8
X_09679_ _02019_ _04403_ _04404_ _02015_ VGND VGND VPWR VPWR _04405_ sky130_fd_sc_hd__a211o_2
XTAP_TAPCELL_ROW_53_930 VGND VPWR sky130_fd_sc_hd__tapvpwrvgnd_1
XTAP_TAPCELL_ROW_81_1273 VGND VPWR sky130_fd_sc_hd__tapvpwrvgnd_1
XFILLER_0_119_293 VPWR VGND VPWR VGND sky130_ef_sc_hd__decap_12
XFILLER_0_37_578 VGND VGND VPWR VPWR sky130_fd_sc_hd__fill_1
XFILLER_0_91_194 VGND VGND VPWR VPWR sky130_fd_sc_hd__fill_2
X_10454_ clknet_leaf_8_clk _00311_ VGND VGND VPWR VPWR tanh_inst.divider.y\[-10\]
+ sky130_fd_sc_hd__dfxtp_2
XFILLER_0_32_250 VGND VGND VPWR VPWR sky130_fd_sc_hd__fill_2
X_10385_ clknet_leaf_7_clk _00242_ VGND VGND VPWR VPWR tanh_inst.divider.x\[-15\]
+ sky130_fd_sc_hd__dfxtp_2
XFILLER_0_20_445 VGND VGND VPWR VPWR sky130_fd_sc_hd__decap_4
XFILLER_0_90_27 VGND VGND VPWR VPWR sky130_fd_sc_hd__fill_1
XFILLER_0_59_136 VPWR VGND VPWR VGND sky130_ef_sc_hd__decap_12
XFILLER_0_59_125 VGND VGND VPWR VPWR sky130_fd_sc_hd__fill_2
XFILLER_0_59_169 VGND VGND VPWR VPWR sky130_fd_sc_hd__decap_6
XFILLER_0_68_692 VGND VGND VPWR VPWR sky130_fd_sc_hd__decap_8
XTAP_TAPCELL_ROW_99_1501 VGND VPWR sky130_fd_sc_hd__tapvpwrvgnd_1
XFILLER_0_7_417 VGND VGND VPWR VPWR sky130_fd_sc_hd__fill_1
X_05360_ _00367_ VGND VGND VPWR VPWR _00368_ sky130_fd_sc_hd__inv_2
XFILLER_0_83_673 VGND VGND VPWR VPWR sky130_fd_sc_hd__decap_8
XFILLER_0_15_217 VGND VGND VPWR VPWR sky130_fd_sc_hd__decap_6
XFILLER_0_28_578 VGND VGND VPWR VPWR sky130_fd_sc_hd__decap_3
XFILLER_0_28_589 VGND VGND VPWR VPWR sky130_fd_sc_hd__decap_6
XTAP_TAPCELL_ROW_31_646 VGND VPWR sky130_fd_sc_hd__tapvpwrvgnd_1
XFILLER_0_3_612 VGND VGND VPWR VPWR sky130_fd_sc_hd__decap_4
X_05291_ _04874_ _04990_ mac_inst.i\[0\] VGND VGND VPWR VPWR _04991_ sky130_fd_sc_hd__mux2_1
X_07030_ tanh_inst.divider.z_\[-13\] _01862_ _01863_ VGND VGND VPWR VPWR _01865_ sky130_fd_sc_hd__and3_2
XFILLER_0_2_133 VGND VGND VPWR VPWR sky130_fd_sc_hd__decap_6
XFILLER_0_23_261 VPWR VGND VPWR VGND sky130_ef_sc_hd__decap_12
XFILLER_0_2_177 VPWR VGND VPWR VGND sky130_ef_sc_hd__decap_12
X_08981_ _03512_ _03560_ _03562_ _03558_ _04760_ tanh_inst.LOOKUP.index\[0\] VGND
+ VGND VPWR VPWR _03724_ sky130_fd_sc_hd__mux4_2
X_07932_ _02724_ _02729_ VGND VGND VPWR VPWR _02730_ sky130_fd_sc_hd__nand2_2
X_07863_ _02660_ _02661_ VGND VGND VPWR VPWR _02662_ sky130_fd_sc_hd__nor2_2
XTAP_TAPCELL_ROW_3_305 VGND VPWR sky130_fd_sc_hd__tapvpwrvgnd_1
X_09602_ tanh_inst.z_\[7\] _04329_ VGND VGND VPWR VPWR _04330_ sky130_fd_sc_hd__nand2_2
X_06814_ _01689_ _01694_ _01699_ VGND VGND VPWR VPWR _01707_ sky130_fd_sc_hd__and3_2
X_07794_ _02535_ _02537_ _02593_ VGND VGND VPWR VPWR _02595_ sky130_fd_sc_hd__o21ai_2
X_09533_ _04197_ _04199_ _04261_ VGND VGND VPWR VPWR _04263_ sky130_fd_sc_hd__nor3_2
XTAP_TAPCELL_ROW_39_746 VGND VPWR sky130_fd_sc_hd__tapvpwrvgnd_1
XFILLER_0_78_445 VGND VGND VPWR VPWR sky130_fd_sc_hd__fill_1
X_06745_ _01502_ _01644_ _01645_ _01469_ mac_y_out[14] VGND VGND VPWR VPWR _00142_
+ sky130_fd_sc_hd__a32o_2
X_09464_ _02022_ _03912_ VGND VGND VPWR VPWR _04195_ sky130_fd_sc_hd__nor2_2
X_06676_ tanh_inst.z_\[-17\] _01582_ VGND VGND VPWR VPWR _01584_ sky130_fd_sc_hd__or2_2
XFILLER_0_38_309 VPWR VGND VPWR VGND sky130_ef_sc_hd__decap_12
X_09395_ _02018_ _04127_ _04128_ _02015_ VGND VGND VPWR VPWR _04129_ sky130_fd_sc_hd__a31o_2
XFILLER_0_65_139 VGND VGND VPWR VPWR sky130_fd_sc_hd__decap_3
XFILLER_0_65_117 VGND VGND VPWR VPWR sky130_fd_sc_hd__fill_1
XFILLER_0_59_681 VGND VGND VPWR VPWR sky130_fd_sc_hd__fill_2
X_05627_ _00610_ _00612_ VGND VGND VPWR VPWR _00613_ sky130_fd_sc_hd__nor2_2
X_08415_ tanh_inst.divider.x\[0\] _03199_ VGND VGND VPWR VPWR _03201_ sky130_fd_sc_hd__nor2_2
XFILLER_0_58_191 VGND VGND VPWR VPWR sky130_fd_sc_hd__decap_4
X_08346_ _03047_ _03097_ VGND VGND VPWR VPWR _03134_ sky130_fd_sc_hd__and2_2
XFILLER_0_61_312 VGND VGND VPWR VPWR sky130_fd_sc_hd__decap_8
XFILLER_0_19_589 VGND VGND VPWR VPWR sky130_fd_sc_hd__fill_1
X_05558_ _00546_ _00550_ VGND VGND VPWR VPWR _05558_/Y sky130_fd_sc_hd__xnor2_2
X_05489_ mac_inst.i\[3\] _00389_ _00486_ _04911_ VGND VGND VPWR VPWR _00487_ sky130_fd_sc_hd__o211a_2
X_08277_ tanh_inst.z_\[7\] _03044_ _03045_ _03065_ _03066_ VGND VGND VPWR VPWR _03067_
+ sky130_fd_sc_hd__a32o_2
XFILLER_0_46_397 VGND VGND VPWR VPWR sky130_fd_sc_hd__fill_1
X_07228_ _02031_ _02035_ _02037_ _02033_ _04760_ _04761_ VGND VGND VPWR VPWR _02038_
+ sky130_fd_sc_hd__mux4_2
X_07159_ tanh_inst.divider.z_\[2\] _01975_ VGND VGND VPWR VPWR _01979_ sky130_fd_sc_hd__nand2_2
XFILLER_0_104_458 VGND VGND VPWR VPWR sky130_fd_sc_hd__fill_2
XTAP_TAPCELL_ROW_83_1302 VGND VPWR sky130_fd_sc_hd__tapvpwrvgnd_1
XFILLER_0_69_434 VPWR VGND VPWR VGND sky130_ef_sc_hd__decap_12
XPHY_EDGE_ROW_69_Right_69 VGND VGND VPWR VPWR sky130_fd_sc_hd__decap_3
XFILLER_0_56_106 VGND VGND VPWR VPWR sky130_fd_sc_hd__fill_1
XFILLER_0_108_720 VGND VGND VPWR VPWR sky130_fd_sc_hd__decap_4
XFILLER_0_56_139 VGND VGND VPWR VPWR sky130_fd_sc_hd__fill_1
XFILLER_0_65_673 VGND VGND VPWR VPWR sky130_fd_sc_hd__fill_2
XFILLER_0_37_386 VGND VGND VPWR VPWR sky130_fd_sc_hd__decap_6
XFILLER_0_12_209 VPWR VGND VPWR VGND sky130_ef_sc_hd__decap_12
XTAP_TAPCELL_ROW_94_1431 VGND VPWR sky130_fd_sc_hd__tapvpwrvgnd_1
X_10437_ clknet_leaf_35_clk _00294_ _00000_ VGND VGND VPWR VPWR mac_inst.i\[29\] sky130_fd_sc_hd__dfrtp_2
XTAP_TAPCELL_ROW_94_1442 VGND VPWR sky130_fd_sc_hd__tapvpwrvgnd_1
XPHY_EDGE_ROW_78_Right_78 VGND VGND VPWR VPWR sky130_fd_sc_hd__decap_3
X_10368_ clknet_leaf_16_clk _00225_ VGND VGND VPWR VPWR tanh_inst.divider.z_\[4\]
+ sky130_fd_sc_hd__dfxtp_2
XFILLER_0_20_253 VPWR VGND VPWR VGND sky130_ef_sc_hd__decap_12
X_10299_ clknet_leaf_22_clk _00156_ VGND VGND VPWR VPWR tanh_inst.z_\[4\] sky130_fd_sc_hd__dfxtp_2
XFILLER_0_18_65 VPWR VGND VPWR VGND sky130_ef_sc_hd__decap_12
XTAP_TAPCELL_ROW_36_716 VGND VPWR sky130_fd_sc_hd__tapvpwrvgnd_1
X_06530_ _01446_ _01447_ VGND VGND VPWR VPWR _01448_ sky130_fd_sc_hd__nor2_2
XPHY_EDGE_ROW_87_Right_87 VGND VGND VPWR VPWR sky130_fd_sc_hd__decap_3
X_06461_ _01088_ _01382_ _01383_ _01384_ VGND VGND VPWR VPWR _00109_ sky130_fd_sc_hd__a31o_2
XFILLER_0_87_297 VGND VGND VPWR VPWR sky130_fd_sc_hd__fill_1
XFILLER_0_75_426 VGND VGND VPWR VPWR sky130_fd_sc_hd__fill_1
XTAP_TAPCELL_ROW_16_462 VGND VPWR sky130_fd_sc_hd__tapvpwrvgnd_1
X_05412_ mac_inst.i\[2\] _00347_ _00415_ VGND VGND VPWR VPWR _00416_ sky130_fd_sc_hd__a21o_2
XFILLER_0_28_331 VGND VGND VPWR VPWR sky130_fd_sc_hd__decap_8
X_08200_ _02991_ VGND VGND VPWR VPWR _02992_ sky130_fd_sc_hd__inv_2
X_06392_ _01299_ _01310_ VGND VGND VPWR VPWR _01321_ sky130_fd_sc_hd__or2_2
X_09180_ _03913_ _03915_ _03918_ _02053_ VGND VGND VPWR VPWR _03919_ sky130_fd_sc_hd__a22o_2
XFILLER_0_7_225 VPWR VGND VPWR VGND sky130_ef_sc_hd__decap_12
X_08131_ _02052_ _02138_ _02833_ VGND VGND VPWR VPWR _02924_ sky130_fd_sc_hd__a21oi_2
X_05343_ _04871_ _04874_ _04876_ _04990_ mac_inst.i\[1\] mac_inst.i\[0\] VGND VGND
+ VPWR VPWR _00351_ sky130_fd_sc_hd__mux4_2
XFILLER_0_50_52 VGND VGND VPWR VPWR sky130_fd_sc_hd__fill_2
X_08062_ _04791_ _02847_ _02855_ _02856_ VGND VGND VPWR VPWR _02857_ sky130_fd_sc_hd__o22a_2
XFILLER_0_70_153 VGND VGND VPWR VPWR sky130_fd_sc_hd__decap_6
X_05274_ mac_inst.i\[30\] _04956_ _04969_ _04972_ _04974_ VGND VGND VPWR VPWR _04975_
+ sky130_fd_sc_hd__o2111ai_2
X_07013_ tanh_inst.divider.i\[4\] tanh_inst.divider.y_\[7\] _01847_ tanh_inst.divider.z_\[-15\]
+ VGND VGND VPWR VPWR _01850_ sky130_fd_sc_hd__a211o_2
XPHY_EDGE_ROW_96_Right_96 VGND VGND VPWR VPWR sky130_fd_sc_hd__decap_3
XFILLER_0_70_197 VPWR VGND VPWR VGND sky130_ef_sc_hd__decap_12
XFILLER_0_113_288 VGND VGND VPWR VPWR sky130_fd_sc_hd__decap_8
XFILLER_0_113_277 VGND VGND VPWR VPWR sky130_fd_sc_hd__decap_3
XFILLER_0_101_417 VGND VGND VPWR VPWR sky130_fd_sc_hd__fill_1
X_08964_ _01478_ _03533_ _03577_ _02109_ _01476_ VGND VGND VPWR VPWR _03708_ sky130_fd_sc_hd__o221a_2
X_07915_ _02711_ _02712_ VGND VGND VPWR VPWR _02713_ sky130_fd_sc_hd__nor2_2
X_08895_ _01482_ _03595_ VGND VGND VPWR VPWR _03640_ sky130_fd_sc_hd__or2_2
X_07846_ tanh_inst.z_\[7\] _02645_ VGND VGND VPWR VPWR _02646_ sky130_fd_sc_hd__nor2_2
X_07777_ _02022_ _02133_ _02488_ VGND VGND VPWR VPWR _02578_ sky130_fd_sc_hd__o21ai_2
XFILLER_0_78_231 VPWR VGND VPWR VGND sky130_ef_sc_hd__decap_12
X_09516_ _04244_ _04245_ VGND VGND VPWR VPWR _04246_ sky130_fd_sc_hd__nand2_2
X_06728_ _01521_ _01629_ VGND VGND VPWR VPWR _01630_ sky130_fd_sc_hd__xnor2_2
X_09447_ _04176_ _04177_ VGND VGND VPWR VPWR _04179_ sky130_fd_sc_hd__xnor2_2
XFILLER_0_93_223 VGND VGND VPWR VPWR sky130_fd_sc_hd__fill_1
XFILLER_0_109_517 VGND VGND VPWR VPWR sky130_fd_sc_hd__fill_2
X_06659_ _01564_ _01566_ _01567_ VGND VGND VPWR VPWR _01569_ sky130_fd_sc_hd__o21ai_2
XTAP_TAPCELL_ROW_65_1076 VGND VPWR sky130_fd_sc_hd__tapvpwrvgnd_1
X_09378_ _04110_ _04111_ VGND VGND VPWR VPWR _04112_ sky130_fd_sc_hd__nand2_2
XFILLER_0_93_289 VGND VGND VPWR VPWR sky130_fd_sc_hd__decap_8
XFILLER_0_93_267 VGND VGND VPWR VPWR sky130_fd_sc_hd__decap_4
XFILLER_0_46_161 VPWR VGND VPWR VGND sky130_ef_sc_hd__decap_12
XFILLER_0_117_561 VGND VGND VPWR VPWR sky130_fd_sc_hd__decap_6
X_08329_ _02019_ _03107_ _03117_ VGND VGND VPWR VPWR _03118_ sky130_fd_sc_hd__a21o_2
XTAP_TAPCELL_ROW_117_1729 VGND VPWR sky130_fd_sc_hd__tapvpwrvgnd_1
XFILLER_0_30_540 VGND VGND VPWR VPWR sky130_fd_sc_hd__decap_3
X_10222_ clknet_leaf_27_clk mac_inst.y\[16\] _00000_ VGND VGND VPWR VPWR mac_y_out[16]
+ sky130_fd_sc_hd__dfrtp_2
XFILLER_0_100_450 VPWR VGND VPWR VGND sky130_ef_sc_hd__decap_12
X_10084_ clknet_leaf_5_clk _00101_ VGND VGND VPWR VPWR tanh_inst.divider.y_\[-9\]
+ sky130_fd_sc_hd__dfxtp_2
XFILLER_0_84_245 VGND VGND VPWR VPWR sky130_fd_sc_hd__decap_6
XFILLER_0_29_139 VGND VGND VPWR VPWR sky130_fd_sc_hd__decap_4
XTAP_TAPCELL_ROW_13_421 VGND VPWR sky130_fd_sc_hd__tapvpwrvgnd_1
XFILLER_0_44_109 VGND VGND VPWR VPWR sky130_fd_sc_hd__fill_1
XTAP_TAPCELL_ROW_41_774 VGND VPWR sky130_fd_sc_hd__tapvpwrvgnd_1
XFILLER_0_80_440 VGND VGND VPWR VPWR sky130_fd_sc_hd__decap_6
XFILLER_0_111_57 VPWR VGND VPWR VGND sky130_ef_sc_hd__decap_12
XFILLER_0_20_77 VGND VGND VPWR VPWR sky130_fd_sc_hd__decap_6
XFILLER_0_25_378 VGND VGND VPWR VPWR sky130_fd_sc_hd__decap_4
XFILLER_0_96_15 VPWR VGND VPWR VGND sky130_ef_sc_hd__decap_12
XFILLER_0_52_197 VGND VGND VPWR VPWR sky130_fd_sc_hd__fill_2
XFILLER_0_110_258 VGND VGND VPWR VPWR sky130_fd_sc_hd__fill_1
XFILLER_0_0_489 VGND VGND VPWR VPWR sky130_fd_sc_hd__fill_2
X_07700_ _02501_ _02502_ VGND VGND VPWR VPWR _02503_ sky130_fd_sc_hd__xnor2_2
X_05961_ _00903_ _00908_ _00902_ VGND VGND VPWR VPWR _00919_ sky130_fd_sc_hd__a21bo_2
XFILLER_0_29_97 VGND VGND VPWR VPWR sky130_fd_sc_hd__fill_2
X_08680_ tanh_inst.divider.x\[5\] _03404_ _03418_ VGND VGND VPWR VPWR _03460_ sky130_fd_sc_hd__a21oi_2
X_05892_ mac_inst.z\[16\] _00852_ VGND VGND VPWR VPWR _00855_ sky130_fd_sc_hd__nand2_2
X_07631_ _02027_ _02048_ _02207_ _02024_ VGND VGND VPWR VPWR _02435_ sky130_fd_sc_hd__a211o_2
XTAP_TAPCELL_ROW_49_874 VGND VPWR sky130_fd_sc_hd__tapvpwrvgnd_1
XFILLER_0_88_540 VGND VGND VPWR VPWR sky130_fd_sc_hd__fill_2
X_07562_ tanh_inst.LOOKUP.index\[2\] _02115_ _02313_ tanh_inst.LOOKUP.index\[3\] VGND
+ VGND VPWR VPWR _02368_ sky130_fd_sc_hd__o211a_2
XFILLER_0_45_85 VGND VGND VPWR VPWR sky130_fd_sc_hd__fill_2
X_09301_ _04035_ _04036_ VGND VGND VPWR VPWR _04037_ sky130_fd_sc_hd__nand2_2
X_06513_ _01430_ _01431_ VGND VGND VPWR VPWR _01432_ sky130_fd_sc_hd__xnor2_2
XFILLER_0_75_212 VGND VGND VPWR VPWR sky130_fd_sc_hd__decap_4
XTAP_TAPCELL_ROW_101_1519 VGND VPWR sky130_fd_sc_hd__tapvpwrvgnd_1
X_07493_ tanh_inst.divider.y\[-21\] tanh_inst.divider.x\[-21\] VGND VGND VPWR VPWR
+ _02300_ sky130_fd_sc_hd__or2_2
XFILLER_0_48_459 VGND VGND VPWR VPWR sky130_fd_sc_hd__fill_2
X_06444_ _01367_ _01368_ VGND VGND VPWR VPWR _01369_ sky130_fd_sc_hd__xnor2_2
X_09232_ _02551_ _03955_ VGND VGND VPWR VPWR _03970_ sky130_fd_sc_hd__and2_2
XFILLER_0_90_204 VGND VGND VPWR VPWR sky130_fd_sc_hd__fill_2
XFILLER_0_29_673 VGND VGND VPWR VPWR sky130_fd_sc_hd__decap_6
X_06375_ _01294_ _01296_ _01293_ VGND VGND VPWR VPWR _01306_ sky130_fd_sc_hd__a21o_2
X_09163_ tanh_inst.divider.y\[-18\] _03902_ VGND VGND VPWR VPWR _03903_ sky130_fd_sc_hd__nand2_2
XFILLER_0_8_589 VGND VGND VPWR VPWR sky130_fd_sc_hd__decap_4
XFILLER_0_16_301 VGND VGND VPWR VPWR sky130_fd_sc_hd__decap_6
XFILLER_0_29_695 VGND VGND VPWR VPWR sky130_fd_sc_hd__decap_6
XFILLER_0_90_259 VPWR VGND VPWR VGND sky130_ef_sc_hd__decap_12
X_08114_ tanh_inst.divider.x\[-10\] _02824_ _02862_ tanh_inst.divider.x\[-9\] VGND
+ VGND VPWR VPWR _02908_ sky130_fd_sc_hd__a22o_2
XFILLER_0_16_345 VGND VGND VPWR VPWR sky130_fd_sc_hd__decap_6
X_05326_ mac_inst.i\[1\] _04853_ _04903_ _04904_ VGND VGND VPWR VPWR _05025_ sky130_fd_sc_hd__or4_2
X_09094_ _02408_ _03834_ VGND VGND VPWR VPWR _03835_ sky130_fd_sc_hd__and2_2
XFILLER_0_71_473 VGND VGND VPWR VPWR sky130_fd_sc_hd__fill_1
XFILLER_0_31_304 VGND VGND VPWR VPWR sky130_fd_sc_hd__decap_6
XFILLER_0_31_315 VGND VGND VPWR VPWR sky130_fd_sc_hd__decap_6
XFILLER_0_43_164 VGND VGND VPWR VPWR sky130_fd_sc_hd__decap_4
XFILLER_0_114_586 VGND VGND VPWR VPWR sky130_fd_sc_hd__fill_2
X_08045_ tanh_inst.divider.y\[-9\] _02839_ VGND VGND VPWR VPWR _02840_ sky130_fd_sc_hd__nor2_2
XFILLER_0_12_540 VGND VGND VPWR VPWR sky130_fd_sc_hd__decap_3
XFILLER_0_3_261 VPWR VGND VPWR VGND sky130_ef_sc_hd__decap_12
X_05257_ mac_inst.i\[23\] mac_inst.i\[25\] mac_inst.i\[31\] VGND VGND VPWR VPWR _04958_
+ sky130_fd_sc_hd__nand3_2
XFILLER_0_31_337 VGND VGND VPWR VPWR sky130_fd_sc_hd__decap_8
X_05188_ _04884_ _04886_ _04888_ _04890_ _04783_ mac_inst.i\[1\] VGND VGND VPWR VPWR
+ _04892_ sky130_fd_sc_hd__mux4_2
XTAP_TAPCELL_ROW_112_1659 VGND VPWR sky130_fd_sc_hd__tapvpwrvgnd_1
XFILLER_0_86_70 VGND VGND VPWR VPWR sky130_fd_sc_hd__fill_1
X_09996_ _04710_ _04711_ VGND VGND VPWR VPWR _04712_ sky130_fd_sc_hd__xnor2_2
X_08947_ _03689_ _03690_ VGND VGND VPWR VPWR _03691_ sky130_fd_sc_hd__and2_2
X_08878_ _02168_ _03612_ _03613_ VGND VGND VPWR VPWR _03623_ sky130_fd_sc_hd__and3_2
X_07829_ _02547_ _02550_ _02628_ VGND VGND VPWR VPWR _02629_ sky130_fd_sc_hd__a21o_2
XTAP_TAPCELL_ROW_67_1105 VGND VPWR sky130_fd_sc_hd__tapvpwrvgnd_1
XFILLER_0_79_584 VGND VGND VPWR VPWR sky130_fd_sc_hd__decap_6
XFILLER_0_66_223 VGND VGND VPWR VPWR sky130_fd_sc_hd__fill_1
XFILLER_0_81_237 VPWR VGND VPWR VGND sky130_ef_sc_hd__decap_12
XFILLER_0_19_161 VGND VGND VPWR VPWR sky130_fd_sc_hd__decap_6
XFILLER_0_35_654 VGND VGND VPWR VPWR sky130_fd_sc_hd__decap_3
XTAP_TAPCELL_ROW_78_1234 VGND VPWR sky130_fd_sc_hd__tapvpwrvgnd_1
XFILLER_0_120_512 VGND VGND VPWR VPWR sky130_fd_sc_hd__decap_3
XFILLER_0_34_197 VGND VGND VPWR VPWR sky130_fd_sc_hd__decap_4
XTAP_TAPCELL_ROW_91_1401 VGND VPWR sky130_fd_sc_hd__tapvpwrvgnd_1
XFILLER_0_120_589 VGND VGND VPWR VPWR sky130_fd_sc_hd__decap_8
XFILLER_0_120_578 VGND VGND VPWR VPWR sky130_fd_sc_hd__decap_3
X_10205_ x_in[31] _00000_ VGND VGND VPWR VPWR mac_inst.x\[31\] sky130_fd_sc_hd__dlxtn_1
X_10067_ clknet_leaf_33_clk _05032_ _00066_ VGND VGND VPWR VPWR done sky130_fd_sc_hd__dfrtp_2
Xclkbuf_2_3__f_clk clknet_0_clk VGND VGND VPWR VPWR clknet_2_3__leaf_clk sky130_fd_sc_hd__clkbuf_16
XTAP_TAPCELL_ROW_89_1374 VGND VPWR sky130_fd_sc_hd__tapvpwrvgnd_1
XTAP_TAPCELL_ROW_46_833 VGND VPWR sky130_fd_sc_hd__tapvpwrvgnd_1
XFILLER_0_15_55 VGND VGND VPWR VPWR sky130_fd_sc_hd__fill_1
XFILLER_0_57_223 VGND VGND VPWR VPWR sky130_fd_sc_hd__fill_1
XFILLER_0_57_278 VGND VGND VPWR VPWR sky130_fd_sc_hd__fill_2
XTAP_TAPCELL_ROW_26_590 VGND VPWR sky130_fd_sc_hd__tapvpwrvgnd_1
XFILLER_0_72_226 VGND VGND VPWR VPWR sky130_fd_sc_hd__decap_3
XFILLER_0_57_289 VPWR VGND VPWR VGND sky130_ef_sc_hd__decap_12
XFILLER_0_38_492 VGND VGND VPWR VPWR sky130_fd_sc_hd__decap_8
XFILLER_0_110_3 VPWR VGND VPWR VGND sky130_ef_sc_hd__decap_12
X_06160_ _01103_ _01104_ tanh_inst.divider.i\[2\] VGND VGND VPWR VPWR _01105_ sky130_fd_sc_hd__mux2_1
X_06091_ _04776_ tanh_inst.divider.i\[3\] VGND VGND VPWR VPWR _01038_ sky130_fd_sc_hd__and2_2
XFILLER_0_13_337 VPWR VGND VPWR VGND sky130_ef_sc_hd__decap_12
X_05111_ _04822_ VGND VGND VPWR VPWR _04823_ sky130_fd_sc_hd__inv_2
XFILLER_0_53_495 VGND VGND VPWR VPWR sky130_fd_sc_hd__decap_8
X_05042_ tanh_inst.divider.y\[-14\] VGND VGND VPWR VPWR _04766_ sky130_fd_sc_hd__inv_2
XFILLER_0_111_523 VPWR VGND VPWR VGND sky130_ef_sc_hd__decap_12
XFILLER_0_1_721 VGND VGND VPWR VPWR sky130_fd_sc_hd__decap_3
XFILLER_0_0_253 VPWR VGND VPWR VGND sky130_ef_sc_hd__decap_12
X_09850_ _04510_ _04513_ _04569_ _02019_ VGND VGND VPWR VPWR _04571_ sky130_fd_sc_hd__a31o_2
X_06993_ tanh_inst.divider.y_\[7\] _01831_ VGND VGND VPWR VPWR _01832_ sky130_fd_sc_hd__or2_2
X_08801_ tanh_inst.divider.x\[3\] _02028_ _03508_ VGND VGND VPWR VPWR _03547_ sky130_fd_sc_hd__o21a_2
X_09781_ _04369_ _04432_ _04502_ VGND VGND VPWR VPWR _04503_ sky130_fd_sc_hd__or3_2
X_05944_ mac_inst.z\[20\] _00901_ VGND VGND VPWR VPWR _00903_ sky130_fd_sc_hd__xor2_2
X_08732_ mac_inst.i\[15\] mac_inst.i\[14\] _00962_ VGND VGND VPWR VPWR _03495_ sky130_fd_sc_hd__and3_2
X_08663_ _03431_ _03432_ _03430_ VGND VGND VPWR VPWR _03443_ sky130_fd_sc_hd__a21boi_2
X_05875_ mac_inst.z\[31\] _00825_ _00838_ VGND VGND VPWR VPWR _00839_ sky130_fd_sc_hd__o21ai_2
XFILLER_0_15_3 VPWR VGND VPWR VGND sky130_ef_sc_hd__decap_12
XFILLER_0_95_329 VGND VGND VPWR VPWR sky130_fd_sc_hd__fill_2
XFILLER_0_88_370 VGND VGND VPWR VPWR sky130_fd_sc_hd__decap_6
X_07614_ tanh_inst.divider.y\[7\] _02181_ _02183_ _02179_ _04758_ _04759_ VGND VGND
+ VPWR VPWR _02419_ sky130_fd_sc_hd__mux4_2
X_08594_ _03258_ _03305_ _03306_ _03343_ VGND VGND VPWR VPWR _03376_ sky130_fd_sc_hd__and4_2
X_07545_ _02289_ _02291_ _02349_ VGND VGND VPWR VPWR _02351_ sky130_fd_sc_hd__a21bo_2
XFILLER_0_48_234 VGND VGND VPWR VPWR sky130_fd_sc_hd__fill_1
X_07476_ _02082_ _02086_ _02089_ _02084_ _04760_ _04761_ VGND VGND VPWR VPWR _02283_
+ sky130_fd_sc_hd__mux4_2
XTAP_TAPCELL_ROW_62_1035 VGND VPWR sky130_fd_sc_hd__tapvpwrvgnd_1
XFILLER_0_118_133 VGND VGND VPWR VPWR sky130_fd_sc_hd__decap_6
X_06427_ _01351_ _01353_ VGND VGND VPWR VPWR _01354_ sky130_fd_sc_hd__nor2_2
X_09215_ _03911_ _03953_ _01469_ VGND VGND VPWR VPWR _00304_ sky130_fd_sc_hd__a21oi_2
XFILLER_0_29_481 VGND VGND VPWR VPWR sky130_fd_sc_hd__fill_2
X_06358_ _01039_ _01188_ _01192_ _01031_ _01289_ VGND VGND VPWR VPWR _01290_ sky130_fd_sc_hd__o221a_2
X_09146_ _03868_ _03884_ VGND VGND VPWR VPWR _03886_ sky130_fd_sc_hd__or2_2
XFILLER_0_16_153 VPWR VGND VPWR VGND sky130_ef_sc_hd__decap_12
XFILLER_0_17_698 VGND VGND VPWR VPWR sky130_fd_sc_hd__decap_4
X_06289_ tanh_inst.divider.i\[3\] _01098_ _01187_ VGND VGND VPWR VPWR _01226_ sky130_fd_sc_hd__o21ai_2
X_09077_ tanh_inst.divider.y\[-20\] _03818_ VGND VGND VPWR VPWR _03819_ sky130_fd_sc_hd__and2_2
XFILLER_0_16_197 VPWR VGND VPWR VGND sky130_ef_sc_hd__decap_12
X_05309_ _04925_ _04926_ mac_inst.z\[31\] VGND VGND VPWR VPWR _05009_ sky130_fd_sc_hd__a21oi_2
XFILLER_0_114_394 VGND VGND VPWR VPWR sky130_fd_sc_hd__fill_1
X_08028_ _02820_ _02823_ VGND VGND VPWR VPWR _02824_ sky130_fd_sc_hd__xnor2_2
XFILLER_0_102_589 VGND VGND VPWR VPWR sky130_fd_sc_hd__decap_4
XTAP_TAPCELL_ROW_73_1175 VGND VPWR sky130_fd_sc_hd__tapvpwrvgnd_1
XFILLER_0_12_392 VGND VGND VPWR VPWR sky130_fd_sc_hd__fill_2
X_09979_ tanh_inst.LOOKUP.index\[4\] _04149_ _04213_ VGND VGND VPWR VPWR _04696_ sky130_fd_sc_hd__o21a_2
XPHY_EDGE_ROW_105_Right_105 VGND VGND VPWR VPWR sky130_fd_sc_hd__decap_3
XTAP_TAPCELL_ROW_43_803 VGND VPWR sky130_fd_sc_hd__tapvpwrvgnd_1
XFILLER_0_109_111 VGND VGND VPWR VPWR sky130_fd_sc_hd__fill_1
XFILLER_0_94_340 VGND VGND VPWR VPWR sky130_fd_sc_hd__decap_4
XFILLER_0_82_502 VGND VGND VPWR VPWR sky130_fd_sc_hd__decap_8
XFILLER_0_67_565 VGND VGND VPWR VPWR sky130_fd_sc_hd__fill_1
XFILLER_0_109_177 VGND VGND VPWR VPWR sky130_fd_sc_hd__fill_1
XFILLER_0_112_309 VGND VGND VPWR VPWR sky130_fd_sc_hd__fill_1
XFILLER_0_2_529 VGND VGND VPWR VPWR sky130_fd_sc_hd__decap_3
XFILLER_0_50_421 VPWR VGND VPWR VGND sky130_ef_sc_hd__decap_12
XFILLER_0_10_307 VGND VGND VPWR VPWR sky130_fd_sc_hd__fill_1
XFILLER_0_22_189 VGND VGND VPWR VPWR sky130_fd_sc_hd__decap_6
XFILLER_0_93_27 VPWR VGND VPWR VGND sky130_ef_sc_hd__decap_12
X_05660_ _00598_ _00623_ _00641_ _00642_ VGND VGND VPWR VPWR _00643_ sky130_fd_sc_hd__o31a_2
X_05591_ mac_inst.y\[22\] _00578_ VGND VGND VPWR VPWR _00580_ sky130_fd_sc_hd__xor2_2
X_07330_ _02022_ _02136_ _02137_ _02053_ VGND VGND VPWR VPWR _02139_ sky130_fd_sc_hd__o211ai_2
XFILLER_0_85_373 VGND VGND VPWR VPWR sky130_fd_sc_hd__decap_8
XTAP_TAPCELL_ROW_21_519 VGND VPWR sky130_fd_sc_hd__tapvpwrvgnd_1
XFILLER_0_116_637 VGND VGND VPWR VPWR sky130_fd_sc_hd__decap_6
X_09000_ _04773_ _03686_ _03685_ VGND VGND VPWR VPWR _03743_ sky130_fd_sc_hd__a21oi_2
XFILLER_0_73_557 VGND VGND VPWR VPWR sky130_fd_sc_hd__decap_3
X_07261_ tanh_inst.divider.y\[3\] _02028_ _02029_ VGND VGND VPWR VPWR _02071_ sky130_fd_sc_hd__o21a_2
X_07192_ _01999_ _02005_ _02006_ _02007_ _01088_ VGND VGND VPWR VPWR _02008_ sky130_fd_sc_hd__o311a_2
XFILLER_0_115_125 VPWR VGND VPWR VGND sky130_ef_sc_hd__decap_12
X_06212_ _01152_ _01153_ VGND VGND VPWR VPWR _01155_ sky130_fd_sc_hd__nand2_2
XFILLER_0_60_218 VPWR VGND VPWR VGND sky130_ef_sc_hd__decap_12
X_06143_ tanh_inst.div_en _01059_ VGND VGND VPWR VPWR _01089_ sky130_fd_sc_hd__or2_2
XFILLER_0_53_281 VGND VGND VPWR VPWR sky130_fd_sc_hd__decap_8
XFILLER_0_13_167 VGND VGND VPWR VPWR sky130_fd_sc_hd__fill_1
XFILLER_0_41_476 VPWR VGND VPWR VGND sky130_ef_sc_hd__decap_12
X_06074_ _01019_ _01020_ tanh_inst.divider.i\[2\] VGND VGND VPWR VPWR _01021_ sky130_fd_sc_hd__mux2_1
XFILLER_0_6_53 VPWR VGND VPWR VGND sky130_ef_sc_hd__decap_12
X_09902_ _04592_ _04595_ _04620_ VGND VGND VPWR VPWR _04621_ sky130_fd_sc_hd__o21ai_2
XFILLER_0_6_97 VPWR VGND VPWR VGND sky130_ef_sc_hd__decap_12
X_09833_ _04552_ _04553_ VGND VGND VPWR VPWR _04554_ sky130_fd_sc_hd__or2_2
X_06976_ _01808_ _01813_ _01815_ VGND VGND VPWR VPWR _01817_ sky130_fd_sc_hd__or3_2
X_09764_ _04454_ _04457_ _04485_ VGND VGND VPWR VPWR _04487_ sky130_fd_sc_hd__o21ai_2
XTAP_TAPCELL_ROW_29_619 VGND VPWR sky130_fd_sc_hd__tapvpwrvgnd_1
X_05927_ _00855_ _00871_ _00873_ VGND VGND VPWR VPWR _00888_ sky130_fd_sc_hd__o21ai_2
X_08715_ mac_inst.i\[3\] _00954_ mac_inst.i\[4\] VGND VGND VPWR VPWR _03489_ sky130_fd_sc_hd__a21oi_2
X_09695_ _03099_ _03100_ _04407_ VGND VGND VPWR VPWR _04420_ sky130_fd_sc_hd__and3_2
XFILLER_0_95_104 VGND VGND VPWR VPWR sky130_fd_sc_hd__decap_8
XFILLER_0_68_307 VGND VGND VPWR VPWR sky130_fd_sc_hd__fill_1
X_08646_ tanh_inst.LOOKUP.index\[4\] _02773_ _02859_ VGND VGND VPWR VPWR _03427_ sky130_fd_sc_hd__o21a_2
X_05858_ _04944_ _00822_ VGND VGND VPWR VPWR _00823_ sky130_fd_sc_hd__or2_2
XTAP_TAPCELL_ROW_1_277 VGND VPWR sky130_fd_sc_hd__tapvpwrvgnd_1
XFILLER_0_49_521 VGND VGND VPWR VPWR sky130_fd_sc_hd__fill_1
X_08577_ tanh_inst.divider.x\[4\] _03357_ VGND VGND VPWR VPWR _03359_ sky130_fd_sc_hd__nor2_2
X_05789_ _04781_ _04782_ VGND VGND VPWR VPWR _00759_ sky130_fd_sc_hd__nor2_2
XTAP_TAPCELL_ROW_120_1758 VGND VPWR sky130_fd_sc_hd__tapvpwrvgnd_1
X_07528_ tanh_inst.divider.x\[-21\] _02015_ _02309_ _02334_ VGND VGND VPWR VPWR _02335_
+ sky130_fd_sc_hd__o2bb2a_2
XFILLER_0_76_384 VGND VGND VPWR VPWR sky130_fd_sc_hd__fill_1
XFILLER_0_107_626 VGND VGND VPWR VPWR sky130_fd_sc_hd__fill_1
X_07459_ _02265_ _02264_ VGND VGND VPWR VPWR _02267_ sky130_fd_sc_hd__and2b_2
XFILLER_0_64_557 VPWR VGND VPWR VGND sky130_ef_sc_hd__decap_12
X_10470_ clknet_leaf_2_clk _00327_ VGND VGND VPWR VPWR tanh_inst.divider.y\[6\] sky130_fd_sc_hd__dfxtp_2
X_09129_ _03666_ _03680_ _02024_ VGND VGND VPWR VPWR _03869_ sky130_fd_sc_hd__mux2_1
XFILLER_0_32_421 VGND VGND VPWR VPWR sky130_fd_sc_hd__decap_6
XFILLER_0_44_281 VGND VGND VPWR VPWR sky130_fd_sc_hd__fill_1
XFILLER_0_114_180 VPWR VGND VPWR VGND sky130_ef_sc_hd__decap_12
XTAP_TAPCELL_ROW_75_1204 VGND VPWR sky130_fd_sc_hd__tapvpwrvgnd_1
XFILLER_0_32_498 VGND VGND VPWR VPWR sky130_fd_sc_hd__fill_1
XTAP_TAPCELL_ROW_9_377 VGND VPWR sky130_fd_sc_hd__tapvpwrvgnd_1
XFILLER_0_4_3 VPWR VGND VPWR VGND sky130_ef_sc_hd__decap_12
XFILLER_0_87_605 VGND VGND VPWR VPWR sky130_fd_sc_hd__decap_6
XTAP_TAPCELL_ROW_86_1333 VGND VPWR sky130_fd_sc_hd__tapvpwrvgnd_1
XFILLER_0_87_649 VGND VGND VPWR VPWR sky130_fd_sc_hd__decap_6
XTAP_TAPCELL_ROW_56_961 VGND VPWR sky130_fd_sc_hd__tapvpwrvgnd_1
XFILLER_0_55_502 VGND VGND VPWR VPWR sky130_fd_sc_hd__fill_2
XFILLER_0_94_170 VGND VGND VPWR VPWR sky130_fd_sc_hd__decap_8
XFILLER_0_82_321 VPWR VGND VPWR VGND sky130_ef_sc_hd__decap_12
XFILLER_0_6_109 VPWR VGND VPWR VGND sky130_ef_sc_hd__decap_12
XFILLER_0_27_248 VGND VGND VPWR VPWR sky130_fd_sc_hd__fill_1
XFILLER_0_88_27 VGND VGND VPWR VPWR sky130_fd_sc_hd__fill_1
XTAP_TAPCELL_ROW_97_1473 VGND VPWR sky130_fd_sc_hd__tapvpwrvgnd_1
XFILLER_0_50_251 VGND VGND VPWR VPWR sky130_fd_sc_hd__fill_1
XFILLER_0_121_640 VGND VGND VPWR VPWR sky130_fd_sc_hd__decap_4
XFILLER_0_50_273 VGND VGND VPWR VPWR sky130_fd_sc_hd__decap_3
XFILLER_0_121_673 VPWR VGND VPWR VGND sky130_ef_sc_hd__decap_12
X_06830_ _01704_ _01714_ VGND VGND VPWR VPWR _01721_ sky130_fd_sc_hd__nor2_2
X_06761_ _01658_ _01659_ VGND VGND VPWR VPWR _01660_ sky130_fd_sc_hd__and2_2
X_09480_ tanh_inst.z_\[7\] _04210_ _04204_ _04205_ VGND VGND VPWR VPWR _04211_ sky130_fd_sc_hd__a2bb2o_2
X_06692_ mac_y_out[8] _01469_ _01502_ _01598_ VGND VGND VPWR VPWR _00136_ sky130_fd_sc_hd__a22o_2
X_05712_ _00671_ _00674_ _00687_ VGND VGND VPWR VPWR _00689_ sky130_fd_sc_hd__a21o_2
X_08500_ tanh_inst.z_\[7\] _03274_ _03276_ VGND VGND VPWR VPWR _03284_ sky130_fd_sc_hd__o21a_2
XFILLER_0_77_137 VGND VGND VPWR VPWR sky130_fd_sc_hd__fill_1
X_05643_ _00510_ _00626_ VGND VGND VPWR VPWR _00627_ sky130_fd_sc_hd__nand2_2
X_08431_ _03213_ _03216_ VGND VGND VPWR VPWR _03217_ sky130_fd_sc_hd__nor2_2
XFILLER_0_92_107 VGND VGND VPWR VPWR sky130_fd_sc_hd__decap_8
XFILLER_0_77_159 VGND VGND VPWR VPWR sky130_fd_sc_hd__decap_8
XTAP_TAPCELL_ROW_106_1591 VGND VPWR sky130_fd_sc_hd__tapvpwrvgnd_1
X_08362_ _03085_ _03087_ _03149_ VGND VGND VPWR VPWR _03150_ sky130_fd_sc_hd__o21a_2
X_05574_ mac_inst.y\[19\] _00557_ _00543_ mac_inst.y\[18\] VGND VGND VPWR VPWR _00565_
+ sky130_fd_sc_hd__o211a_2
X_07313_ _02113_ _02122_ VGND VGND VPWR VPWR _02123_ sky130_fd_sc_hd__and2_2
XTAP_TAPCELL_ROW_34_688 VGND VPWR sky130_fd_sc_hd__tapvpwrvgnd_1
X_08293_ _02019_ _03067_ _03082_ _02015_ VGND VGND VPWR VPWR _03083_ sky130_fd_sc_hd__a211o_2
XFILLER_0_116_434 VGND VGND VPWR VPWR sky130_fd_sc_hd__fill_2
X_07244_ tanh_inst.divider.y\[-20\] tanh_inst.divider.y\[-19\] tanh_inst.LOOKUP.index\[0\]
+ VGND VGND VPWR VPWR _02054_ sky130_fd_sc_hd__mux2_1
XFILLER_0_6_643 VGND VGND VPWR VPWR sky130_fd_sc_hd__fill_1
XFILLER_0_82_3 VGND VGND VPWR VPWR sky130_fd_sc_hd__decap_6
XFILLER_0_61_549 VGND VGND VPWR VPWR sky130_fd_sc_hd__decap_3
X_07175_ tanh_inst.divider.z_\[4\] _01975_ VGND VGND VPWR VPWR _01993_ sky130_fd_sc_hd__and2_2
X_06126_ tanh_inst.divider.x\[7\] _01068_ _01070_ _01067_ _04777_ _04778_ VGND VGND
+ VPWR VPWR _01072_ sky130_fd_sc_hd__mux4_2
X_06057_ _01005_ _01006_ VGND VGND VPWR VPWR _01007_ sky130_fd_sc_hd__or2_2
XTAP_TAPCELL_ROW_70_1134 VGND VPWR sky130_fd_sc_hd__tapvpwrvgnd_1
XTAP_TAPCELL_ROW_6_336 VGND VPWR sky130_fd_sc_hd__tapvpwrvgnd_1
X_09816_ _03228_ _04516_ VGND VGND VPWR VPWR _04538_ sky130_fd_sc_hd__or2_2
X_06959_ tanh_inst.divider.z_\[-20\] _01800_ VGND VGND VPWR VPWR _01801_ sky130_fd_sc_hd__and2_2
X_09747_ _04446_ _04470_ _02019_ VGND VGND VPWR VPWR _04471_ sky130_fd_sc_hd__mux2_1
X_09678_ _04377_ _02018_ _04376_ VGND VGND VPWR VPWR _04404_ sky130_fd_sc_hd__and3b_2
X_08629_ _03404_ _03409_ VGND VGND VPWR VPWR _03410_ sky130_fd_sc_hd__and2_2
XTAP_TAPCELL_ROW_53_920 VGND VPWR sky130_fd_sc_hd__tapvpwrvgnd_1
XFILLER_0_119_261 VPWR VGND VPWR VGND sky130_ef_sc_hd__decap_12
XFILLER_0_92_652 VGND VGND VPWR VPWR sky130_fd_sc_hd__fill_1
XTAP_TAPCELL_ROW_81_1274 VGND VPWR sky130_fd_sc_hd__tapvpwrvgnd_1
XFILLER_0_64_321 VGND VGND VPWR VPWR sky130_fd_sc_hd__fill_1
XFILLER_0_107_434 VGND VGND VPWR VPWR sky130_fd_sc_hd__decap_3
XFILLER_0_64_365 VGND VGND VPWR VPWR sky130_fd_sc_hd__decap_4
XFILLER_0_17_281 VPWR VGND VPWR VGND sky130_ef_sc_hd__decap_12
X_10453_ clknet_leaf_7_clk _00310_ VGND VGND VPWR VPWR tanh_inst.divider.y\[-11\]
+ sky130_fd_sc_hd__dfxtp_2
X_10384_ clknet_leaf_7_clk _00241_ VGND VGND VPWR VPWR tanh_inst.divider.x\[-16\]
+ sky130_fd_sc_hd__dfxtp_2
XFILLER_0_74_29 VGND VGND VPWR VPWR sky130_fd_sc_hd__decap_4
XFILLER_0_59_148 VGND VGND VPWR VPWR sky130_fd_sc_hd__decap_4
XFILLER_0_23_55 VGND VGND VPWR VPWR sky130_fd_sc_hd__fill_1
XTAP_TAPCELL_ROW_99_1502 VGND VPWR sky130_fd_sc_hd__tapvpwrvgnd_1
XFILLER_0_99_15 VPWR VGND VPWR VGND sky130_ef_sc_hd__decap_12
Xclkbuf_leaf_40_clk clknet_2_0__leaf_clk VGND VGND VPWR VPWR clknet_leaf_40_clk sky130_fd_sc_hd__clkbuf_8
XTAP_TAPCELL_ROW_31_647 VGND VPWR sky130_fd_sc_hd__tapvpwrvgnd_1
XFILLER_0_43_505 VGND VGND VPWR VPWR sky130_fd_sc_hd__decap_4
XFILLER_0_82_195 VGND VGND VPWR VPWR sky130_fd_sc_hd__fill_1
XFILLER_0_70_313 VGND VGND VPWR VPWR sky130_fd_sc_hd__fill_1
X_05290_ mac_inst.x\[30\] _04852_ _04853_ VGND VGND VPWR VPWR _04990_ sky130_fd_sc_hd__a21o_2
XFILLER_0_43_549 VGND VGND VPWR VPWR sky130_fd_sc_hd__fill_1
XFILLER_0_11_413 VGND VGND VPWR VPWR sky130_fd_sc_hd__fill_2
XFILLER_0_23_273 VGND VGND VPWR VPWR sky130_fd_sc_hd__decap_6
XFILLER_0_11_435 VGND VGND VPWR VPWR sky130_fd_sc_hd__decap_6
XFILLER_0_2_189 VGND VGND VPWR VPWR sky130_fd_sc_hd__decap_6
X_08980_ _03513_ _03561_ _03563_ _03559_ _04760_ tanh_inst.LOOKUP.index\[0\] VGND
+ VGND VPWR VPWR _03723_ sky130_fd_sc_hd__mux4_2
XFILLER_0_11_468 VPWR VGND VPWR VGND sky130_ef_sc_hd__decap_12
X_07931_ _02727_ _02728_ VGND VGND VPWR VPWR _02729_ sky130_fd_sc_hd__or2_2
XFILLER_0_48_74 VGND VGND VPWR VPWR sky130_fd_sc_hd__decap_4
X_07862_ tanh_inst.divider.y\[-13\] _02659_ VGND VGND VPWR VPWR _02661_ sky130_fd_sc_hd__and2_2
XFILLER_0_48_96 VGND VGND VPWR VPWR sky130_fd_sc_hd__fill_2
X_09601_ _04326_ _04328_ _04324_ VGND VGND VPWR VPWR _04329_ sky130_fd_sc_hd__a21o_2
X_06813_ _01704_ _01705_ VGND VGND VPWR VPWR _01706_ sky130_fd_sc_hd__and2_2
X_07793_ _02535_ _02537_ _02593_ VGND VGND VPWR VPWR _02594_ sky130_fd_sc_hd__nor3_2
X_09532_ _04197_ _04199_ _04261_ VGND VGND VPWR VPWR _04262_ sky130_fd_sc_hd__o21a_2
XFILLER_0_64_73 VGND VGND VPWR VPWR sky130_fd_sc_hd__fill_2
XTAP_TAPCELL_ROW_39_747 VGND VPWR sky130_fd_sc_hd__tapvpwrvgnd_1
X_06744_ _01642_ _01643_ VGND VGND VPWR VPWR _01645_ sky130_fd_sc_hd__nand2b_2
X_09463_ _02022_ _03917_ VGND VGND VPWR VPWR _04194_ sky130_fd_sc_hd__and2_2
X_06675_ tanh_inst.z_\[-17\] _01582_ VGND VGND VPWR VPWR _01583_ sky130_fd_sc_hd__nand2_2
X_09394_ _04126_ _04121_ VGND VGND VPWR VPWR _04128_ sky130_fd_sc_hd__nand2b_2
XFILLER_0_59_671 VGND VGND VPWR VPWR sky130_fd_sc_hd__fill_1
X_05626_ _00575_ _00576_ _00587_ _00611_ mac_inst.z\[31\] VGND VGND VPWR VPWR _00612_
+ sky130_fd_sc_hd__a41o_2
X_08414_ tanh_inst.divider.x\[0\] _03199_ VGND VGND VPWR VPWR _03200_ sky130_fd_sc_hd__and2_2
XFILLER_0_80_83 VGND VGND VPWR VPWR sky130_fd_sc_hd__fill_1
X_08345_ _03130_ _03132_ VGND VGND VPWR VPWR _03133_ sky130_fd_sc_hd__nand2_2
X_05557_ _00530_ _00549_ _00548_ VGND VGND VPWR VPWR _00550_ sky130_fd_sc_hd__o21ba_2
XFILLER_0_117_721 VGND VGND VPWR VPWR sky130_fd_sc_hd__decap_3
XFILLER_0_73_140 VPWR VGND VPWR VGND sky130_ef_sc_hd__decap_12
Xclkbuf_leaf_31_clk clknet_2_1__leaf_clk VGND VGND VPWR VPWR clknet_leaf_31_clk sky130_fd_sc_hd__clkbuf_8
XFILLER_0_46_365 VPWR VGND VPWR VGND sky130_ef_sc_hd__decap_12
X_05488_ mac_inst.i\[3\] _00384_ VGND VGND VPWR VPWR _00486_ sky130_fd_sc_hd__nand2_2
X_08276_ _03060_ _03062_ _03064_ _04791_ VGND VGND VPWR VPWR _03066_ sky130_fd_sc_hd__o31a_2
X_07227_ tanh_inst.divider.y\[-12\] _02028_ _02029_ VGND VGND VPWR VPWR _02037_ sky130_fd_sc_hd__o21ai_2
X_07158_ _01977_ _01978_ tanh_inst.divider.z_\[1\] _01092_ VGND VGND VPWR VPWR _00222_
+ sky130_fd_sc_hd__a2bb2o_2
XFILLER_0_14_251 VGND VGND VPWR VPWR sky130_fd_sc_hd__fill_1
X_06109_ _01055_ VGND VGND VPWR VPWR _01056_ sky130_fd_sc_hd__inv_2
X_07089_ _01909_ _01915_ tanh_inst.divider.z_\[-6\] VGND VGND VPWR VPWR _01917_ sky130_fd_sc_hd__a21oi_2
XTAP_TAPCELL_ROW_83_1303 VGND VPWR sky130_fd_sc_hd__tapvpwrvgnd_1
XFILLER_0_69_468 VPWR VGND VPWR VGND sky130_ef_sc_hd__decap_12
XFILLER_0_69_446 VGND VGND VPWR VPWR sky130_fd_sc_hd__fill_2
XFILLER_0_84_416 VGND VGND VPWR VPWR sky130_fd_sc_hd__decap_4
XFILLER_0_65_630 VGND VGND VPWR VPWR sky130_fd_sc_hd__fill_1
XFILLER_0_37_332 VGND VGND VPWR VPWR sky130_fd_sc_hd__decap_4
Xclkbuf_leaf_22_clk clknet_2_3__leaf_clk VGND VGND VPWR VPWR clknet_leaf_22_clk sky130_fd_sc_hd__clkbuf_8
XFILLER_0_64_162 VGND VGND VPWR VPWR sky130_fd_sc_hd__fill_1
XFILLER_0_25_505 VGND VGND VPWR VPWR sky130_fd_sc_hd__decap_4
XFILLER_0_25_516 VPWR VGND VPWR VGND sky130_ef_sc_hd__decap_12
XFILLER_0_80_677 VGND VGND VPWR VPWR sky130_fd_sc_hd__fill_1
XFILLER_0_69_29 VGND VGND VPWR VPWR sky130_fd_sc_hd__fill_1
XFILLER_0_52_357 VGND VGND VPWR VPWR sky130_fd_sc_hd__decap_6
XFILLER_0_100_15 VPWR VGND VPWR VGND sky130_ef_sc_hd__decap_12
XTAP_TAPCELL_ROW_94_1432 VGND VPWR sky130_fd_sc_hd__tapvpwrvgnd_1
X_10436_ clknet_leaf_40_clk _00293_ _00000_ VGND VGND VPWR VPWR mac_inst.i\[28\] sky130_fd_sc_hd__dfrtp_2
XTAP_TAPCELL_ROW_94_1443 VGND VPWR sky130_fd_sc_hd__tapvpwrvgnd_1
XFILLER_0_20_221 VPWR VGND VPWR VGND sky130_ef_sc_hd__decap_12
X_10367_ clknet_leaf_16_clk _00224_ VGND VGND VPWR VPWR tanh_inst.divider.z_\[3\]
+ sky130_fd_sc_hd__dfxtp_2
XFILLER_0_0_649 VGND VGND VPWR VPWR sky130_fd_sc_hd__fill_1
XFILLER_0_20_265 VPWR VGND VPWR VGND sky130_ef_sc_hd__decap_12
X_10298_ clknet_leaf_23_clk _00155_ VGND VGND VPWR VPWR tanh_inst.z_\[3\] sky130_fd_sc_hd__dfxtp_2
XFILLER_0_109_57 VPWR VGND VPWR VGND sky130_ef_sc_hd__decap_12
XFILLER_0_18_77 VGND VGND VPWR VPWR sky130_fd_sc_hd__decap_6
XTAP_TAPCELL_ROW_36_706 VGND VPWR sky130_fd_sc_hd__tapvpwrvgnd_1
XTAP_TAPCELL_ROW_36_717 VGND VPWR sky130_fd_sc_hd__tapvpwrvgnd_1
XFILLER_0_87_232 VGND VGND VPWR VPWR sky130_fd_sc_hd__decap_3
X_06460_ tanh_inst.divider.y\[-1\] tanh_inst.div_en tanh_inst.divider.y_\[-1\] _01092_
+ VGND VGND VPWR VPWR _01384_ sky130_fd_sc_hd__a22o_2
XTAP_TAPCELL_ROW_103_1550 VGND VPWR sky130_fd_sc_hd__tapvpwrvgnd_1
XFILLER_0_75_449 VGND VGND VPWR VPWR sky130_fd_sc_hd__decap_6
XTAP_TAPCELL_ROW_16_463 VGND VPWR sky130_fd_sc_hd__tapvpwrvgnd_1
X_05411_ mac_inst.i\[2\] _00356_ VGND VGND VPWR VPWR _00415_ sky130_fd_sc_hd__nor2_2
X_06391_ tanh_inst.divider.i\[4\] _01099_ _01289_ VGND VGND VPWR VPWR _01320_ sky130_fd_sc_hd__o21a_2
Xclkbuf_leaf_13_clk clknet_2_3__leaf_clk VGND VGND VPWR VPWR clknet_leaf_13_clk sky130_fd_sc_hd__clkbuf_8
XPHY_EDGE_ROW_78_Left_200 VGND VGND VPWR VPWR sky130_fd_sc_hd__decap_3
XFILLER_0_71_600 VPWR VGND VPWR VGND sky130_ef_sc_hd__decap_12
X_08130_ _02015_ _02922_ _02923_ _02921_ _01470_ VGND VGND VPWR VPWR _00249_ sky130_fd_sc_hd__o311a_2
XFILLER_0_7_237 VPWR VGND VPWR VGND sky130_ef_sc_hd__decap_12
XFILLER_0_28_354 VGND VGND VPWR VPWR sky130_fd_sc_hd__decap_8
XFILLER_0_28_365 VGND VGND VPWR VPWR sky130_fd_sc_hd__decap_4
XFILLER_0_50_42 VGND VGND VPWR VPWR sky130_fd_sc_hd__decap_4
XFILLER_0_71_633 VGND VGND VPWR VPWR sky130_fd_sc_hd__fill_1
XFILLER_0_55_195 VGND VGND VPWR VPWR sky130_fd_sc_hd__fill_2
XFILLER_0_55_173 VGND VGND VPWR VPWR sky130_fd_sc_hd__fill_1
X_05342_ mac_inst.i\[2\] _04788_ VGND VGND VPWR VPWR _00350_ sky130_fd_sc_hd__nand2_2
X_08061_ _02810_ _02815_ _02854_ tanh_inst.z_\[7\] VGND VGND VPWR VPWR _02856_ sky130_fd_sc_hd__a31o_2
X_05273_ _04786_ _04847_ _04939_ _04951_ _04973_ VGND VGND VPWR VPWR _04974_ sky130_fd_sc_hd__o32a_2
X_07012_ tanh_inst.divider.i\[4\] tanh_inst.divider.y_\[7\] _01847_ tanh_inst.divider.z_\[-15\]
+ VGND VGND VPWR VPWR _01849_ sky130_fd_sc_hd__a211oi_2
XFILLER_0_71_699 VGND VGND VPWR VPWR sky130_fd_sc_hd__decap_4
XTAP_TAPCELL_ROW_114_1690 VGND VPWR sky130_fd_sc_hd__tapvpwrvgnd_1
X_08963_ _04759_ _03706_ VGND VGND VPWR VPWR _03707_ sky130_fd_sc_hd__or2_2
X_07914_ tanh_inst.divider.y\[-12\] tanh_inst.divider.x\[-12\] VGND VGND VPWR VPWR
+ _02712_ sky130_fd_sc_hd__and2_2
XFILLER_0_45_3 VGND VGND VPWR VPWR sky130_fd_sc_hd__decap_8
X_08894_ tanh_inst.divider.x\[-19\] tanh_inst.divider.x\[-18\] tanh_inst.divider.x\[-17\]
+ tanh_inst.divider.x\[-16\] tanh_inst.LOOKUP.index\[0\] tanh_inst.LOOKUP.index\[1\]
+ VGND VGND VPWR VPWR _03639_ sky130_fd_sc_hd__mux4_2
X_07845_ _02515_ _02516_ _02567_ _02602_ VGND VGND VPWR VPWR _02645_ sky130_fd_sc_hd__and4_2
X_07776_ tanh_inst.divider.x\[-16\] _02014_ _02577_ _01470_ VGND VGND VPWR VPWR _00241_
+ sky130_fd_sc_hd__o211a_2
XFILLER_0_78_243 VGND VGND VPWR VPWR sky130_fd_sc_hd__fill_2
X_09515_ _02892_ _04243_ VGND VGND VPWR VPWR _04245_ sky130_fd_sc_hd__nand2b_2
X_06727_ _01532_ _01533_ tanh_inst.z_\[7\] VGND VGND VPWR VPWR _01629_ sky130_fd_sc_hd__a21o_2
X_09446_ _04176_ _04177_ VGND VGND VPWR VPWR _04178_ sky130_fd_sc_hd__and2_2
XFILLER_0_66_416 VGND VGND VPWR VPWR sky130_fd_sc_hd__decap_4
X_06658_ _01564_ _01566_ _01567_ VGND VGND VPWR VPWR _01568_ sky130_fd_sc_hd__or3_2
XTAP_TAPCELL_ROW_65_1077 VGND VPWR sky130_fd_sc_hd__tapvpwrvgnd_1
X_09377_ _04105_ _04109_ tanh_inst.z_\[7\] VGND VGND VPWR VPWR _04111_ sky130_fd_sc_hd__o21a_2
X_06589_ _01488_ _01489_ _01502_ _01469_ mac_y_out[0] VGND VGND VPWR VPWR _00128_
+ sky130_fd_sc_hd__a32o_2
X_05609_ mac_inst.y\[22\] _00578_ _00590_ mac_inst.y\[23\] VGND VGND VPWR VPWR _00596_
+ sky130_fd_sc_hd__a22o_2
XFILLER_0_62_622 VGND VGND VPWR VPWR sky130_fd_sc_hd__fill_1
X_08328_ _02018_ _03115_ _03116_ _02015_ VGND VGND VPWR VPWR _03117_ sky130_fd_sc_hd__a31o_2
XTAP_TAPCELL_ROW_117_1719 VGND VPWR sky130_fd_sc_hd__tapvpwrvgnd_1
XFILLER_0_61_154 VGND VGND VPWR VPWR sky130_fd_sc_hd__fill_1
X_08259_ tanh_inst.divider.y\[-5\] tanh_inst.divider.x\[-5\] tanh_inst.divider.x\[-6\]
+ tanh_inst.divider.y\[-6\] VGND VGND VPWR VPWR _03049_ sky130_fd_sc_hd__o211a_2
XFILLER_0_34_379 VGND VGND VPWR VPWR sky130_fd_sc_hd__decap_8
X_10221_ clknet_leaf_30_clk mac_inst.y\[15\] _00000_ VGND VGND VPWR VPWR mac_y_out[15]
+ sky130_fd_sc_hd__dfrtp_2
XFILLER_0_100_462 VPWR VGND VPWR VGND sky130_ef_sc_hd__decap_12
XFILLER_0_30_596 VGND VGND VPWR VPWR sky130_fd_sc_hd__fill_1
X_10083_ clknet_leaf_5_clk _00100_ VGND VGND VPWR VPWR tanh_inst.divider.y_\[-10\]
+ sky130_fd_sc_hd__dfxtp_2
XFILLER_0_69_210 VPWR VGND VPWR VGND sky130_ef_sc_hd__decap_12
XFILLER_0_69_243 VPWR VGND VPWR VGND sky130_ef_sc_hd__decap_12
XFILLER_0_97_585 VGND VGND VPWR VPWR sky130_fd_sc_hd__fill_1
XFILLER_0_57_449 VGND VGND VPWR VPWR sky130_fd_sc_hd__decap_4
XFILLER_0_72_419 VGND VGND VPWR VPWR sky130_fd_sc_hd__fill_1
XTAP_TAPCELL_ROW_13_422 VGND VPWR sky130_fd_sc_hd__tapvpwrvgnd_1
XTAP_TAPCELL_ROW_41_775 VGND VPWR sky130_fd_sc_hd__tapvpwrvgnd_1
XFILLER_0_25_335 VGND VGND VPWR VPWR sky130_fd_sc_hd__fill_1
XFILLER_0_111_69 VPWR VGND VPWR VGND sky130_ef_sc_hd__decap_12
XFILLER_0_80_463 VGND VGND VPWR VPWR sky130_fd_sc_hd__decap_3
XFILLER_0_40_305 VGND VGND VPWR VPWR sky130_fd_sc_hd__decap_3
XFILLER_0_96_27 VGND VGND VPWR VPWR sky130_fd_sc_hd__fill_1
X_10419_ clknet_leaf_37_clk _00276_ _00000_ VGND VGND VPWR VPWR mac_inst.i\[11\] sky130_fd_sc_hd__dfrtp_2
Xclkbuf_leaf_2_clk clknet_2_2__leaf_clk VGND VGND VPWR VPWR clknet_leaf_2_clk sky130_fd_sc_hd__clkbuf_8
X_05960_ _04802_ _00915_ VGND VGND VPWR VPWR _00918_ sky130_fd_sc_hd__xnor2_2
XPHY_EDGE_ROW_119_Right_119 VGND VGND VPWR VPWR sky130_fd_sc_hd__decap_3
X_05891_ _00849_ _00850_ mac_inst.z\[16\] VGND VGND VPWR VPWR _00854_ sky130_fd_sc_hd__a21bo_2
X_07630_ _02433_ VGND VGND VPWR VPWR _02434_ sky130_fd_sc_hd__inv_2
XTAP_TAPCELL_ROW_49_875 VGND VPWR sky130_fd_sc_hd__tapvpwrvgnd_1
X_07561_ tanh_inst.LOOKUP.index\[2\] _02115_ _02313_ VGND VGND VPWR VPWR _02367_ sky130_fd_sc_hd__o21a_2
X_06512_ _01421_ _01422_ _04793_ VGND VGND VPWR VPWR _01431_ sky130_fd_sc_hd__o21ai_2
X_09300_ _02630_ _02631_ _04021_ VGND VGND VPWR VPWR _04036_ sky130_fd_sc_hd__a21o_2
X_07492_ tanh_inst.divider.y\[-21\] tanh_inst.divider.x\[-21\] VGND VGND VPWR VPWR
+ _02299_ sky130_fd_sc_hd__nand2_2
X_06443_ _01357_ _01358_ _04793_ VGND VGND VPWR VPWR _01368_ sky130_fd_sc_hd__o21a_2
X_09231_ _02551_ _03955_ VGND VGND VPWR VPWR _03969_ sky130_fd_sc_hd__nor2_2
X_06374_ _01303_ _01304_ VGND VGND VPWR VPWR _01305_ sky130_fd_sc_hd__and2_2
X_09162_ _03900_ _03901_ VGND VGND VPWR VPWR _03902_ sky130_fd_sc_hd__xnor2_2
XFILLER_0_44_633 VGND VGND VPWR VPWR sky130_fd_sc_hd__decap_8
X_08113_ _02564_ _02743_ _02905_ VGND VGND VPWR VPWR _02907_ sky130_fd_sc_hd__or3_2
X_05325_ _05022_ _05023_ mac_inst.i\[2\] VGND VGND VPWR VPWR _05024_ sky130_fd_sc_hd__mux2_1
X_09093_ _02052_ _03833_ _03830_ VGND VGND VPWR VPWR _03834_ sky130_fd_sc_hd__o21a_2
X_08044_ tanh_inst.divider.x\[-9\] _02837_ VGND VGND VPWR VPWR _02839_ sky130_fd_sc_hd__xnor2_2
X_05256_ mac_inst.i\[23\] mac_inst.i\[25\] mac_inst.i\[31\] VGND VGND VPWR VPWR _04957_
+ sky130_fd_sc_hd__or3_2
XFILLER_0_3_273 VGND VGND VPWR VPWR sky130_fd_sc_hd__decap_6
X_05187_ mac_inst.x\[10\] _04852_ _04853_ VGND VGND VPWR VPWR _04891_ sky130_fd_sc_hd__a21o_2
X_09995_ _04700_ _04701_ _04699_ VGND VGND VPWR VPWR _04711_ sky130_fd_sc_hd__a21bo_2
X_08946_ _03585_ _03619_ _03618_ VGND VGND VPWR VPWR _03690_ sky130_fd_sc_hd__a21o_2
X_08877_ _03585_ _03620_ _04791_ VGND VGND VPWR VPWR _03622_ sky130_fd_sc_hd__a21o_2
X_07828_ _02548_ _02580_ VGND VGND VPWR VPWR _02628_ sky130_fd_sc_hd__nand2b_2
X_07759_ _02557_ _02560_ _02554_ VGND VGND VPWR VPWR _02561_ sky130_fd_sc_hd__o21a_2
XFILLER_0_66_202 VPWR VGND VPWR VGND sky130_ef_sc_hd__decap_12
XFILLER_0_94_533 VGND VGND VPWR VPWR sky130_fd_sc_hd__decap_4
XFILLER_0_66_235 VPWR VGND VPWR VGND sky130_ef_sc_hd__decap_12
XFILLER_0_39_449 VPWR VGND VPWR VGND sky130_ef_sc_hd__decap_12
XFILLER_0_54_419 VGND VGND VPWR VPWR sky130_fd_sc_hd__fill_1
X_09429_ _01525_ _03894_ _04159_ _04757_ _04160_ VGND VGND VPWR VPWR _04161_ sky130_fd_sc_hd__o221a_2
XFILLER_0_34_110 VGND VGND VPWR VPWR sky130_fd_sc_hd__decap_3
XFILLER_0_81_249 VGND VGND VPWR VPWR sky130_fd_sc_hd__decap_3
XTAP_TAPCELL_ROW_78_1235 VGND VPWR sky130_fd_sc_hd__tapvpwrvgnd_1
XFILLER_0_15_390 VGND VGND VPWR VPWR sky130_fd_sc_hd__fill_2
XTAP_TAPCELL_ROW_91_1402 VGND VPWR sky130_fd_sc_hd__tapvpwrvgnd_1
X_10204_ x_in[30] _00000_ VGND VGND VPWR VPWR mac_inst.x\[30\] sky130_fd_sc_hd__dlxtn_1
X_10066_ rst VGND VGND VPWR VPWR _00085_ sky130_fd_sc_hd__inv_2
XFILLER_0_82_29 VGND VGND VPWR VPWR sky130_fd_sc_hd__fill_1
XFILLER_0_82_18 VGND VGND VPWR VPWR sky130_fd_sc_hd__decap_3
XTAP_TAPCELL_ROW_89_1375 VGND VPWR sky130_fd_sc_hd__tapvpwrvgnd_1
XTAP_TAPCELL_ROW_46_834 VGND VPWR sky130_fd_sc_hd__tapvpwrvgnd_1
XFILLER_0_97_393 VPWR VGND VPWR VGND sky130_ef_sc_hd__decap_12
XTAP_TAPCELL_ROW_26_591 VGND VPWR sky130_fd_sc_hd__tapvpwrvgnd_1
XFILLER_0_72_238 VPWR VGND VPWR VGND sky130_ef_sc_hd__decap_12
XFILLER_0_31_33 VGND VGND VPWR VPWR sky130_fd_sc_hd__fill_1
XFILLER_0_25_110 VGND VGND VPWR VPWR sky130_fd_sc_hd__fill_2
XFILLER_0_25_143 VGND VGND VPWR VPWR sky130_fd_sc_hd__decap_3
XFILLER_0_53_430 VGND VGND VPWR VPWR sky130_fd_sc_hd__decap_4
XFILLER_0_13_305 VPWR VGND VPWR VGND sky130_ef_sc_hd__decap_12
X_05110_ current_state\[1\] mac_counter\[2\] mac_counter\[1\] mac_counter\[0\] VGND
+ VGND VPWR VPWR _04822_ sky130_fd_sc_hd__and4b_2
XFILLER_0_103_3 VPWR VGND VPWR VGND sky130_ef_sc_hd__decap_12
X_06090_ _01033_ _01036_ _01029_ _01031_ VGND VGND VPWR VPWR _01037_ sky130_fd_sc_hd__a211o_2
XFILLER_0_13_349 VPWR VGND VPWR VGND sky130_ef_sc_hd__decap_12
XFILLER_0_40_113 VGND VGND VPWR VPWR sky130_fd_sc_hd__fill_1
XFILLER_0_0_221 VGND VGND VPWR VPWR sky130_fd_sc_hd__decap_3
XFILLER_0_41_669 VGND VGND VPWR VPWR sky130_fd_sc_hd__decap_3
X_05041_ tanh_inst.divider.y\[-6\] VGND VGND VPWR VPWR _04765_ sky130_fd_sc_hd__inv_2
X_08800_ tanh_inst.divider.x\[2\] _02028_ _03508_ VGND VGND VPWR VPWR _03546_ sky130_fd_sc_hd__o21a_2
XFILLER_0_0_265 VPWR VGND VPWR VGND sky130_ef_sc_hd__decap_12
X_06992_ _01811_ _01819_ _01829_ VGND VGND VPWR VPWR _01831_ sky130_fd_sc_hd__and3_2
XPHY_EDGE_ROW_7_Right_7 VGND VGND VPWR VPWR sky130_fd_sc_hd__decap_3
X_09780_ _04441_ _04498_ VGND VGND VPWR VPWR _04502_ sky130_fd_sc_hd__nand2_2
XFILLER_0_56_63 VGND VGND VPWR VPWR sky130_fd_sc_hd__decap_8
X_05943_ mac_inst.z\[20\] _00899_ VGND VGND VPWR VPWR _00902_ sky130_fd_sc_hd__nand2_2
X_08731_ mac_inst.i\[14\] _00962_ mac_inst.i\[15\] VGND VGND VPWR VPWR _03494_ sky130_fd_sc_hd__a21oi_2
X_08662_ _03440_ _03441_ VGND VGND VPWR VPWR _03442_ sky130_fd_sc_hd__nand2_2
XFILLER_0_56_85 VGND VGND VPWR VPWR sky130_fd_sc_hd__decap_6
X_07613_ tanh_inst.LOOKUP.index\[2\] _02183_ _02313_ VGND VGND VPWR VPWR _02418_ sky130_fd_sc_hd__o21a_2
X_05874_ _04943_ _00837_ VGND VGND VPWR VPWR _00838_ sky130_fd_sc_hd__nand2_2
XFILLER_0_88_360 VGND VGND VPWR VPWR sky130_fd_sc_hd__decap_4
X_08593_ _03220_ _03223_ _03231_ _03374_ VGND VGND VPWR VPWR _03375_ sky130_fd_sc_hd__a211o_2
X_07544_ _02289_ _02291_ VGND VGND VPWR VPWR _02350_ sky130_fd_sc_hd__nand2_2
XFILLER_0_76_533 VGND VGND VPWR VPWR sky130_fd_sc_hd__decap_6
XFILLER_0_72_95 VPWR VGND VPWR VGND sky130_ef_sc_hd__decap_12
XFILLER_0_119_646 VGND VGND VPWR VPWR sky130_fd_sc_hd__decap_3
X_07475_ _02072_ _02075_ _02079_ _02073_ _04760_ _04761_ VGND VGND VPWR VPWR _02282_
+ sky130_fd_sc_hd__mux4_2
XTAP_TAPCELL_ROW_62_1036 VGND VPWR sky130_fd_sc_hd__tapvpwrvgnd_1
XFILLER_0_8_321 VPWR VGND VPWR VGND sky130_ef_sc_hd__decap_12
X_06426_ _01306_ _01352_ VGND VGND VPWR VPWR _01353_ sky130_fd_sc_hd__and2_2
X_09214_ _02018_ _03952_ _03937_ _02015_ VGND VGND VPWR VPWR _03953_ sky130_fd_sc_hd__a211o_2
XFILLER_0_29_460 VGND VGND VPWR VPWR sky130_fd_sc_hd__decap_3
XFILLER_0_106_307 VGND VGND VPWR VPWR sky130_fd_sc_hd__fill_1
XFILLER_0_8_365 VGND VGND VPWR VPWR sky130_fd_sc_hd__decap_3
XFILLER_0_16_121 VPWR VGND VPWR VGND sky130_ef_sc_hd__decap_12
XFILLER_0_17_666 VGND VGND VPWR VPWR sky130_fd_sc_hd__decap_6
X_06357_ _04769_ tanh_inst.divider.i\[4\] VGND VGND VPWR VPWR _01289_ sky130_fd_sc_hd__nand2_2
X_09145_ _03868_ _03884_ VGND VGND VPWR VPWR _03885_ sky130_fd_sc_hd__nand2_2
XFILLER_0_16_165 VPWR VGND VPWR VGND sky130_ef_sc_hd__decap_12
X_06288_ tanh_inst.divider.y\[-15\] tanh_inst.div_en tanh_inst.divider.y_\[-15\] _01092_
+ _01225_ VGND VGND VPWR VPWR _00095_ sky130_fd_sc_hd__a221o_2
XFILLER_0_114_362 VGND VGND VPWR VPWR sky130_fd_sc_hd__fill_2
XFILLER_0_114_351 VGND VGND VPWR VPWR sky130_fd_sc_hd__decap_3
X_09076_ _03815_ _03817_ VGND VGND VPWR VPWR _03818_ sky130_fd_sc_hd__xnor2_2
XPHY_EDGE_ROW_15_Left_137 VGND VGND VPWR VPWR sky130_fd_sc_hd__decap_3
X_05308_ mac_inst.x\[31\] mac_inst.i\[5\] _04835_ _04994_ _05007_ VGND VGND VPWR VPWR
+ _05008_ sky130_fd_sc_hd__a221oi_2
X_08027_ tanh_inst.z_\[7\] _02822_ VGND VGND VPWR VPWR _02823_ sky130_fd_sc_hd__nor2_2
X_05239_ _04939_ VGND VGND VPWR VPWR _04940_ sky130_fd_sc_hd__inv_2
XFILLER_0_31_157 VGND VGND VPWR VPWR sky130_fd_sc_hd__decap_8
XTAP_TAPCELL_ROW_73_1176 VGND VPWR sky130_fd_sc_hd__tapvpwrvgnd_1
X_09978_ _04684_ _04685_ _04694_ tanh_inst.z_\[7\] VGND VGND VPWR VPWR _04695_ sky130_fd_sc_hd__a22o_2
X_08929_ _02025_ _03671_ _03672_ _02022_ VGND VGND VPWR VPWR _03673_ sky130_fd_sc_hd__a31o_2
XFILLER_0_99_614 VGND VGND VPWR VPWR sky130_fd_sc_hd__fill_2
XPHY_EDGE_ROW_24_Left_146 VGND VGND VPWR VPWR sky130_fd_sc_hd__decap_3
XTAP_TAPCELL_ROW_43_804 VGND VPWR sky130_fd_sc_hd__tapvpwrvgnd_1
XFILLER_0_39_268 VPWR VGND VPWR VGND sky130_ef_sc_hd__decap_12
XTAP_TAPCELL_ROW_23_550 VGND VPWR sky130_fd_sc_hd__tapvpwrvgnd_1
XFILLER_0_27_419 VGND VGND VPWR VPWR sky130_fd_sc_hd__decap_8
XFILLER_0_118_690 VGND VGND VPWR VPWR sky130_fd_sc_hd__fill_1
XPHY_EDGE_ROW_33_Left_155 VGND VGND VPWR VPWR sky130_fd_sc_hd__decap_3
XFILLER_0_35_463 VGND VGND VPWR VPWR sky130_fd_sc_hd__decap_4
XFILLER_0_77_29 VGND VGND VPWR VPWR sky130_fd_sc_hd__fill_1
XFILLER_0_120_365 VGND VGND VPWR VPWR sky130_fd_sc_hd__decap_8
XFILLER_0_30_190 VGND VGND VPWR VPWR sky130_fd_sc_hd__decap_6
XFILLER_0_93_39 VGND VGND VPWR VPWR sky130_fd_sc_hd__decap_8
XPHY_EDGE_ROW_42_Left_164 VGND VGND VPWR VPWR sky130_fd_sc_hd__decap_3
XFILLER_0_89_113 VGND VGND VPWR VPWR sky130_fd_sc_hd__decap_3
XFILLER_0_117_57 VPWR VGND VPWR VGND sky130_ef_sc_hd__decap_12
XFILLER_0_89_135 VGND VGND VPWR VPWR sky130_fd_sc_hd__fill_1
X_10049_ rst VGND VGND VPWR VPWR _00068_ sky130_fd_sc_hd__inv_2
XFILLER_0_58_533 VPWR VGND VPWR VGND sky130_ef_sc_hd__decap_12
X_05590_ mac_inst.y\[22\] _00578_ VGND VGND VPWR VPWR _00579_ sky130_fd_sc_hd__and2_2
XFILLER_0_73_525 VPWR VGND VPWR VGND sky130_ef_sc_hd__decap_12
X_07260_ tanh_inst.divider.y\[7\] _02066_ _02067_ _02068_ _04760_ _04761_ VGND VGND
+ VPWR VPWR _02070_ sky130_fd_sc_hd__mux4_2
XFILLER_0_61_709 VPWR VGND VPWR VGND sky130_ef_sc_hd__decap_12
XPHY_EDGE_ROW_51_Left_173 VGND VGND VPWR VPWR sky130_fd_sc_hd__decap_3
X_07191_ _01997_ _01999_ _02005_ _01998_ VGND VGND VPWR VPWR _02007_ sky130_fd_sc_hd__o211ai_2
XFILLER_0_115_137 VGND VGND VPWR VPWR sky130_fd_sc_hd__decap_4
X_06211_ _01152_ _01153_ VGND VGND VPWR VPWR _01154_ sky130_fd_sc_hd__or2_2
XFILLER_0_5_335 VGND VGND VPWR VPWR sky130_fd_sc_hd__fill_1
X_06142_ tanh_inst.div_en _01059_ VGND VGND VPWR VPWR _01088_ sky130_fd_sc_hd__nor2_2
XFILLER_0_13_113 VPWR VGND VPWR VGND sky130_ef_sc_hd__decap_12
XFILLER_0_41_411 VPWR VGND VPWR VGND sky130_ef_sc_hd__decap_12
XFILLER_0_53_271 VGND VGND VPWR VPWR sky130_fd_sc_hd__decap_8
X_06073_ tanh_inst.divider.x\[-4\] tanh_inst.divider.x\[-3\] tanh_inst.divider.x\[-2\]
+ tanh_inst.divider.x\[-1\] tanh_inst.divider.i\[0\] tanh_inst.divider.i\[1\] VGND
+ VGND VPWR VPWR _01020_ sky130_fd_sc_hd__mux4_2
X_09901_ _04618_ _04619_ VGND VGND VPWR VPWR _04620_ sky130_fd_sc_hd__nor2_2
XFILLER_0_41_488 VGND VGND VPWR VPWR sky130_fd_sc_hd__decap_4
XFILLER_0_6_65 VPWR VGND VPWR VGND sky130_ef_sc_hd__decap_12
XFILLER_0_1_574 VPWR VGND VPWR VGND sky130_ef_sc_hd__decap_12
XPHY_EDGE_ROW_60_Left_182 VGND VGND VPWR VPWR sky130_fd_sc_hd__decap_3
X_09832_ tanh_inst.divider.y\[1\] _04546_ VGND VGND VPWR VPWR _04553_ sky130_fd_sc_hd__nor2_2
X_09763_ _04454_ _04457_ _04485_ VGND VGND VPWR VPWR _04486_ sky130_fd_sc_hd__o21a_2
X_06975_ _01813_ _01815_ _01808_ VGND VGND VPWR VPWR _01816_ sky130_fd_sc_hd__o21ai_2
X_08714_ _00759_ _00953_ _03488_ VGND VGND VPWR VPWR _00268_ sky130_fd_sc_hd__a21oi_2
X_05926_ _00861_ _00885_ _00886_ VGND VGND VPWR VPWR _00887_ sky130_fd_sc_hd__a21o_2
X_09694_ _03099_ _03100_ _04407_ VGND VGND VPWR VPWR _04419_ sky130_fd_sc_hd__a21oi_2
X_08645_ tanh_inst.z_\[7\] _03424_ _03425_ _03416_ VGND VGND VPWR VPWR _03426_ sky130_fd_sc_hd__a31o_2
X_05857_ _00716_ _00730_ VGND VGND VPWR VPWR _00822_ sky130_fd_sc_hd__or2_2
X_08576_ tanh_inst.divider.x\[4\] _03357_ VGND VGND VPWR VPWR _03358_ sky130_fd_sc_hd__and2_2
XTAP_TAPCELL_ROW_1_278 VGND VPWR sky130_fd_sc_hd__tapvpwrvgnd_1
X_07527_ _02014_ _02333_ VGND VGND VPWR VPWR _02334_ sky130_fd_sc_hd__nand2_2
X_05788_ _00755_ _00756_ VGND VGND VPWR VPWR _05788_/X sky130_fd_sc_hd__xor2_2
XTAP_TAPCELL_ROW_120_1759 VGND VPWR sky130_fd_sc_hd__tapvpwrvgnd_1
XFILLER_0_119_476 VGND VGND VPWR VPWR sky130_fd_sc_hd__fill_2
X_07458_ _02264_ _02265_ VGND VGND VPWR VPWR _02266_ sky130_fd_sc_hd__and2b_2
XFILLER_0_64_569 VGND VGND VPWR VPWR sky130_fd_sc_hd__decap_8
XFILLER_0_29_290 VGND VGND VPWR VPWR sky130_fd_sc_hd__decap_6
X_06409_ tanh_inst.divider.y_\[-5\] _01335_ VGND VGND VPWR VPWR _01337_ sky130_fd_sc_hd__nand2_2
X_07389_ _02196_ _02197_ VGND VGND VPWR VPWR _02198_ sky130_fd_sc_hd__nor2_2
XFILLER_0_8_195 VGND VGND VPWR VPWR sky130_fd_sc_hd__fill_1
X_09128_ _03782_ _03797_ _03845_ _03867_ VGND VGND VPWR VPWR _03868_ sky130_fd_sc_hd__o31ai_2
XFILLER_0_115_671 VGND VGND VPWR VPWR sky130_fd_sc_hd__fill_1
XTAP_TAPCELL_ROW_75_1205 VGND VPWR sky130_fd_sc_hd__tapvpwrvgnd_1
XFILLER_0_114_192 VGND VGND VPWR VPWR sky130_fd_sc_hd__decap_4
XFILLER_0_102_321 VGND VGND VPWR VPWR sky130_fd_sc_hd__decap_8
X_09059_ _02359_ _03788_ VGND VGND VPWR VPWR _03801_ sky130_fd_sc_hd__or2_2
XFILLER_0_13_680 VGND VGND VPWR VPWR sky130_fd_sc_hd__decap_6
XFILLER_0_102_365 VGND VGND VPWR VPWR sky130_fd_sc_hd__decap_8
XTAP_TAPCELL_ROW_9_378 VGND VPWR sky130_fd_sc_hd__tapvpwrvgnd_1
XFILLER_0_99_477 VGND VGND VPWR VPWR sky130_fd_sc_hd__decap_8
XTAP_TAPCELL_ROW_86_1334 VGND VPWR sky130_fd_sc_hd__tapvpwrvgnd_1
XTAP_TAPCELL_ROW_56_962 VGND VPWR sky130_fd_sc_hd__tapvpwrvgnd_1
XFILLER_0_95_650 VGND VGND VPWR VPWR sky130_fd_sc_hd__decap_4
XFILLER_0_86_149 VPWR VGND VPWR VGND sky130_ef_sc_hd__decap_12
XFILLER_0_79_190 VPWR VGND VPWR VGND sky130_ef_sc_hd__decap_12
XFILLER_0_103_15 VPWR VGND VPWR VGND sky130_ef_sc_hd__decap_12
XFILLER_0_55_514 VPWR VGND VPWR VGND sky130_ef_sc_hd__decap_12
XFILLER_0_82_333 VGND VGND VPWR VPWR sky130_fd_sc_hd__decap_4
XFILLER_0_55_558 VGND VGND VPWR VPWR sky130_fd_sc_hd__fill_2
XFILLER_0_70_528 VGND VGND VPWR VPWR sky130_fd_sc_hd__decap_4
XFILLER_0_35_260 VGND VGND VPWR VPWR sky130_fd_sc_hd__fill_1
XTAP_TAPCELL_ROW_97_1474 VGND VPWR sky130_fd_sc_hd__tapvpwrvgnd_1
XFILLER_0_121_630 VGND VGND VPWR VPWR sky130_fd_sc_hd__decap_3
XFILLER_0_11_617 VPWR VGND VPWR VGND sky130_ef_sc_hd__decap_12
XFILLER_0_121_685 VPWR VGND VPWR VGND sky130_ef_sc_hd__decap_12
XFILLER_0_120_195 VGND VGND VPWR VPWR sky130_fd_sc_hd__fill_1
X_06760_ tanh_inst.z_\[-8\] _01657_ VGND VGND VPWR VPWR _01659_ sky130_fd_sc_hd__or2_2
X_06691_ _01596_ _01597_ VGND VGND VPWR VPWR _01598_ sky130_fd_sc_hd__nor2_2
X_05711_ mac_inst.z\[1\] _00669_ _00670_ _00672_ _00663_ VGND VGND VPWR VPWR _00688_
+ sky130_fd_sc_hd__a32o_2
X_05642_ _04911_ _00464_ VGND VGND VPWR VPWR _00626_ sky130_fd_sc_hd__nand2_2
X_08430_ _03215_ VGND VGND VPWR VPWR _03216_ sky130_fd_sc_hd__inv_2
XTAP_TAPCELL_ROW_106_1581 VGND VPWR sky130_fd_sc_hd__tapvpwrvgnd_1
XFILLER_0_58_341 VPWR VGND VPWR VGND sky130_ef_sc_hd__decap_12
XFILLER_0_53_75 VPWR VGND VPWR VGND sky130_ef_sc_hd__decap_12
XTAP_TAPCELL_ROW_106_1592 VGND VPWR sky130_fd_sc_hd__tapvpwrvgnd_1
XFILLER_0_85_160 VGND VGND VPWR VPWR sky130_fd_sc_hd__decap_8
X_08361_ tanh_inst.divider.y\[-2\] _03147_ VGND VGND VPWR VPWR _03149_ sky130_fd_sc_hd__xor2_2
X_05573_ mac_inst.y\[20\] _00562_ VGND VGND VPWR VPWR _00564_ sky130_fd_sc_hd__xnor2_2
XFILLER_0_85_193 VGND VGND VPWR VPWR sky130_fd_sc_hd__decap_3
XFILLER_0_85_182 VGND VGND VPWR VPWR sky130_fd_sc_hd__decap_3
XTAP_TAPCELL_ROW_34_689 VGND VPWR sky130_fd_sc_hd__tapvpwrvgnd_1
X_08292_ _03081_ _02018_ _03080_ VGND VGND VPWR VPWR _03082_ sky130_fd_sc_hd__and3b_2
X_07312_ tanh_inst.LOOKUP.index\[4\] _02121_ VGND VGND VPWR VPWR _02122_ sky130_fd_sc_hd__nand2_2
X_07243_ _02028_ _02051_ VGND VGND VPWR VPWR _02053_ sky130_fd_sc_hd__or2_2
XFILLER_0_116_468 VGND VGND VPWR VPWR sky130_fd_sc_hd__decap_8
X_07174_ _01974_ _01976_ _01990_ _01991_ _01982_ VGND VGND VPWR VPWR _01992_ sky130_fd_sc_hd__o311a_2
XFILLER_0_6_699 VGND VGND VPWR VPWR sky130_fd_sc_hd__fill_1
XFILLER_0_41_230 VGND VGND VPWR VPWR sky130_fd_sc_hd__fill_2
XFILLER_0_112_652 VPWR VGND VPWR VGND sky130_ef_sc_hd__decap_12
XFILLER_0_112_641 VGND VGND VPWR VPWR sky130_fd_sc_hd__decap_3
X_06125_ tanh_inst.divider.x\[7\] _01070_ _04778_ VGND VGND VPWR VPWR _01071_ sky130_fd_sc_hd__mux2_1
XFILLER_0_75_3 VGND VGND VPWR VPWR sky130_fd_sc_hd__decap_6
XFILLER_0_14_477 VGND VGND VPWR VPWR sky130_fd_sc_hd__fill_2
XFILLER_0_78_83 VGND VGND VPWR VPWR sky130_fd_sc_hd__fill_1
X_06056_ mac_inst.z\[29\] _01004_ VGND VGND VPWR VPWR _01006_ sky130_fd_sc_hd__nor2_2
XFILLER_0_1_393 VPWR VGND VPWR VGND sky130_ef_sc_hd__decap_12
XTAP_TAPCELL_ROW_70_1135 VGND VPWR sky130_fd_sc_hd__tapvpwrvgnd_1
XTAP_TAPCELL_ROW_6_337 VGND VPWR sky130_fd_sc_hd__tapvpwrvgnd_1
X_09815_ _04419_ _04449_ _04450_ _04476_ _04536_ VGND VGND VPWR VPWR _04537_ sky130_fd_sc_hd__o41a_2
X_06958_ tanh_inst.divider.y_\[7\] _01792_ _01799_ _01776_ VGND VGND VPWR VPWR _01800_
+ sky130_fd_sc_hd__o22a_2
X_09746_ _04452_ _04453_ _04469_ tanh_inst.z_\[7\] VGND VGND VPWR VPWR _04470_ sky130_fd_sc_hd__a22o_2
XFILLER_0_69_617 VGND VGND VPWR VPWR sky130_fd_sc_hd__decap_6
X_05909_ mac_inst.z\[17\] _00869_ VGND VGND VPWR VPWR _00871_ sky130_fd_sc_hd__nor2_2
X_09677_ _04791_ _04387_ _04401_ _04402_ VGND VGND VPWR VPWR _04403_ sky130_fd_sc_hd__a22o_2
X_06889_ tanh_inst.divider.i\[2\] _01766_ _01769_ VGND VGND VPWR VPWR _00162_ sky130_fd_sc_hd__o21a_2
X_08628_ _03405_ _03408_ VGND VGND VPWR VPWR _03409_ sky130_fd_sc_hd__xnor2_2
XFILLER_0_68_149 VGND VGND VPWR VPWR sky130_fd_sc_hd__decap_6
XTAP_TAPCELL_ROW_53_921 VGND VPWR sky130_fd_sc_hd__tapvpwrvgnd_1
XFILLER_0_64_300 VGND VGND VPWR VPWR sky130_fd_sc_hd__fill_1
XFILLER_0_37_503 VGND VGND VPWR VPWR sky130_fd_sc_hd__fill_1
X_08559_ _03338_ _03341_ VGND VGND VPWR VPWR _03342_ sky130_fd_sc_hd__xnor2_2
XFILLER_0_92_642 VGND VGND VPWR VPWR sky130_fd_sc_hd__fill_2
XFILLER_0_91_130 VPWR VGND VPWR VGND sky130_ef_sc_hd__decap_12
XTAP_TAPCELL_ROW_81_1275 VGND VPWR sky130_fd_sc_hd__tapvpwrvgnd_1
XFILLER_0_119_273 VGND VGND VPWR VPWR sky130_fd_sc_hd__decap_6
XFILLER_0_107_446 VGND VGND VPWR VPWR sky130_fd_sc_hd__fill_2
XFILLER_0_92_697 VGND VGND VPWR VPWR sky130_fd_sc_hd__decap_3
X_10452_ clknet_leaf_7_clk _00309_ VGND VGND VPWR VPWR tanh_inst.divider.y\[-12\]
+ sky130_fd_sc_hd__dfxtp_2
XFILLER_0_17_293 VPWR VGND VPWR VGND sky130_ef_sc_hd__decap_12
X_10383_ clknet_leaf_7_clk _00240_ VGND VGND VPWR VPWR tanh_inst.divider.x\[-17\]
+ sky130_fd_sc_hd__dfxtp_2
XFILLER_0_60_561 VPWR VGND VPWR VGND sky130_ef_sc_hd__decap_12
XFILLER_0_32_274 VGND VGND VPWR VPWR sky130_fd_sc_hd__decap_8
XFILLER_0_102_195 VGND VGND VPWR VPWR sky130_fd_sc_hd__fill_1
XFILLER_0_99_230 VGND VGND VPWR VPWR sky130_fd_sc_hd__decap_8
XFILLER_0_99_252 VPWR VGND VPWR VGND sky130_ef_sc_hd__decap_12
XFILLER_0_99_285 VGND VGND VPWR VPWR sky130_fd_sc_hd__fill_1
XFILLER_0_99_274 VGND VGND VPWR VPWR sky130_fd_sc_hd__decap_6
XFILLER_0_90_29 VGND VGND VPWR VPWR sky130_fd_sc_hd__decap_6
XFILLER_0_87_458 VGND VGND VPWR VPWR sky130_fd_sc_hd__decap_4
XFILLER_0_87_447 VGND VGND VPWR VPWR sky130_fd_sc_hd__fill_1
XFILLER_0_68_683 VGND VGND VPWR VPWR sky130_fd_sc_hd__decap_4
XTAP_TAPCELL_ROW_99_1503 VGND VPWR sky130_fd_sc_hd__tapvpwrvgnd_1
XFILLER_0_99_27 VPWR VGND VPWR VGND sky130_ef_sc_hd__decap_12
XFILLER_0_82_141 VGND VGND VPWR VPWR sky130_fd_sc_hd__decap_6
XTAP_TAPCELL_ROW_31_648 VGND VPWR sky130_fd_sc_hd__tapvpwrvgnd_1
XFILLER_0_113_405 VGND VGND VPWR VPWR sky130_fd_sc_hd__decap_4
XTAP_TAPCELL_ROW_11_394 VGND VPWR sky130_fd_sc_hd__tapvpwrvgnd_1
XFILLER_0_61_9 VGND VGND VPWR VPWR sky130_fd_sc_hd__fill_1
XFILLER_0_11_447 VGND VGND VPWR VPWR sky130_fd_sc_hd__fill_1
X_07930_ _02635_ _02725_ _02726_ _02672_ VGND VGND VPWR VPWR _02728_ sky130_fd_sc_hd__a211o_2
X_07861_ tanh_inst.divider.y\[-13\] _02659_ VGND VGND VPWR VPWR _02660_ sky130_fd_sc_hd__nor2_2
X_07792_ tanh_inst.divider.y\[-15\] _02592_ VGND VGND VPWR VPWR _02593_ sky130_fd_sc_hd__xor2_2
X_09600_ _04252_ _04254_ _04327_ VGND VGND VPWR VPWR _04328_ sky130_fd_sc_hd__a21o_2
X_06812_ tanh_inst.z_\[-2\] _01703_ VGND VGND VPWR VPWR _01705_ sky130_fd_sc_hd__or2_2
XFILLER_0_3_55 VGND VGND VPWR VPWR sky130_fd_sc_hd__fill_1
XTAP_TAPCELL_ROW_108_1610 VGND VPWR sky130_fd_sc_hd__tapvpwrvgnd_1
X_09531_ _04259_ _04260_ VGND VGND VPWR VPWR _04261_ sky130_fd_sc_hd__nor2_2
XFILLER_0_64_41 VPWR VGND VPWR VGND sky130_ef_sc_hd__decap_12
XTAP_TAPCELL_ROW_39_748 VGND VPWR sky130_fd_sc_hd__tapvpwrvgnd_1
X_06743_ _01639_ _01641_ _01643_ VGND VGND VPWR VPWR _01644_ sky130_fd_sc_hd__or3_2
XFILLER_0_78_414 VGND VGND VPWR VPWR sky130_fd_sc_hd__decap_6
XFILLER_0_64_85 VGND VGND VPWR VPWR sky130_fd_sc_hd__fill_2
X_09462_ _04769_ _02053_ VGND VGND VPWR VPWR _04193_ sky130_fd_sc_hd__nand2_2
X_06674_ _01547_ tanh_inst.z_\[7\] _01581_ VGND VGND VPWR VPWR _01582_ sky130_fd_sc_hd__mux2_1
XFILLER_0_78_469 VGND VGND VPWR VPWR sky130_fd_sc_hd__fill_1
XFILLER_0_66_609 VGND VGND VPWR VPWR sky130_fd_sc_hd__fill_1
X_09393_ _04121_ _04126_ VGND VGND VPWR VPWR _04127_ sky130_fd_sc_hd__nand2b_2
X_08413_ _02053_ _02531_ _02834_ VGND VGND VPWR VPWR _03199_ sky130_fd_sc_hd__o21a_2
XTAP_TAPCELL_ROW_19_494 VGND VPWR sky130_fd_sc_hd__tapvpwrvgnd_1
XFILLER_0_19_503 VGND VGND VPWR VPWR sky130_fd_sc_hd__fill_1
X_05625_ _00599_ _00607_ VGND VGND VPWR VPWR _00611_ sky130_fd_sc_hd__nor2_2
XFILLER_0_74_631 VGND VGND VPWR VPWR sky130_fd_sc_hd__fill_2
X_08344_ tanh_inst.divider.y\[-2\] tanh_inst.divider.x\[-2\] VGND VGND VPWR VPWR _03132_
+ sky130_fd_sc_hd__or2_2
X_05556_ _00527_ _00537_ VGND VGND VPWR VPWR _00549_ sky130_fd_sc_hd__or2_2
XFILLER_0_73_152 VGND VGND VPWR VPWR sky130_fd_sc_hd__decap_4
XFILLER_0_46_377 VPWR VGND VPWR VGND sky130_ef_sc_hd__decap_12
XFILLER_0_73_185 VGND VGND VPWR VPWR sky130_fd_sc_hd__decap_6
X_08275_ _03062_ _03064_ _03060_ VGND VGND VPWR VPWR _03065_ sky130_fd_sc_hd__o21ai_2
X_05487_ _00476_ _00485_ VGND VGND VPWR VPWR _05487_/X sky130_fd_sc_hd__xor2_2
XTAP_TAPCELL_ROW_119_1750 VGND VPWR sky130_fd_sc_hd__tapvpwrvgnd_1
XFILLER_0_116_287 VGND VGND VPWR VPWR sky130_fd_sc_hd__fill_2
X_07226_ tanh_inst.divider.y\[-12\] _02028_ _02029_ VGND VGND VPWR VPWR _02036_ sky130_fd_sc_hd__o21a_2
X_07157_ _01966_ _01974_ _01976_ _01089_ VGND VGND VPWR VPWR _01978_ sky130_fd_sc_hd__a31o_2
XFILLER_0_30_701 VGND VGND VPWR VPWR sky130_fd_sc_hd__fill_2
X_06108_ _01047_ _01048_ _01053_ _01054_ VGND VGND VPWR VPWR _01055_ sky130_fd_sc_hd__or4_2
XFILLER_0_100_611 VGND VGND VPWR VPWR sky130_fd_sc_hd__decap_8
X_07088_ tanh_inst.divider.z_\[-6\] _01909_ _01915_ VGND VGND VPWR VPWR _01916_ sky130_fd_sc_hd__and3_2
X_06039_ _00990_ VGND VGND VPWR VPWR _00991_ sky130_fd_sc_hd__inv_2
XFILLER_0_97_701 VGND VGND VPWR VPWR sky130_fd_sc_hd__fill_2
X_09729_ _04449_ _04451_ tanh_inst.z_\[7\] VGND VGND VPWR VPWR _04453_ sky130_fd_sc_hd__a21oi_2
XTAP_TAPCELL_ROW_83_1304 VGND VPWR sky130_fd_sc_hd__tapvpwrvgnd_1
XFILLER_0_92_461 VGND VGND VPWR VPWR sky130_fd_sc_hd__fill_1
XFILLER_0_64_141 VGND VGND VPWR VPWR sky130_fd_sc_hd__decap_3
XFILLER_0_37_355 VPWR VGND VPWR VGND sky130_ef_sc_hd__decap_12
XFILLER_0_80_634 VGND VGND VPWR VPWR sky130_fd_sc_hd__decap_8
XFILLER_0_64_185 VGND VGND VPWR VPWR sky130_fd_sc_hd__decap_3
XPHY_EDGE_ROW_7_Left_129 VGND VGND VPWR VPWR sky130_fd_sc_hd__decap_3
XFILLER_0_25_528 VPWR VGND VPWR VGND sky130_ef_sc_hd__decap_12
XFILLER_0_100_27 VGND VGND VPWR VPWR sky130_fd_sc_hd__fill_1
X_10435_ clknet_leaf_40_clk _00292_ _00000_ VGND VGND VPWR VPWR mac_inst.i\[27\] sky130_fd_sc_hd__dfrtp_2
XFILLER_0_33_561 VPWR VGND VPWR VGND sky130_ef_sc_hd__decap_12
XFILLER_0_110_419 VGND VGND VPWR VPWR sky130_fd_sc_hd__fill_1
XFILLER_0_103_460 VGND VGND VPWR VPWR sky130_fd_sc_hd__decap_4
XTAP_TAPCELL_ROW_94_1433 VGND VPWR sky130_fd_sc_hd__tapvpwrvgnd_1
XFILLER_0_0_617 VGND VGND VPWR VPWR sky130_fd_sc_hd__fill_2
XFILLER_0_20_233 VPWR VGND VPWR VGND sky130_ef_sc_hd__decap_12
X_10366_ clknet_leaf_17_clk _00223_ VGND VGND VPWR VPWR tanh_inst.divider.z_\[2\]
+ sky130_fd_sc_hd__dfxtp_2
XFILLER_0_103_482 VPWR VGND VPWR VGND sky130_ef_sc_hd__decap_12
X_10297_ clknet_leaf_29_clk _00154_ VGND VGND VPWR VPWR tanh_inst.z_\[2\] sky130_fd_sc_hd__dfxtp_2
XFILLER_0_20_277 VPWR VGND VPWR VGND sky130_ef_sc_hd__decap_12
XFILLER_0_109_69 VPWR VGND VPWR VGND sky130_ef_sc_hd__decap_12
XFILLER_0_88_701 VGND VGND VPWR VPWR sky130_fd_sc_hd__decap_6
XTAP_TAPCELL_ROW_36_707 VGND VPWR sky130_fd_sc_hd__tapvpwrvgnd_1
XTAP_TAPCELL_ROW_36_718 VGND VPWR sky130_fd_sc_hd__tapvpwrvgnd_1
XTAP_TAPCELL_ROW_103_1551 VGND VPWR sky130_fd_sc_hd__tapvpwrvgnd_1
XFILLER_0_7_205 VPWR VGND VPWR VGND sky130_ef_sc_hd__decap_12
XTAP_TAPCELL_ROW_16_464 VGND VPWR sky130_fd_sc_hd__tapvpwrvgnd_1
X_05410_ mac_inst.i\[3\] _00413_ _00412_ VGND VGND VPWR VPWR _00414_ sky130_fd_sc_hd__o21a_2
X_06390_ _01088_ _01318_ _01319_ VGND VGND VPWR VPWR _00103_ sky130_fd_sc_hd__a21o_2
XFILLER_0_71_612 VGND VGND VPWR VPWR sky130_fd_sc_hd__decap_4
XFILLER_0_56_686 VPWR VGND VPWR VGND sky130_ef_sc_hd__decap_12
XFILLER_0_7_249 VPWR VGND VPWR VGND sky130_ef_sc_hd__decap_12
X_05341_ _00347_ _00348_ mac_inst.i\[2\] VGND VGND VPWR VPWR _00349_ sky130_fd_sc_hd__mux2_1
XFILLER_0_28_377 VGND VGND VPWR VPWR sky130_fd_sc_hd__decap_4
X_08060_ _02810_ _02815_ _02854_ VGND VGND VPWR VPWR _02855_ sky130_fd_sc_hd__a21oi_2
X_05272_ mac_inst.i\[13\] mac_inst.i\[15\] mac_inst.i\[14\] mac_inst.i\[16\] VGND
+ VGND VPWR VPWR _04973_ sky130_fd_sc_hd__and4_2
XFILLER_0_43_369 VGND VGND VPWR VPWR sky130_fd_sc_hd__decap_3
X_07011_ tanh_inst.divider.y_\[7\] _01847_ _01846_ tanh_inst.divider.z_\[-15\] VGND
+ VGND VPWR VPWR _01848_ sky130_fd_sc_hd__o211a_2
XFILLER_0_12_701 VGND VGND VPWR VPWR sky130_fd_sc_hd__fill_2
XFILLER_0_51_391 VGND VGND VPWR VPWR sky130_fd_sc_hd__fill_1
XTAP_TAPCELL_ROW_114_1691 VGND VPWR sky130_fd_sc_hd__tapvpwrvgnd_1
X_08962_ tanh_inst.divider.x\[-18\] tanh_inst.divider.x\[-17\] tanh_inst.divider.x\[-16\]
+ tanh_inst.divider.x\[-15\] tanh_inst.LOOKUP.index\[0\] tanh_inst.LOOKUP.index\[1\]
+ VGND VGND VPWR VPWR _03706_ sky130_fd_sc_hd__mux4_2
X_07913_ tanh_inst.divider.y\[-12\] tanh_inst.divider.x\[-12\] VGND VGND VPWR VPWR
+ _02711_ sky130_fd_sc_hd__nor2_2
X_08893_ tanh_inst.divider.x\[-19\] tanh_inst.divider.x\[-18\] tanh_inst.LOOKUP.index\[0\]
+ VGND VGND VPWR VPWR _03638_ sky130_fd_sc_hd__mux2_1
X_07844_ _02643_ VGND VGND VPWR VPWR _02644_ sky130_fd_sc_hd__inv_2
XFILLER_0_38_3 VGND VGND VPWR VPWR sky130_fd_sc_hd__decap_8
XFILLER_0_98_509 VGND VGND VPWR VPWR sky130_fd_sc_hd__decap_3
X_07775_ _02563_ _02576_ _02015_ VGND VGND VPWR VPWR _02577_ sky130_fd_sc_hd__a21o_2
X_09514_ _04243_ _02892_ VGND VGND VPWR VPWR _04244_ sky130_fd_sc_hd__nand2b_2
X_06726_ _01627_ _01628_ mac_y_out[12] _01469_ VGND VGND VPWR VPWR _00140_ sky130_fd_sc_hd__a2bb2o_2
X_09445_ tanh_inst.divider.x\[-11\] _04134_ _04132_ VGND VGND VPWR VPWR _04177_ sky130_fd_sc_hd__o21ai_2
XFILLER_0_91_83 VGND VGND VPWR VPWR sky130_fd_sc_hd__decap_6
X_06657_ _01560_ _01561_ _01558_ VGND VGND VPWR VPWR _01567_ sky130_fd_sc_hd__a21oi_2
XTAP_TAPCELL_ROW_65_1078 VGND VPWR sky130_fd_sc_hd__tapvpwrvgnd_1
X_05608_ _00566_ _00583_ _00582_ VGND VGND VPWR VPWR _00595_ sky130_fd_sc_hd__a21boi_2
X_09376_ _04105_ _04109_ VGND VGND VPWR VPWR _04110_ sky130_fd_sc_hd__nand2_2
X_06588_ _01502_ VGND VGND VPWR VPWR _01503_ sky130_fd_sc_hd__inv_2
XFILLER_0_74_494 VPWR VGND VPWR VGND sky130_ef_sc_hd__decap_12
X_08327_ _03074_ _03081_ _03113_ VGND VGND VPWR VPWR _03116_ sky130_fd_sc_hd__or3_2
XFILLER_0_34_303 VGND VGND VPWR VPWR sky130_fd_sc_hd__decap_4
X_05539_ _00532_ VGND VGND VPWR VPWR _00533_ sky130_fd_sc_hd__inv_2
X_08258_ _03046_ _03047_ VGND VGND VPWR VPWR _03048_ sky130_fd_sc_hd__nand2_2
X_07209_ _01522_ _01527_ tanh_inst.LOOKUP.index\[4\] VGND VGND VPWR VPWR _02019_ sky130_fd_sc_hd__a21o_2
XFILLER_0_61_177 VGND VGND VPWR VPWR sky130_fd_sc_hd__fill_1
XFILLER_0_15_561 VGND VGND VPWR VPWR sky130_fd_sc_hd__decap_8
XFILLER_0_120_706 VGND VGND VPWR VPWR sky130_fd_sc_hd__fill_1
X_08189_ _02895_ _02930_ VGND VGND VPWR VPWR _02981_ sky130_fd_sc_hd__nor2_2
X_10220_ clknet_leaf_30_clk mac_inst.y\[14\] _00000_ VGND VGND VPWR VPWR mac_y_out[14]
+ sky130_fd_sc_hd__dfrtp_2
X_10082_ clknet_leaf_11_clk _00099_ VGND VGND VPWR VPWR tanh_inst.divider.y_\[-11\]
+ sky130_fd_sc_hd__dfxtp_2
XFILLER_0_100_474 VGND VGND VPWR VPWR sky130_fd_sc_hd__fill_2
XFILLER_0_97_531 VGND VGND VPWR VPWR sky130_fd_sc_hd__fill_1
XFILLER_0_69_222 VGND VGND VPWR VPWR sky130_fd_sc_hd__fill_2
XFILLER_0_97_575 VGND VGND VPWR VPWR sky130_fd_sc_hd__fill_1
XFILLER_0_57_417 VGND VGND VPWR VPWR sky130_fd_sc_hd__decap_6
XFILLER_0_57_406 VGND VGND VPWR VPWR sky130_fd_sc_hd__fill_2
XFILLER_0_69_288 VGND VGND VPWR VPWR sky130_fd_sc_hd__fill_1
XTAP_TAPCELL_ROW_13_423 VGND VPWR sky130_fd_sc_hd__tapvpwrvgnd_1
XFILLER_0_38_642 VGND VGND VPWR VPWR sky130_fd_sc_hd__fill_2
XFILLER_0_53_634 VGND VGND VPWR VPWR sky130_fd_sc_hd__decap_6
XTAP_TAPCELL_ROW_41_776 VGND VPWR sky130_fd_sc_hd__tapvpwrvgnd_1
XFILLER_0_111_15 VPWR VGND VPWR VGND sky130_ef_sc_hd__decap_12
XFILLER_0_108_585 VGND VGND VPWR VPWR sky130_fd_sc_hd__decap_3
XFILLER_0_92_291 VGND VGND VPWR VPWR sky130_fd_sc_hd__fill_1
X_10418_ clknet_leaf_37_clk _00275_ _00000_ VGND VGND VPWR VPWR mac_inst.i\[10\] sky130_fd_sc_hd__dfrtp_2
X_10349_ clknet_leaf_14_clk _00206_ VGND VGND VPWR VPWR tanh_inst.divider.z_\[-15\]
+ sky130_fd_sc_hd__dfxtp_2
XFILLER_0_103_290 VPWR VGND VPWR VGND sky130_ef_sc_hd__decap_12
XFILLER_0_0_447 VGND VGND VPWR VPWR sky130_fd_sc_hd__fill_1
XFILLER_0_21_586 VGND VGND VPWR VPWR sky130_fd_sc_hd__fill_1
XFILLER_0_29_55 VGND VGND VPWR VPWR sky130_fd_sc_hd__fill_1
X_05890_ mac_inst.z\[16\] _00852_ VGND VGND VPWR VPWR _00853_ sky130_fd_sc_hd__or2_2
XFILLER_0_45_32 VGND VGND VPWR VPWR sky130_fd_sc_hd__fill_1
XFILLER_0_45_54 VGND VGND VPWR VPWR sky130_fd_sc_hd__fill_2
XTAP_TAPCELL_ROW_49_876 VGND VPWR sky130_fd_sc_hd__tapvpwrvgnd_1
X_07560_ _02116_ _02118_ _04759_ VGND VGND VPWR VPWR _02366_ sky130_fd_sc_hd__mux2_1
X_06511_ tanh_inst.divider.i\[4\] _01247_ _01289_ VGND VGND VPWR VPWR _01430_ sky130_fd_sc_hd__o21a_2
X_09230_ _03964_ _03966_ _03967_ VGND VGND VPWR VPWR _03968_ sky130_fd_sc_hd__a21o_2
X_07491_ tanh_inst.z_\[7\] _02297_ VGND VGND VPWR VPWR _02298_ sky130_fd_sc_hd__nand2_2
XFILLER_0_75_225 VGND VGND VPWR VPWR sky130_fd_sc_hd__decap_3
XFILLER_0_61_42 VGND VGND VPWR VPWR sky130_fd_sc_hd__fill_2
XFILLER_0_61_20 VGND VGND VPWR VPWR sky130_fd_sc_hd__decap_6
X_06442_ tanh_inst.divider.i\[4\] _01175_ _01289_ VGND VGND VPWR VPWR _01367_ sky130_fd_sc_hd__o21a_2
XFILLER_0_61_75 VGND VGND VPWR VPWR sky130_fd_sc_hd__decap_6
X_06373_ tanh_inst.divider.y_\[-8\] _01302_ VGND VGND VPWR VPWR _01304_ sky130_fd_sc_hd__or2_2
X_09161_ _03858_ _03859_ tanh_inst.z_\[7\] VGND VGND VPWR VPWR _03901_ sky130_fd_sc_hd__a21o_2
XFILLER_0_8_547 VGND VGND VPWR VPWR sky130_fd_sc_hd__fill_2
X_09092_ _03831_ _03832_ _02023_ VGND VGND VPWR VPWR _03833_ sky130_fd_sc_hd__mux2_1
X_08112_ _02905_ _02745_ VGND VGND VPWR VPWR _02906_ sky130_fd_sc_hd__nand2b_2
X_05324_ _04855_ _04857_ _04898_ _04900_ _04783_ _04789_ VGND VGND VPWR VPWR _05023_
+ sky130_fd_sc_hd__mux4_2
XFILLER_0_43_144 VGND VGND VPWR VPWR sky130_fd_sc_hd__decap_8
XFILLER_0_44_645 VGND VGND VPWR VPWR sky130_fd_sc_hd__fill_2
XFILLER_0_114_533 VGND VGND VPWR VPWR sky130_fd_sc_hd__decap_8
X_08043_ tanh_inst.divider.x\[-9\] _02837_ VGND VGND VPWR VPWR _02838_ sky130_fd_sc_hd__and2_2
XFILLER_0_16_369 VGND VGND VPWR VPWR sky130_fd_sc_hd__fill_1
XFILLER_0_114_566 VGND VGND VPWR VPWR sky130_fd_sc_hd__decap_3
XFILLER_0_102_706 VGND VGND VPWR VPWR sky130_fd_sc_hd__fill_1
XFILLER_0_12_520 VGND VGND VPWR VPWR sky130_fd_sc_hd__fill_1
X_05255_ _04846_ _04946_ VGND VGND VPWR VPWR _04956_ sky130_fd_sc_hd__nor2_2
XFILLER_0_114_599 VPWR VGND VPWR VGND sky130_ef_sc_hd__decap_12
X_05186_ mac_inst.x\[10\] _04852_ _04853_ VGND VGND VPWR VPWR _04890_ sky130_fd_sc_hd__a21oi_2
X_09994_ _04708_ _04709_ VGND VGND VPWR VPWR _04710_ sky130_fd_sc_hd__and2b_2
XFILLER_0_12_575 VPWR VGND VPWR VGND sky130_ef_sc_hd__decap_12
X_08945_ _03687_ _03688_ VGND VGND VPWR VPWR _03689_ sky130_fd_sc_hd__xor2_2
X_08876_ _03585_ _03620_ VGND VGND VPWR VPWR _03621_ sky130_fd_sc_hd__nor2_2
X_07827_ _02625_ _02626_ VGND VGND VPWR VPWR _02627_ sky130_fd_sc_hd__nor2_2
X_07758_ _02460_ _02505_ _02506_ VGND VGND VPWR VPWR _02560_ sky130_fd_sc_hd__a21bo_2
XFILLER_0_94_501 VGND VGND VPWR VPWR sky130_fd_sc_hd__decap_4
X_06709_ mac_y_out[10] _01469_ _01612_ _01613_ VGND VGND VPWR VPWR _00138_ sky130_fd_sc_hd__a22o_2
XFILLER_0_109_305 VGND VGND VPWR VPWR sky130_fd_sc_hd__decap_8
X_07689_ _02491_ tanh_inst.divider.x\[-17\] VGND VGND VPWR VPWR _02492_ sky130_fd_sc_hd__and2b_2
XFILLER_0_94_523 VGND VGND VPWR VPWR sky130_fd_sc_hd__fill_2
XFILLER_0_94_567 VGND VGND VPWR VPWR sky130_fd_sc_hd__decap_3
XFILLER_0_66_247 VGND VGND VPWR VPWR sky130_fd_sc_hd__decap_4
X_09428_ _01477_ _03897_ VGND VGND VPWR VPWR _04160_ sky130_fd_sc_hd__or2_2
X_09359_ _03973_ _03993_ _04092_ VGND VGND VPWR VPWR _04093_ sky130_fd_sc_hd__and3_2
XFILLER_0_47_461 VGND VGND VPWR VPWR sky130_fd_sc_hd__decap_4
XFILLER_0_117_360 VPWR VGND VPWR VGND sky130_ef_sc_hd__decap_12
XTAP_TAPCELL_ROW_78_1236 VGND VPWR sky130_fd_sc_hd__tapvpwrvgnd_1
XFILLER_0_62_475 VGND VGND VPWR VPWR sky130_fd_sc_hd__fill_1
XFILLER_0_105_555 VGND VGND VPWR VPWR sky130_fd_sc_hd__decap_4
XPHY_EDGE_ROW_97_Left_219 VGND VGND VPWR VPWR sky130_fd_sc_hd__decap_3
XTAP_TAPCELL_ROW_91_1403 VGND VPWR sky130_fd_sc_hd__tapvpwrvgnd_1
XFILLER_0_30_350 VGND VGND VPWR VPWR sky130_fd_sc_hd__fill_2
XFILLER_0_30_383 VGND VGND VPWR VPWR sky130_fd_sc_hd__decap_8
X_10203_ x_in[29] _00000_ VGND VGND VPWR VPWR mac_inst.x\[29\] sky130_fd_sc_hd__dlxtn_1
XFILLER_0_100_293 VGND VGND VPWR VPWR sky130_fd_sc_hd__fill_1
X_10065_ rst VGND VGND VPWR VPWR _00084_ sky130_fd_sc_hd__inv_2
XFILLER_0_106_15 VPWR VGND VPWR VGND sky130_ef_sc_hd__decap_12
XTAP_TAPCELL_ROW_89_1376 VGND VPWR sky130_fd_sc_hd__tapvpwrvgnd_1
XFILLER_0_15_57 VPWR VGND VPWR VGND sky130_ef_sc_hd__decap_12
XTAP_TAPCELL_ROW_46_835 VGND VPWR sky130_fd_sc_hd__tapvpwrvgnd_1
XTAP_TAPCELL_ROW_100_1510 VGND VPWR sky130_fd_sc_hd__tapvpwrvgnd_1
XTAP_TAPCELL_ROW_26_581 VGND VPWR sky130_fd_sc_hd__tapvpwrvgnd_1
XTAP_TAPCELL_ROW_26_592 VGND VPWR sky130_fd_sc_hd__tapvpwrvgnd_1
XFILLER_0_108_360 VGND VGND VPWR VPWR sky130_fd_sc_hd__decap_4
XFILLER_0_5_528 VGND VGND VPWR VPWR sky130_fd_sc_hd__decap_4
XFILLER_0_5_517 VGND VGND VPWR VPWR sky130_fd_sc_hd__decap_4
XFILLER_0_26_645 VGND VGND VPWR VPWR sky130_fd_sc_hd__decap_4
XFILLER_0_53_420 VGND VGND VPWR VPWR sky130_fd_sc_hd__decap_3
XFILLER_0_13_317 VPWR VGND VPWR VGND sky130_ef_sc_hd__decap_12
XFILLER_0_26_689 VGND VGND VPWR VPWR sky130_fd_sc_hd__decap_4
XFILLER_0_25_177 VGND VGND VPWR VPWR sky130_fd_sc_hd__fill_2
XFILLER_0_41_659 VGND VGND VPWR VPWR sky130_fd_sc_hd__fill_2
X_05040_ tanh_inst.divider.y\[-1\] VGND VGND VPWR VPWR _04764_ sky130_fd_sc_hd__inv_2
XFILLER_0_0_277 VGND VGND VPWR VPWR sky130_fd_sc_hd__decap_3
XTAP_TAPCELL_ROW_111_1650 VGND VPWR sky130_fd_sc_hd__tapvpwrvgnd_1
X_06991_ tanh_inst.divider.i\[2\] _01035_ _01818_ VGND VGND VPWR VPWR _01830_ sky130_fd_sc_hd__o21a_2
X_05942_ _00704_ _00847_ _00900_ mac_inst.z\[31\] VGND VGND VPWR VPWR _00901_ sky130_fd_sc_hd__o22ai_2
X_08730_ mac_inst.i\[14\] _00962_ VGND VGND VPWR VPWR _00279_ sky130_fd_sc_hd__xor2_2
X_08661_ tanh_inst.divider.x\[6\] _03439_ VGND VGND VPWR VPWR _03441_ sky130_fd_sc_hd__or2_2
X_05873_ _00691_ _00717_ _04782_ VGND VGND VPWR VPWR _00837_ sky130_fd_sc_hd__and3b_2
X_07612_ _02179_ _02181_ tanh_inst.LOOKUP.index\[2\] VGND VGND VPWR VPWR _02417_ sky130_fd_sc_hd__mux2_1
X_08592_ _03260_ _03305_ _03343_ VGND VGND VPWR VPWR _03374_ sky130_fd_sc_hd__nand3_2
XFILLER_0_119_603 VGND VGND VPWR VPWR sky130_fd_sc_hd__decap_4
X_07543_ tanh_inst.divider.y\[-20\] _02347_ VGND VGND VPWR VPWR _02349_ sky130_fd_sc_hd__xor2_2
XFILLER_0_72_85 VGND VGND VPWR VPWR sky130_fd_sc_hd__decap_3
XFILLER_0_72_74 VGND VGND VPWR VPWR sky130_fd_sc_hd__decap_8
X_07474_ tanh_inst.divider.y\[7\] _02280_ _02025_ VGND VGND VPWR VPWR _02281_ sky130_fd_sc_hd__mux2_1
XTAP_TAPCELL_ROW_62_1037 VGND VPWR sky130_fd_sc_hd__tapvpwrvgnd_1
XFILLER_0_119_669 VGND VGND VPWR VPWR sky130_fd_sc_hd__decap_3
X_06425_ _01305_ _01316_ _01349_ VGND VGND VPWR VPWR _01352_ sky130_fd_sc_hd__and3_2
X_09213_ _03950_ _03951_ VGND VGND VPWR VPWR _03952_ sky130_fd_sc_hd__xnor2_2
XFILLER_0_8_333 VPWR VGND VPWR VGND sky130_ef_sc_hd__decap_12
XFILLER_0_118_179 VGND VGND VPWR VPWR sky130_fd_sc_hd__decap_8
X_09144_ _03883_ VGND VGND VPWR VPWR _03884_ sky130_fd_sc_hd__inv_2
XFILLER_0_16_133 VGND VGND VPWR VPWR sky130_fd_sc_hd__decap_6
X_06356_ _01088_ _01287_ _01288_ VGND VGND VPWR VPWR _00100_ sky130_fd_sc_hd__a21o_2
XFILLER_0_32_604 VGND VGND VPWR VPWR sky130_fd_sc_hd__decap_4
XFILLER_0_44_475 VGND VGND VPWR VPWR sky130_fd_sc_hd__fill_1
X_06287_ _01222_ _01223_ _01224_ VGND VGND VPWR VPWR _01225_ sky130_fd_sc_hd__a21boi_2
X_09075_ tanh_inst.z_\[7\] _03816_ VGND VGND VPWR VPWR _03817_ sky130_fd_sc_hd__nor2_2
XFILLER_0_16_177 VPWR VGND VPWR VGND sky130_ef_sc_hd__decap_12
X_05307_ mac_inst.i\[3\] _04997_ _05000_ _05006_ VGND VGND VPWR VPWR _05007_ sky130_fd_sc_hd__a211oi_2
XFILLER_0_114_385 VGND VGND VPWR VPWR sky130_fd_sc_hd__fill_2
X_08026_ _02645_ _02735_ _02736_ _02775_ VGND VGND VPWR VPWR _02822_ sky130_fd_sc_hd__and4_2
X_05238_ _04840_ _04841_ _04938_ VGND VGND VPWR VPWR _04939_ sky130_fd_sc_hd__or3_2
XFILLER_0_31_169 VGND VGND VPWR VPWR sky130_fd_sc_hd__decap_3
XFILLER_0_12_383 VGND VGND VPWR VPWR sky130_fd_sc_hd__fill_1
X_05169_ _04869_ _04870_ _04871_ _04872_ _04783_ mac_inst.i\[1\] VGND VGND VPWR VPWR
+ _04873_ sky130_fd_sc_hd__mux4_2
XTAP_TAPCELL_ROW_73_1177 VGND VPWR sky130_fd_sc_hd__tapvpwrvgnd_1
X_09977_ _04692_ _04693_ VGND VGND VPWR VPWR _04694_ sky130_fd_sc_hd__xnor2_2
X_08928_ _02026_ _03534_ VGND VGND VPWR VPWR _03672_ sky130_fd_sc_hd__nand2_2
X_08859_ _02027_ _03601_ _03602_ _03600_ _02024_ VGND VGND VPWR VPWR _03604_ sky130_fd_sc_hd__o311a_2
XFILLER_0_86_309 VGND VGND VPWR VPWR sky130_fd_sc_hd__decap_6
XFILLER_0_39_225 VGND VGND VPWR VPWR sky130_fd_sc_hd__decap_4
XTAP_TAPCELL_ROW_43_805 VGND VPWR sky130_fd_sc_hd__tapvpwrvgnd_1
XFILLER_0_109_113 VPWR VGND VPWR VGND sky130_ef_sc_hd__decap_12
XFILLER_0_39_258 VGND VGND VPWR VPWR sky130_fd_sc_hd__fill_2
XFILLER_0_94_386 VGND VGND VPWR VPWR sky130_fd_sc_hd__fill_1
XFILLER_0_82_526 VGND VGND VPWR VPWR sky130_fd_sc_hd__decap_6
XTAP_TAPCELL_ROW_23_551 VGND VPWR sky130_fd_sc_hd__tapvpwrvgnd_1
XFILLER_0_120_344 VGND VGND VPWR VPWR sky130_fd_sc_hd__decap_6
XFILLER_0_10_309 VPWR VGND VPWR VGND sky130_ef_sc_hd__decap_12
XFILLER_0_101_591 VGND VGND VPWR VPWR sky130_fd_sc_hd__decap_4
X_10048_ rst VGND VGND VPWR VPWR _00067_ sky130_fd_sc_hd__inv_2
XFILLER_0_117_69 VPWR VGND VPWR VGND sky130_ef_sc_hd__decap_12
XFILLER_0_58_501 VPWR VGND VPWR VGND sky130_ef_sc_hd__decap_12
XFILLER_0_97_191 VGND VGND VPWR VPWR sky130_fd_sc_hd__fill_1
XFILLER_0_58_545 VPWR VGND VPWR VGND sky130_ef_sc_hd__decap_12
XFILLER_0_73_537 VGND VGND VPWR VPWR sky130_fd_sc_hd__fill_2
XFILLER_0_58_589 VGND VGND VPWR VPWR sky130_fd_sc_hd__decap_3
XFILLER_0_115_105 VGND VGND VPWR VPWR sky130_fd_sc_hd__decap_6
X_06210_ _01134_ _01135_ _01132_ VGND VGND VPWR VPWR _01153_ sky130_fd_sc_hd__a21o_2
XFILLER_0_42_99 VGND VGND VPWR VPWR sky130_fd_sc_hd__fill_2
X_07190_ _01997_ _01998_ VGND VGND VPWR VPWR _02006_ sky130_fd_sc_hd__and2_2
XFILLER_0_60_209 VGND VGND VPWR VPWR sky130_fd_sc_hd__decap_4
X_06141_ tanh_inst.divider.y_\[-23\] _01085_ VGND VGND VPWR VPWR _01087_ sky130_fd_sc_hd__xnor2_2
XFILLER_0_13_125 VPWR VGND VPWR VGND sky130_ef_sc_hd__decap_12
XFILLER_0_41_423 VPWR VGND VPWR VGND sky130_ef_sc_hd__decap_12
X_06072_ tanh_inst.divider.x\[-8\] tanh_inst.divider.x\[-7\] tanh_inst.divider.x\[-6\]
+ tanh_inst.divider.x\[-5\] tanh_inst.divider.i\[0\] tanh_inst.divider.i\[1\] VGND
+ VGND VPWR VPWR _01019_ sky130_fd_sc_hd__mux4_2
X_09900_ tanh_inst.divider.x\[3\] _04617_ VGND VGND VPWR VPWR _04619_ sky130_fd_sc_hd__and2_2
XFILLER_0_13_169 VPWR VGND VPWR VGND sky130_ef_sc_hd__decap_12
XFILLER_0_111_366 VGND VGND VPWR VPWR sky130_fd_sc_hd__decap_4
XFILLER_0_1_586 VPWR VGND VPWR VGND sky130_ef_sc_hd__decap_12
XFILLER_0_22_692 VGND VGND VPWR VPWR sky130_fd_sc_hd__decap_8
XFILLER_0_6_77 VGND VGND VPWR VPWR sky130_fd_sc_hd__decap_6
X_09831_ tanh_inst.divider.y\[1\] _04546_ VGND VGND VPWR VPWR _04552_ sky130_fd_sc_hd__and2_2
X_06974_ tanh_inst.divider.z_\[-19\] _01812_ VGND VGND VPWR VPWR _01815_ sky130_fd_sc_hd__and2_2
X_09762_ _04483_ _04484_ VGND VGND VPWR VPWR _04485_ sky130_fd_sc_hd__nor2_2
X_05925_ _00854_ _00872_ _00871_ VGND VGND VPWR VPWR _00886_ sky130_fd_sc_hd__a21oi_2
X_08713_ mac_inst.i\[3\] _00954_ VGND VGND VPWR VPWR _03488_ sky130_fd_sc_hd__nor2_2
XFILLER_0_20_3 VPWR VGND VPWR VGND sky130_ef_sc_hd__decap_12
X_09693_ _04416_ _04417_ VGND VGND VPWR VPWR _04418_ sky130_fd_sc_hd__xnor2_2
X_08644_ _03364_ _03371_ _03423_ VGND VGND VPWR VPWR _03425_ sky130_fd_sc_hd__or3_2
X_05856_ mac_inst.i\[2\] _04944_ _00676_ _00716_ VGND VGND VPWR VPWR _00821_ sky130_fd_sc_hd__or4_2
X_08575_ _02052_ _02690_ _02833_ VGND VGND VPWR VPWR _03357_ sky130_fd_sc_hd__a21oi_2
X_05787_ _00736_ _00757_ _00744_ VGND VGND VPWR VPWR _00758_ sky130_fd_sc_hd__a21o_2
XTAP_TAPCELL_ROW_1_279 VGND VPWR sky130_fd_sc_hd__tapvpwrvgnd_1
XFILLER_0_49_534 VGND VGND VPWR VPWR sky130_fd_sc_hd__decap_6
XFILLER_0_88_180 VPWR VGND VPWR VGND sky130_ef_sc_hd__decap_12
X_07526_ _02331_ _02332_ _02019_ VGND VGND VPWR VPWR _02333_ sky130_fd_sc_hd__a21o_2
XFILLER_0_49_556 VGND VGND VPWR VPWR sky130_fd_sc_hd__decap_4
XFILLER_0_9_653 VGND VGND VPWR VPWR sky130_fd_sc_hd__decap_4
XFILLER_0_91_334 VGND VGND VPWR VPWR sky130_fd_sc_hd__fill_2
X_07457_ _02197_ _02199_ _02196_ VGND VGND VPWR VPWR _02265_ sky130_fd_sc_hd__o21bai_2
XFILLER_0_8_141 VPWR VGND VPWR VGND sky130_ef_sc_hd__decap_12
X_06408_ tanh_inst.divider.y_\[-5\] _01335_ VGND VGND VPWR VPWR _01336_ sky130_fd_sc_hd__nor2_2
XFILLER_0_91_389 VGND VGND VPWR VPWR sky130_fd_sc_hd__decap_3
X_07388_ tanh_inst.divider.x\[-23\] _02195_ VGND VGND VPWR VPWR _02197_ sky130_fd_sc_hd__nor2_2
XTAP_TAPCELL_ROW_20_510 VGND VPWR sky130_fd_sc_hd__tapvpwrvgnd_1
X_06339_ _01270_ _01272_ VGND VGND VPWR VPWR _01273_ sky130_fd_sc_hd__and2_2
XFILLER_0_106_149 VGND VGND VPWR VPWR sky130_fd_sc_hd__decap_3
X_09127_ _03795_ _03843_ _03844_ VGND VGND VPWR VPWR _03867_ sky130_fd_sc_hd__a21bo_2
XFILLER_0_115_694 VGND VGND VPWR VPWR sky130_fd_sc_hd__fill_2
X_09058_ _03782_ _03797_ _03799_ VGND VGND VPWR VPWR _03800_ sky130_fd_sc_hd__a21o_2
X_08009_ _02718_ _02804_ _02547_ VGND VGND VPWR VPWR _02805_ sky130_fd_sc_hd__or3b_2
XTAP_TAPCELL_ROW_9_379 VGND VPWR sky130_fd_sc_hd__tapvpwrvgnd_1
XFILLER_0_99_467 VGND VGND VPWR VPWR sky130_fd_sc_hd__fill_1
XTAP_TAPCELL_ROW_86_1335 VGND VPWR sky130_fd_sc_hd__tapvpwrvgnd_1
XTAP_TAPCELL_ROW_28_610 VGND VPWR sky130_fd_sc_hd__tapvpwrvgnd_1
XTAP_TAPCELL_ROW_56_963 VGND VPWR sky130_fd_sc_hd__tapvpwrvgnd_1
XFILLER_0_55_526 VPWR VGND VPWR VGND sky130_ef_sc_hd__decap_12
XFILLER_0_103_27 VPWR VGND VPWR VGND sky130_ef_sc_hd__decap_12
XFILLER_0_94_194 VGND VGND VPWR VPWR sky130_fd_sc_hd__fill_2
XTAP_TAPCELL_ROW_97_1475 VGND VPWR sky130_fd_sc_hd__tapvpwrvgnd_1
XFILLER_0_23_445 VGND VGND VPWR VPWR sky130_fd_sc_hd__decap_3
XFILLER_0_11_629 VGND VGND VPWR VPWR sky130_fd_sc_hd__decap_3
XFILLER_0_50_253 VPWR VGND VPWR VGND sky130_ef_sc_hd__decap_12
XFILLER_0_120_141 VPWR VGND VPWR VGND sky130_ef_sc_hd__decap_12
XFILLER_0_10_139 VGND VGND VPWR VPWR sky130_fd_sc_hd__fill_1
XFILLER_0_121_697 VGND VGND VPWR VPWR sky130_fd_sc_hd__decap_3
X_06690_ _01594_ _01595_ VGND VGND VPWR VPWR _01597_ sky130_fd_sc_hd__and2_2
X_05710_ mac_inst.z\[2\] _00683_ VGND VGND VPWR VPWR _00687_ sky130_fd_sc_hd__xnor2_2
X_05641_ _00622_ _00625_ VGND VGND VPWR VPWR _05641_/X sky130_fd_sc_hd__xor2_2
XFILLER_0_19_707 VPWR VGND VPWR VGND sky130_ef_sc_hd__decap_12
X_08360_ tanh_inst.divider.y\[-2\] _03147_ VGND VGND VPWR VPWR _03148_ sky130_fd_sc_hd__nor2_2
XFILLER_0_53_87 VGND VGND VPWR VPWR sky130_fd_sc_hd__decap_6
XTAP_TAPCELL_ROW_106_1593 VGND VPWR sky130_fd_sc_hd__tapvpwrvgnd_1
XTAP_TAPCELL_ROW_106_1582 VGND VPWR sky130_fd_sc_hd__tapvpwrvgnd_1
XFILLER_0_58_353 VGND VGND VPWR VPWR sky130_fd_sc_hd__decap_8
X_07311_ _02115_ _02116_ _02118_ _02119_ _04759_ _04758_ VGND VGND VPWR VPWR _02121_
+ sky130_fd_sc_hd__mux4_2
X_05572_ mac_inst.y\[20\] _00562_ VGND VGND VPWR VPWR _00563_ sky130_fd_sc_hd__nand2_2
XFILLER_0_53_98 VGND VGND VPWR VPWR sky130_fd_sc_hd__decap_4
X_08291_ _03075_ _03079_ VGND VGND VPWR VPWR _03081_ sky130_fd_sc_hd__nor2_2
X_07242_ _02028_ _02051_ VGND VGND VPWR VPWR _02052_ sky130_fd_sc_hd__nor2_2
XFILLER_0_5_111 VGND VGND VPWR VPWR sky130_fd_sc_hd__fill_1
X_07173_ tanh_inst.divider.z_\[3\] tanh_inst.divider.z_\[2\] _01975_ VGND VGND VPWR
+ VPWR _01991_ sky130_fd_sc_hd__o21ai_2
XFILLER_0_26_250 VGND VGND VPWR VPWR sky130_fd_sc_hd__fill_2
X_06124_ tanh_inst.divider.x\[5\] tanh_inst.divider.x\[6\] tanh_inst.divider.i\[0\]
+ VGND VGND VPWR VPWR _01070_ sky130_fd_sc_hd__mux2_1
XFILLER_0_14_456 VGND VGND VPWR VPWR sky130_fd_sc_hd__fill_1
XFILLER_0_112_664 VGND VGND VPWR VPWR sky130_fd_sc_hd__decap_8
XFILLER_0_68_3 VPWR VGND VPWR VGND sky130_ef_sc_hd__decap_12
XFILLER_0_1_361 VPWR VGND VPWR VGND sky130_ef_sc_hd__decap_12
X_06055_ mac_inst.z\[29\] _01004_ VGND VGND VPWR VPWR _01005_ sky130_fd_sc_hd__and2_2
XFILLER_0_111_185 VGND VGND VPWR VPWR sky130_fd_sc_hd__fill_1
XFILLER_0_10_651 VGND VGND VPWR VPWR sky130_fd_sc_hd__fill_1
XTAP_TAPCELL_ROW_70_1136 VGND VPWR sky130_fd_sc_hd__tapvpwrvgnd_1
XFILLER_0_10_673 VGND VGND VPWR VPWR sky130_fd_sc_hd__decap_3
XTAP_TAPCELL_ROW_6_338 VGND VPWR sky130_fd_sc_hd__tapvpwrvgnd_1
X_09814_ _04448_ _04475_ _04474_ VGND VGND VPWR VPWR _04536_ sky130_fd_sc_hd__a21o_2
X_06957_ _04777_ _01034_ VGND VGND VPWR VPWR _01799_ sky130_fd_sc_hd__or2_2
X_09745_ _04463_ _04467_ VGND VGND VPWR VPWR _04469_ sky130_fd_sc_hd__xor2_2
X_06888_ tanh_inst.div_en _01768_ VGND VGND VPWR VPWR _01769_ sky130_fd_sc_hd__nor2_2
X_05908_ _00848_ _00851_ mac_inst.z\[31\] VGND VGND VPWR VPWR _00870_ sky130_fd_sc_hd__a21o_2
X_09676_ _04396_ _04400_ tanh_inst.z_\[7\] VGND VGND VPWR VPWR _04402_ sky130_fd_sc_hd__o21a_2
X_08627_ _03406_ _03407_ VGND VGND VPWR VPWR _03408_ sky130_fd_sc_hd__nand2b_2
XFILLER_0_68_128 VGND VGND VPWR VPWR sky130_fd_sc_hd__decap_4
X_05839_ _00778_ _00789_ _00791_ VGND VGND VPWR VPWR _00806_ sky130_fd_sc_hd__o21ai_2
XTAP_TAPCELL_ROW_53_922 VGND VPWR sky130_fd_sc_hd__tapvpwrvgnd_1
XFILLER_0_83_109 VGND VGND VPWR VPWR sky130_fd_sc_hd__decap_3
XFILLER_0_77_673 VPWR VGND VPWR VGND sky130_ef_sc_hd__decap_12
X_08558_ _03339_ _03340_ VGND VGND VPWR VPWR _03341_ sky130_fd_sc_hd__nand2b_2
XFILLER_0_91_120 VGND VGND VPWR VPWR sky130_fd_sc_hd__decap_4
XTAP_TAPCELL_ROW_81_1276 VGND VPWR sky130_fd_sc_hd__tapvpwrvgnd_1
XFILLER_0_37_559 VGND VGND VPWR VPWR sky130_fd_sc_hd__fill_1
X_08489_ _04757_ _02600_ _02858_ VGND VGND VPWR VPWR _03274_ sky130_fd_sc_hd__a21o_2
X_07509_ _02312_ _02315_ tanh_inst.LOOKUP.index\[3\] VGND VGND VPWR VPWR _02316_ sky130_fd_sc_hd__mux2_1
XFILLER_0_107_414 VGND VGND VPWR VPWR sky130_fd_sc_hd__fill_2
XFILLER_0_92_687 VGND VGND VPWR VPWR sky130_fd_sc_hd__fill_2
XFILLER_0_92_665 VGND VGND VPWR VPWR sky130_fd_sc_hd__fill_1
XFILLER_0_91_153 VPWR VGND VPWR VGND sky130_ef_sc_hd__decap_12
XFILLER_0_91_142 VGND VGND VPWR VPWR sky130_fd_sc_hd__decap_4
XFILLER_0_64_378 VPWR VGND VPWR VGND sky130_ef_sc_hd__decap_12
X_10451_ clknet_leaf_9_clk _00308_ VGND VGND VPWR VPWR tanh_inst.divider.y\[-13\]
+ sky130_fd_sc_hd__dfxtp_2
XFILLER_0_17_261 VPWR VGND VPWR VGND sky130_ef_sc_hd__decap_12
XFILLER_0_32_231 VGND VGND VPWR VPWR sky130_fd_sc_hd__fill_1
X_10382_ clknet_leaf_9_clk _00239_ VGND VGND VPWR VPWR tanh_inst.divider.x\[-18\]
+ sky130_fd_sc_hd__dfxtp_2
XFILLER_0_60_573 VPWR VGND VPWR VGND sky130_ef_sc_hd__decap_12
XFILLER_0_32_253 VGND VGND VPWR VPWR sky130_fd_sc_hd__decap_4
XFILLER_0_102_141 VPWR VGND VPWR VGND sky130_ef_sc_hd__decap_12
XFILLER_0_99_264 VGND VGND VPWR VPWR sky130_fd_sc_hd__decap_4
XFILLER_0_114_15 VPWR VGND VPWR VGND sky130_ef_sc_hd__decap_12
XFILLER_0_23_57 VPWR VGND VPWR VGND sky130_ef_sc_hd__decap_12
XFILLER_0_28_526 VGND VGND VPWR VPWR sky130_fd_sc_hd__decap_6
XTAP_TAPCELL_ROW_99_1504 VGND VPWR sky130_fd_sc_hd__tapvpwrvgnd_1
XFILLER_0_55_345 VPWR VGND VPWR VGND sky130_ef_sc_hd__decap_12
XTAP_TAPCELL_ROW_31_649 VGND VPWR sky130_fd_sc_hd__tapvpwrvgnd_1
XFILLER_0_99_39 VPWR VGND VPWR VGND sky130_ef_sc_hd__decap_12
XFILLER_0_82_197 VGND VGND VPWR VPWR sky130_fd_sc_hd__decap_4
XFILLER_0_3_637 VGND VGND VPWR VPWR sky130_fd_sc_hd__fill_1
XTAP_TAPCELL_ROW_11_395 VGND VPWR sky130_fd_sc_hd__tapvpwrvgnd_1
XFILLER_0_121_461 VGND VGND VPWR VPWR sky130_fd_sc_hd__fill_1
XFILLER_0_121_494 VGND VGND VPWR VPWR sky130_fd_sc_hd__decap_8
XFILLER_0_48_43 VGND VGND VPWR VPWR sky130_fd_sc_hd__fill_2
X_07860_ _02657_ _02658_ VGND VGND VPWR VPWR _02659_ sky130_fd_sc_hd__or2_2
X_07791_ _02590_ _02591_ VGND VGND VPWR VPWR _02592_ sky130_fd_sc_hd__nand2_2
X_06811_ tanh_inst.z_\[-2\] _01703_ VGND VGND VPWR VPWR _01704_ sky130_fd_sc_hd__nand2_2
XTAP_TAPCELL_ROW_108_1611 VGND VPWR sky130_fd_sc_hd__tapvpwrvgnd_1
X_09530_ tanh_inst.divider.x\[-8\] _04258_ VGND VGND VPWR VPWR _04260_ sky130_fd_sc_hd__and2_2
XFILLER_0_64_53 VGND VGND VPWR VPWR sky130_fd_sc_hd__decap_3
XTAP_TAPCELL_ROW_39_749 VGND VPWR sky130_fd_sc_hd__tapvpwrvgnd_1
X_06742_ _01633_ _01634_ _01631_ VGND VGND VPWR VPWR _01643_ sky130_fd_sc_hd__a21oi_2
X_09461_ _02015_ _04191_ _04192_ _01470_ VGND VGND VPWR VPWR _00311_ sky130_fd_sc_hd__o211a_2
X_06673_ _01517_ _01545_ _01483_ VGND VGND VPWR VPWR _01581_ sky130_fd_sc_hd__or3b_2
X_09392_ _03976_ _04123_ _04125_ VGND VGND VPWR VPWR _04126_ sky130_fd_sc_hd__o21ai_2
XFILLER_0_80_41 VPWR VGND VPWR VGND sky130_ef_sc_hd__decap_12
XFILLER_0_59_673 VGND VGND VPWR VPWR sky130_fd_sc_hd__decap_8
XTAP_TAPCELL_ROW_19_495 VGND VPWR sky130_fd_sc_hd__tapvpwrvgnd_1
X_08412_ tanh_inst.divider.x\[-1\] _02014_ _03188_ _03198_ _01470_ VGND VGND VPWR
+ VPWR _00256_ sky130_fd_sc_hd__o221a_2
X_05624_ _00599_ _00600_ _00608_ VGND VGND VPWR VPWR _00610_ sky130_fd_sc_hd__o21a_2
X_08343_ tanh_inst.divider.y\[-2\] tanh_inst.divider.x\[-2\] VGND VGND VPWR VPWR _03131_
+ sky130_fd_sc_hd__nor2_2
X_05555_ mac_inst.y\[17\] _00536_ _00547_ VGND VGND VPWR VPWR _00548_ sky130_fd_sc_hd__a21o_2
XFILLER_0_104_70 VPWR VGND VPWR VGND sky130_ef_sc_hd__decap_12
XFILLER_0_80_85 VPWR VGND VPWR VGND sky130_ef_sc_hd__decap_12
X_08274_ _02978_ _02980_ _03005_ _03063_ _03004_ VGND VGND VPWR VPWR _03064_ sky130_fd_sc_hd__a311o_2
X_07225_ tanh_inst.divider.y\[-11\] _02028_ _02029_ VGND VGND VPWR VPWR _02035_ sky130_fd_sc_hd__o21ai_2
X_05486_ mac_inst.y\[12\] _00484_ VGND VGND VPWR VPWR _00485_ sky130_fd_sc_hd__xnor2_2
XFILLER_0_46_389 VGND VGND VPWR VPWR sky130_fd_sc_hd__decap_8
XTAP_TAPCELL_ROW_119_1751 VGND VPWR sky130_fd_sc_hd__tapvpwrvgnd_1
XFILLER_0_116_266 VGND VGND VPWR VPWR sky130_fd_sc_hd__decap_3
XFILLER_0_61_337 VPWR VGND VPWR VGND sky130_ef_sc_hd__decap_12
XFILLER_0_6_475 VGND VGND VPWR VPWR sky130_fd_sc_hd__fill_1
X_07156_ _01966_ _01974_ _01976_ VGND VGND VPWR VPWR _01977_ sky130_fd_sc_hd__a21oi_2
XFILLER_0_14_253 VPWR VGND VPWR VGND sky130_ef_sc_hd__decap_12
X_06107_ _01045_ _01046_ _01049_ _01050_ VGND VGND VPWR VPWR _01054_ sky130_fd_sc_hd__or4_2
X_07087_ _01031_ _01784_ VGND VGND VPWR VPWR _01915_ sky130_fd_sc_hd__or2_2
X_06038_ mac_inst.z\[27\] _00987_ _00988_ VGND VGND VPWR VPWR _00990_ sky130_fd_sc_hd__and3_2
X_07989_ _02022_ _02438_ _02488_ VGND VGND VPWR VPWR _02785_ sky130_fd_sc_hd__o21ai_2
XPHY_EDGE_ROW_29_Right_29 VGND VGND VPWR VPWR sky130_fd_sc_hd__decap_3
X_09728_ _04386_ _04450_ _04449_ _04419_ VGND VGND VPWR VPWR _04452_ sky130_fd_sc_hd__a211o_2
XTAP_TAPCELL_ROW_83_1305 VGND VPWR sky130_fd_sc_hd__tapvpwrvgnd_1
X_09659_ _04247_ _04272_ _04381_ _04384_ VGND VGND VPWR VPWR _04385_ sky130_fd_sc_hd__o31ai_2
XFILLER_0_108_701 VGND VGND VPWR VPWR sky130_fd_sc_hd__fill_2
XFILLER_0_64_131 VGND VGND VPWR VPWR sky130_fd_sc_hd__decap_4
XFILLER_0_37_367 VGND VGND VPWR VPWR sky130_fd_sc_hd__fill_1
XPHY_EDGE_ROW_38_Right_38 VGND VGND VPWR VPWR sky130_fd_sc_hd__decap_3
XFILLER_0_64_197 VGND VGND VPWR VPWR sky130_fd_sc_hd__decap_4
X_10434_ clknet_leaf_40_clk _00291_ _00000_ VGND VGND VPWR VPWR mac_inst.i\[26\] sky130_fd_sc_hd__dfrtp_2
XFILLER_0_21_702 VGND VGND VPWR VPWR sky130_fd_sc_hd__fill_1
XFILLER_0_33_573 VGND VGND VPWR VPWR sky130_fd_sc_hd__decap_8
X_10365_ clknet_leaf_17_clk _00222_ VGND VGND VPWR VPWR tanh_inst.divider.z_\[1\]
+ sky130_fd_sc_hd__dfxtp_2
XTAP_TAPCELL_ROW_94_1434 VGND VPWR sky130_fd_sc_hd__tapvpwrvgnd_1
XFILLER_0_33_595 VGND VGND VPWR VPWR sky130_fd_sc_hd__decap_6
XFILLER_0_103_494 VGND VGND VPWR VPWR sky130_fd_sc_hd__decap_8
XFILLER_0_20_245 VGND VGND VPWR VPWR sky130_fd_sc_hd__decap_6
X_10296_ clknet_leaf_23_clk _00153_ VGND VGND VPWR VPWR tanh_inst.z_\[1\] sky130_fd_sc_hd__dfxtp_2
XFILLER_0_20_289 VPWR VGND VPWR VGND sky130_ef_sc_hd__decap_12
XFILLER_0_109_15 VPWR VGND VPWR VGND sky130_ef_sc_hd__decap_12
XPHY_EDGE_ROW_47_Right_47 VGND VGND VPWR VPWR sky130_fd_sc_hd__decap_3
XFILLER_0_87_201 VGND VGND VPWR VPWR sky130_fd_sc_hd__fill_1
XTAP_TAPCELL_ROW_36_708 VGND VPWR sky130_fd_sc_hd__tapvpwrvgnd_1
XFILLER_0_87_223 VGND VGND VPWR VPWR sky130_fd_sc_hd__fill_1
XFILLER_0_87_278 VGND VGND VPWR VPWR sky130_fd_sc_hd__fill_2
XFILLER_0_118_509 VGND VGND VPWR VPWR sky130_fd_sc_hd__decap_4
XTAP_TAPCELL_ROW_103_1552 VGND VPWR sky130_fd_sc_hd__tapvpwrvgnd_1
XFILLER_0_56_610 VPWR VGND VPWR VGND sky130_ef_sc_hd__decap_12
XTAP_TAPCELL_ROW_16_465 VGND VPWR sky130_fd_sc_hd__tapvpwrvgnd_1
XPHY_EDGE_ROW_56_Right_56 VGND VGND VPWR VPWR sky130_fd_sc_hd__decap_3
XFILLER_0_56_643 VGND VGND VPWR VPWR sky130_fd_sc_hd__fill_1
XFILLER_0_7_217 VGND VGND VPWR VPWR sky130_fd_sc_hd__decap_6
XFILLER_0_16_507 VGND VGND VPWR VPWR sky130_fd_sc_hd__decap_8
X_05340_ _04865_ _04869_ _04870_ _04872_ mac_inst.i\[1\] mac_inst.i\[0\] VGND VGND
+ VPWR VPWR _00348_ sky130_fd_sc_hd__mux4_2
XPHY_EDGE_ROW_117_Left_239 VGND VGND VPWR VPWR sky130_fd_sc_hd__decap_3
XFILLER_0_56_698 VGND VGND VPWR VPWR sky130_fd_sc_hd__fill_2
X_05271_ _04785_ _04939_ _04971_ VGND VGND VPWR VPWR _04972_ sky130_fd_sc_hd__o21a_2
XFILLER_0_43_337 VPWR VGND VPWR VGND sky130_ef_sc_hd__decap_12
X_07010_ _01831_ _01838_ _01846_ VGND VGND VPWR VPWR _01847_ sky130_fd_sc_hd__and3_2
XFILLER_0_70_178 VPWR VGND VPWR VGND sky130_ef_sc_hd__decap_12
XFILLER_0_113_269 VGND VGND VPWR VPWR sky130_fd_sc_hd__decap_8
XFILLER_0_11_223 VGND VGND VPWR VPWR sky130_fd_sc_hd__fill_1
XFILLER_0_51_370 VGND VGND VPWR VPWR sky130_fd_sc_hd__decap_4
XTAP_TAPCELL_ROW_114_1692 VGND VPWR sky130_fd_sc_hd__tapvpwrvgnd_1
XTAP_TAPCELL_ROW_114_1681 VGND VPWR sky130_fd_sc_hd__tapvpwrvgnd_1
XPHY_EDGE_ROW_65_Right_65 VGND VGND VPWR VPWR sky130_fd_sc_hd__decap_3
X_08961_ _03701_ _03704_ tanh_inst.LOOKUP.index\[3\] VGND VGND VPWR VPWR _03705_ sky130_fd_sc_hd__mux2_1
X_07912_ _02702_ _02707_ VGND VGND VPWR VPWR _02710_ sky130_fd_sc_hd__or2_2
X_08892_ _03630_ _03631_ _03633_ _03635_ tanh_inst.LOOKUP.index\[2\] tanh_inst.LOOKUP.index\[3\]
+ VGND VGND VPWR VPWR _03637_ sky130_fd_sc_hd__mux4_2
X_07843_ tanh_inst.LOOKUP.index\[4\] _02641_ _02642_ VGND VGND VPWR VPWR _02643_ sky130_fd_sc_hd__a21bo_2
X_07774_ _02574_ _02575_ _02019_ VGND VGND VPWR VPWR _02576_ sky130_fd_sc_hd__a21o_2
X_09513_ _02053_ _03568_ _04193_ VGND VGND VPWR VPWR _04243_ sky130_fd_sc_hd__o21a_2
X_06725_ _01616_ _01625_ _01626_ _01503_ VGND VGND VPWR VPWR _01628_ sky130_fd_sc_hd__a31o_2
X_09444_ tanh_inst.divider.x\[-10\] _04175_ VGND VGND VPWR VPWR _04176_ sky130_fd_sc_hd__xor2_2
X_06656_ tanh_inst.z_\[-19\] _01563_ VGND VGND VPWR VPWR _01566_ sky130_fd_sc_hd__and2_2
XPHY_EDGE_ROW_74_Right_74 VGND VGND VPWR VPWR sky130_fd_sc_hd__decap_3
XFILLER_0_66_429 VPWR VGND VPWR VGND sky130_ef_sc_hd__decap_12
XTAP_TAPCELL_ROW_65_1079 VGND VPWR sky130_fd_sc_hd__tapvpwrvgnd_1
XFILLER_0_59_492 VPWR VGND VPWR VGND sky130_ef_sc_hd__decap_12
X_05607_ _00580_ _00592_ VGND VGND VPWR VPWR _00594_ sky130_fd_sc_hd__nand2_2
X_09375_ _04031_ _04106_ _04107_ _04071_ VGND VGND VPWR VPWR _04109_ sky130_fd_sc_hd__a211o_2
X_06587_ _01469_ _01501_ VGND VGND VPWR VPWR _01502_ sky130_fd_sc_hd__nor2_2
XFILLER_0_62_602 VGND VGND VPWR VPWR sky130_fd_sc_hd__fill_1
XFILLER_0_19_389 VGND VGND VPWR VPWR sky130_fd_sc_hd__decap_3
X_08326_ _03074_ _03081_ _03113_ VGND VGND VPWR VPWR _03115_ sky130_fd_sc_hd__o21ai_2
X_05538_ _00509_ _00531_ VGND VGND VPWR VPWR _00532_ sky130_fd_sc_hd__or2_2
XFILLER_0_105_704 VGND VGND VPWR VPWR sky130_fd_sc_hd__fill_1
X_05469_ mac_inst.y\[11\] _00468_ VGND VGND VPWR VPWR _00469_ sky130_fd_sc_hd__nor2_2
X_08257_ tanh_inst.divider.y\[-4\] tanh_inst.divider.x\[-4\] VGND VGND VPWR VPWR _03047_
+ sky130_fd_sc_hd__nand2_2
X_07208_ _01522_ _01527_ tanh_inst.LOOKUP.index\[4\] VGND VGND VPWR VPWR _02018_ sky130_fd_sc_hd__a21oi_2
X_08188_ _02924_ _02929_ _02979_ VGND VGND VPWR VPWR _02980_ sky130_fd_sc_hd__o21ai_2
X_07139_ tanh_inst.divider.z_\[-1\] _01960_ VGND VGND VPWR VPWR _01962_ sky130_fd_sc_hd__xor2_2
XFILLER_0_15_584 VPWR VGND VPWR VGND sky130_ef_sc_hd__decap_12
XPHY_EDGE_ROW_83_Right_83 VGND VGND VPWR VPWR sky130_fd_sc_hd__decap_3
XFILLER_0_30_587 VGND VGND VPWR VPWR sky130_fd_sc_hd__fill_1
X_10081_ clknet_leaf_11_clk _00098_ VGND VGND VPWR VPWR tanh_inst.divider.y_\[-12\]
+ sky130_fd_sc_hd__dfxtp_2
XFILLER_0_97_554 VGND VGND VPWR VPWR sky130_fd_sc_hd__fill_1
XPHY_EDGE_ROW_92_Right_92 VGND VGND VPWR VPWR sky130_fd_sc_hd__decap_3
XTAP_TAPCELL_ROW_13_424 VGND VPWR sky130_fd_sc_hd__tapvpwrvgnd_1
XFILLER_0_38_698 VGND VGND VPWR VPWR sky130_fd_sc_hd__fill_2
XFILLER_0_111_27 VPWR VGND VPWR VGND sky130_ef_sc_hd__decap_12
XFILLER_0_80_421 VGND VGND VPWR VPWR sky130_fd_sc_hd__decap_6
XFILLER_0_53_668 VGND VGND VPWR VPWR sky130_fd_sc_hd__decap_4
XFILLER_0_4_209 VPWR VGND VPWR VGND sky130_ef_sc_hd__decap_12
XFILLER_0_25_337 VGND VGND VPWR VPWR sky130_fd_sc_hd__decap_3
XTAP_TAPCELL_ROW_41_777 VGND VPWR sky130_fd_sc_hd__tapvpwrvgnd_1
XFILLER_0_80_487 VGND VGND VPWR VPWR sky130_fd_sc_hd__fill_2
XFILLER_0_61_690 VGND VGND VPWR VPWR sky130_fd_sc_hd__decap_8
XFILLER_0_96_29 VPWR VGND VPWR VGND sky130_ef_sc_hd__decap_12
X_10417_ clknet_leaf_36_clk _00274_ _00000_ VGND VGND VPWR VPWR mac_inst.i\[9\] sky130_fd_sc_hd__dfrtp_2
X_10348_ clknet_leaf_14_clk _00205_ VGND VGND VPWR VPWR tanh_inst.divider.z_\[-16\]
+ sky130_fd_sc_hd__dfxtp_2
X_10279_ clknet_leaf_21_clk _00136_ VGND VGND VPWR VPWR tanh_inst.z_\[-16\] sky130_fd_sc_hd__dfxtp_2
XTAP_TAPCELL_ROW_49_877 VGND VPWR sky130_fd_sc_hd__tapvpwrvgnd_1
X_06510_ _01088_ _01427_ _01428_ _01429_ VGND VGND VPWR VPWR _00113_ sky130_fd_sc_hd__a31o_2
XFILLER_0_88_587 VGND VGND VPWR VPWR sky130_fd_sc_hd__fill_1
X_07490_ _02295_ _02296_ VGND VGND VPWR VPWR _02297_ sky130_fd_sc_hd__xnor2_2
X_06441_ _01088_ _01365_ _01366_ VGND VGND VPWR VPWR _00107_ sky130_fd_sc_hd__a21o_2
XFILLER_0_0_57 VPWR VGND VPWR VGND sky130_ef_sc_hd__decap_12
XPHY_EDGE_ROW_100_Right_100 VGND VGND VPWR VPWR sky130_fd_sc_hd__decap_3
X_06372_ tanh_inst.divider.y_\[-8\] _01302_ VGND VGND VPWR VPWR _01303_ sky130_fd_sc_hd__nand2_2
X_09160_ _04757_ _03896_ _03899_ VGND VGND VPWR VPWR _03900_ sky130_fd_sc_hd__o21ai_2
X_09091_ _03605_ _03607_ _02025_ VGND VGND VPWR VPWR _03832_ sky130_fd_sc_hd__mux2_1
XFILLER_0_83_281 VPWR VGND VPWR VGND sky130_ef_sc_hd__decap_12
XFILLER_0_71_421 VPWR VGND VPWR VGND sky130_ef_sc_hd__decap_12
X_08111_ _02741_ _02781_ _02825_ _02863_ VGND VGND VPWR VPWR _02905_ sky130_fd_sc_hd__or4_2
X_05323_ _04889_ _04891_ _04894_ _04896_ _04783_ mac_inst.i\[1\] VGND VGND VPWR VPWR
+ _05022_ sky130_fd_sc_hd__mux4_2
X_08042_ _02835_ _02836_ _02833_ VGND VGND VPWR VPWR _02837_ sky130_fd_sc_hd__a21oi_2
XFILLER_0_9_55 VGND VGND VPWR VPWR sky130_fd_sc_hd__fill_1
X_05254_ _04945_ _04950_ _04954_ _04940_ _04949_ VGND VGND VPWR VPWR _04955_ sky130_fd_sc_hd__o221ai_2
XTAP_TAPCELL_ROW_116_1710 VGND VPWR sky130_fd_sc_hd__tapvpwrvgnd_1
XFILLER_0_52_690 VGND VGND VPWR VPWR sky130_fd_sc_hd__decap_4
XFILLER_0_114_589 VGND VGND VPWR VPWR sky130_fd_sc_hd__fill_2
X_05185_ mac_inst.x\[11\] _04852_ _04853_ VGND VGND VPWR VPWR _04889_ sky130_fd_sc_hd__a21o_2
XFILLER_0_24_392 VGND VGND VPWR VPWR sky130_fd_sc_hd__decap_8
X_09993_ _04763_ _04707_ VGND VGND VPWR VPWR _04709_ sky130_fd_sc_hd__nand2_2
XFILLER_0_12_587 VGND VGND VPWR VPWR sky130_fd_sc_hd__fill_1
X_08944_ _03614_ _03616_ VGND VGND VPWR VPWR _03688_ sky130_fd_sc_hd__nand2b_2
XFILLER_0_50_3 VGND VGND VPWR VPWR sky130_fd_sc_hd__decap_6
X_08875_ _03618_ _03619_ VGND VGND VPWR VPWR _03620_ sky130_fd_sc_hd__and2b_2
X_07826_ tanh_inst.divider.y\[-14\] tanh_inst.divider.x\[-14\] VGND VGND VPWR VPWR
+ _02626_ sky130_fd_sc_hd__and2_2
X_07757_ _02460_ _02505_ _02506_ VGND VGND VPWR VPWR _02559_ sky130_fd_sc_hd__a21boi_2
X_06708_ _01609_ _01611_ _01502_ VGND VGND VPWR VPWR _01613_ sky130_fd_sc_hd__o21a_2
X_07688_ _02053_ _02490_ _02487_ VGND VGND VPWR VPWR _02491_ sky130_fd_sc_hd__a21boi_2
X_06639_ _01549_ _01550_ VGND VGND VPWR VPWR _01551_ sky130_fd_sc_hd__nor2_2
X_09427_ tanh_inst.LOOKUP.index\[3\] _03895_ _03938_ VGND VGND VPWR VPWR _04159_ sky130_fd_sc_hd__o21a_2
X_09358_ _04037_ _04061_ VGND VGND VPWR VPWR _04092_ sky130_fd_sc_hd__nor2_2
XFILLER_0_74_281 VGND VGND VPWR VPWR sky130_fd_sc_hd__fill_1
X_08309_ _03096_ _03097_ VGND VGND VPWR VPWR _03098_ sky130_fd_sc_hd__nand2b_2
XFILLER_0_117_372 VGND VGND VPWR VPWR sky130_fd_sc_hd__decap_8
X_09289_ tanh_inst.divider.x\[-14\] _04023_ VGND VGND VPWR VPWR _04025_ sky130_fd_sc_hd__and2_2
XFILLER_0_105_534 VGND VGND VPWR VPWR sky130_fd_sc_hd__decap_6
XFILLER_0_22_307 VGND VGND VPWR VPWR sky130_fd_sc_hd__fill_1
XTAP_TAPCELL_ROW_78_1237 VGND VPWR sky130_fd_sc_hd__tapvpwrvgnd_1
XTAP_TAPCELL_ROW_91_1404 VGND VPWR sky130_fd_sc_hd__tapvpwrvgnd_1
X_10202_ x_in[28] _00000_ VGND VGND VPWR VPWR mac_inst.x\[28\] sky130_fd_sc_hd__dlxtn_1
XFILLER_0_100_283 VGND VGND VPWR VPWR sky130_fd_sc_hd__decap_3
X_10064_ rst VGND VGND VPWR VPWR _00083_ sky130_fd_sc_hd__inv_2
XFILLER_0_106_27 VGND VGND VPWR VPWR sky130_fd_sc_hd__fill_1
XTAP_TAPCELL_ROW_89_1377 VGND VPWR sky130_fd_sc_hd__tapvpwrvgnd_1
XTAP_TAPCELL_ROW_46_836 VGND VPWR sky130_fd_sc_hd__tapvpwrvgnd_1
XFILLER_0_15_69 VPWR VGND VPWR VGND sky130_ef_sc_hd__decap_12
XTAP_TAPCELL_ROW_26_582 VGND VPWR sky130_fd_sc_hd__tapvpwrvgnd_1
XTAP_TAPCELL_ROW_100_1511 VGND VPWR sky130_fd_sc_hd__tapvpwrvgnd_1
XTAP_TAPCELL_ROW_26_593 VGND VPWR sky130_fd_sc_hd__tapvpwrvgnd_1
XFILLER_0_38_473 VGND VGND VPWR VPWR sky130_fd_sc_hd__decap_3
XFILLER_0_65_281 VGND VGND VPWR VPWR sky130_fd_sc_hd__decap_8
XFILLER_0_53_443 VGND VGND VPWR VPWR sky130_fd_sc_hd__decap_4
XFILLER_0_25_167 VGND VGND VPWR VPWR sky130_fd_sc_hd__fill_1
XFILLER_0_13_329 VGND VGND VPWR VPWR sky130_fd_sc_hd__decap_6
XFILLER_0_111_559 VGND VGND VPWR VPWR sky130_fd_sc_hd__fill_1
X_06990_ tanh_inst.divider.i\[2\] _01035_ _01776_ VGND VGND VPWR VPWR _01829_ sky130_fd_sc_hd__or3_2
XTAP_TAPCELL_ROW_111_1651 VGND VPWR sky130_fd_sc_hd__tapvpwrvgnd_1
X_05941_ _00876_ _00879_ _00889_ VGND VGND VPWR VPWR _00900_ sky130_fd_sc_hd__and3_2
X_08660_ tanh_inst.divider.x\[6\] _03439_ VGND VGND VPWR VPWR _03440_ sky130_fd_sc_hd__nand2_2
XFILLER_0_56_98 VGND VGND VPWR VPWR sky130_fd_sc_hd__decap_8
X_05872_ _00835_ _00836_ VGND VGND VPWR VPWR _05872_/Y sky130_fd_sc_hd__nor2_2
X_07611_ _02380_ _02381_ _02378_ VGND VGND VPWR VPWR _02416_ sky130_fd_sc_hd__a21oi_2
XFILLER_0_72_42 VPWR VGND VPWR VGND sky130_ef_sc_hd__decap_12
X_08591_ _03366_ _03370_ _03372_ VGND VGND VPWR VPWR _03373_ sky130_fd_sc_hd__o21ai_2
X_07542_ tanh_inst.divider.y\[-20\] _02347_ VGND VGND VPWR VPWR _02348_ sky130_fd_sc_hd__nor2_2
XFILLER_0_88_395 VGND VGND VPWR VPWR sky130_fd_sc_hd__decap_4
XFILLER_0_76_513 VGND VGND VPWR VPWR sky130_fd_sc_hd__decap_3
XFILLER_0_76_546 VGND VGND VPWR VPWR sky130_fd_sc_hd__fill_2
X_07473_ _02066_ _02067_ _02071_ _02068_ tanh_inst.LOOKUP.index\[0\] tanh_inst.LOOKUP.index\[1\]
+ VGND VGND VPWR VPWR _02280_ sky130_fd_sc_hd__mux4_2
XFILLER_0_8_301 VGND VGND VPWR VPWR sky130_fd_sc_hd__decap_6
X_06424_ _01325_ _01336_ _01337_ _01350_ VGND VGND VPWR VPWR _01351_ sky130_fd_sc_hd__o211ai_2
X_09212_ _03863_ _03905_ _03906_ _03903_ VGND VGND VPWR VPWR _03951_ sky130_fd_sc_hd__o31ai_2
XTAP_TAPCELL_ROW_62_1038 VGND VPWR sky130_fd_sc_hd__tapvpwrvgnd_1
XFILLER_0_8_345 VPWR VGND VPWR VGND sky130_ef_sc_hd__decap_12
X_06355_ tanh_inst.divider.y\[-10\] tanh_inst.div_en tanh_inst.divider.y_\[-10\] _01092_
+ VGND VGND VPWR VPWR _01288_ sky130_fd_sc_hd__a22o_2
XFILLER_0_106_309 VPWR VGND VPWR VGND sky130_ef_sc_hd__decap_12
X_09143_ _03880_ _03881_ VGND VGND VPWR VPWR _03883_ sky130_fd_sc_hd__xnor2_2
XFILLER_0_17_635 VPWR VGND VPWR VGND sky130_ef_sc_hd__decap_12
XFILLER_0_44_421 VPWR VGND VPWR VGND sky130_ef_sc_hd__decap_12
XFILLER_0_98_3 VPWR VGND VPWR VGND sky130_ef_sc_hd__decap_12
X_05306_ _05003_ _05005_ _04909_ VGND VGND VPWR VPWR _05006_ sky130_fd_sc_hd__a21oi_2
X_06286_ _01222_ _01223_ _01088_ VGND VGND VPWR VPWR _01224_ sky130_fd_sc_hd__o21a_2
X_09074_ _03646_ _03658_ _03713_ _03771_ VGND VGND VPWR VPWR _03816_ sky130_fd_sc_hd__and4_2
XFILLER_0_4_551 VGND VGND VPWR VPWR sky130_fd_sc_hd__decap_4
XFILLER_0_16_189 VGND VGND VPWR VPWR sky130_fd_sc_hd__decap_6
X_08025_ _02820_ VGND VGND VPWR VPWR _02821_ sky130_fd_sc_hd__inv_2
XFILLER_0_4_584 VGND VGND VPWR VPWR sky130_fd_sc_hd__decap_4
X_05237_ mac_inst.i\[5\] _04843_ _04936_ VGND VGND VPWR VPWR _04938_ sky130_fd_sc_hd__or3_2
X_05168_ mac_inst.x\[26\] _04852_ _04853_ VGND VGND VPWR VPWR _04872_ sky130_fd_sc_hd__a21o_2
XFILLER_0_110_581 VGND VGND VPWR VPWR sky130_fd_sc_hd__decap_6
XTAP_TAPCELL_ROW_73_1178 VGND VPWR sky130_fd_sc_hd__tapvpwrvgnd_1
X_09976_ _04656_ _04662_ VGND VGND VPWR VPWR _04693_ sky130_fd_sc_hd__nand2_2
X_05099_ _04805_ _04815_ VGND VGND VPWR VPWR _00336_ sky130_fd_sc_hd__nor2_2
X_08927_ _04761_ _03531_ _03530_ _02026_ VGND VGND VPWR VPWR _03671_ sky130_fd_sc_hd__a211o_2
X_08858_ _02027_ _03601_ _03602_ _03600_ VGND VGND VPWR VPWR _03603_ sky130_fd_sc_hd__o31a_2
X_07809_ _02019_ _02608_ _02609_ _02014_ VGND VGND VPWR VPWR _02610_ sky130_fd_sc_hd__o31a_2
X_08789_ tanh_inst.divider.x\[-24\] tanh_inst.divider.x\[-23\] tanh_inst.LOOKUP.index\[0\]
+ VGND VGND VPWR VPWR _03535_ sky130_fd_sc_hd__mux2_1
XFILLER_0_94_321 VGND VGND VPWR VPWR sky130_fd_sc_hd__decap_8
XFILLER_0_109_169 VGND VGND VPWR VPWR sky130_fd_sc_hd__decap_8
XTAP_TAPCELL_ROW_23_552 VGND VPWR sky130_fd_sc_hd__tapvpwrvgnd_1
XTAP_TAPCELL_ROW_51_894 VGND VPWR sky130_fd_sc_hd__tapvpwrvgnd_1
XFILLER_0_117_191 VGND VGND VPWR VPWR sky130_fd_sc_hd__decap_8
XFILLER_0_90_571 VGND VGND VPWR VPWR sky130_fd_sc_hd__decap_8
XFILLER_0_120_323 VGND VGND VPWR VPWR sky130_fd_sc_hd__decap_4
XFILLER_0_31_671 VGND VGND VPWR VPWR sky130_fd_sc_hd__fill_1
XFILLER_0_117_15 VPWR VGND VPWR VGND sky130_ef_sc_hd__decap_12
X_10047_ tanh_inst.LOOKUP.index\[4\] _04755_ _01469_ VGND VGND VPWR VPWR _00333_ sky130_fd_sc_hd__a21o_2
XFILLER_0_98_660 VGND VGND VPWR VPWR sky130_fd_sc_hd__fill_1
XTAP_TAPCELL_ROW_59_994 VGND VPWR sky130_fd_sc_hd__tapvpwrvgnd_1
XFILLER_0_58_513 VPWR VGND VPWR VGND sky130_ef_sc_hd__decap_12
XFILLER_0_73_549 VGND VGND VPWR VPWR sky130_fd_sc_hd__decap_8
XFILLER_0_109_670 VGND VGND VPWR VPWR sky130_fd_sc_hd__fill_2
XFILLER_0_5_337 VPWR VGND VPWR VGND sky130_ef_sc_hd__decap_12
X_06140_ _01085_ tanh_inst.divider.y_\[-23\] VGND VGND VPWR VPWR _01086_ sky130_fd_sc_hd__and2b_2
XFILLER_0_13_137 VPWR VGND VPWR VGND sky130_ef_sc_hd__decap_12
X_06071_ _01013_ _01015_ _01018_ _01011_ VGND VGND VPWR VPWR _06071_/X sky130_fd_sc_hd__o211a_2
XFILLER_0_41_435 VPWR VGND VPWR VGND sky130_ef_sc_hd__decap_12
XFILLER_0_41_457 VGND VGND VPWR VPWR sky130_fd_sc_hd__fill_1
XFILLER_0_111_334 VGND VGND VPWR VPWR sky130_fd_sc_hd__fill_2
XFILLER_0_67_20 VPWR VGND VPWR VGND sky130_ef_sc_hd__decap_12
XFILLER_0_21_181 VPWR VGND VPWR VGND sky130_ef_sc_hd__decap_12
XFILLER_0_1_598 VPWR VGND VPWR VGND sky130_ef_sc_hd__decap_12
X_09830_ _04538_ _04541_ _04549_ tanh_inst.z_\[7\] VGND VGND VPWR VPWR _04551_ sky130_fd_sc_hd__a31o_2
X_06973_ _01813_ VGND VGND VPWR VPWR _01814_ sky130_fd_sc_hd__inv_2
X_09761_ tanh_inst.divider.x\[-1\] _04482_ VGND VGND VPWR VPWR _04484_ sky130_fd_sc_hd__and2_2
X_05924_ _00856_ _00874_ VGND VGND VPWR VPWR _00885_ sky130_fd_sc_hd__and2_2
X_08712_ _04782_ _00953_ VGND VGND VPWR VPWR _00267_ sky130_fd_sc_hd__xnor2_2
X_09692_ _04396_ _04400_ _04394_ VGND VGND VPWR VPWR _04417_ sky130_fd_sc_hd__a21bo_2
XFILLER_0_83_96 VGND VGND VPWR VPWR sky130_fd_sc_hd__decap_4
X_08643_ _03364_ _03371_ _03423_ VGND VGND VPWR VPWR _03424_ sky130_fd_sc_hd__o21ai_2
XFILLER_0_13_3 VPWR VGND VPWR VGND sky130_ef_sc_hd__decap_12
X_05855_ _00819_ _00820_ VGND VGND VPWR VPWR _05855_/Y sky130_fd_sc_hd__xnor2_2
XFILLER_0_107_81 VPWR VGND VPWR VGND sky130_ef_sc_hd__decap_12
X_05786_ mac_inst.z\[7\] _00743_ _00737_ _00739_ VGND VGND VPWR VPWR _00757_ sky130_fd_sc_hd__o2bb2a_2
XTAP_TAPCELL_ROW_1_269 VGND VPWR sky130_fd_sc_hd__tapvpwrvgnd_1
X_08574_ tanh_inst.divider.x\[3\] _02014_ _03356_ _01470_ VGND VGND VPWR VPWR _00260_
+ sky130_fd_sc_hd__o211a_2
XFILLER_0_88_192 VGND VGND VPWR VPWR sky130_fd_sc_hd__decap_4
XFILLER_0_76_321 VPWR VGND VPWR VGND sky130_ef_sc_hd__decap_12
X_07525_ _02329_ _02330_ VGND VGND VPWR VPWR _02332_ sky130_fd_sc_hd__or2_2
XFILLER_0_9_643 VGND VGND VPWR VPWR sky130_fd_sc_hd__fill_1
X_07456_ _02262_ _02263_ VGND VGND VPWR VPWR _02264_ sky130_fd_sc_hd__nand2b_2
XFILLER_0_9_665 VGND VGND VPWR VPWR sky130_fd_sc_hd__decap_6
XFILLER_0_8_153 VPWR VGND VPWR VGND sky130_ef_sc_hd__decap_12
XFILLER_0_29_270 VGND VGND VPWR VPWR sky130_fd_sc_hd__decap_8
X_06407_ _01332_ _01334_ VGND VGND VPWR VPWR _01335_ sky130_fd_sc_hd__xnor2_2
X_07387_ tanh_inst.divider.x\[-23\] _02195_ VGND VGND VPWR VPWR _02196_ sky130_fd_sc_hd__and2_2
XFILLER_0_8_197 VPWR VGND VPWR VGND sky130_ef_sc_hd__decap_12
XTAP_TAPCELL_ROW_20_511 VGND VPWR sky130_fd_sc_hd__tapvpwrvgnd_1
X_06338_ _01271_ VGND VGND VPWR VPWR _01272_ sky130_fd_sc_hd__inv_2
XFILLER_0_106_139 VGND VGND VPWR VPWR sky130_fd_sc_hd__fill_1
X_09126_ tanh_inst.divider.y\[-19\] _02014_ _03849_ _03866_ _01470_ VGND VGND VPWR
+ VPWR _00302_ sky130_fd_sc_hd__o221a_2
XFILLER_0_60_722 VGND VGND VPWR VPWR sky130_fd_sc_hd__fill_2
XFILLER_0_121_109 VGND VGND VPWR VPWR sky130_fd_sc_hd__decap_3
X_06269_ _01206_ _01207_ VGND VGND VPWR VPWR _01208_ sky130_fd_sc_hd__xnor2_2
X_09057_ tanh_inst.z_\[7\] _03798_ VGND VGND VPWR VPWR _03799_ sky130_fd_sc_hd__nand2_2
X_08008_ _02711_ _02712_ _02764_ VGND VGND VPWR VPWR _02804_ sky130_fd_sc_hd__or3_2
XTAP_TAPCELL_ROW_9_369 VGND VPWR sky130_fd_sc_hd__tapvpwrvgnd_1
X_09959_ tanh_inst.divider.y\[4\] _02014_ VGND VGND VPWR VPWR _04677_ sky130_fd_sc_hd__or2_2
XTAP_TAPCELL_ROW_86_1336 VGND VPWR sky130_fd_sc_hd__tapvpwrvgnd_1
XTAP_TAPCELL_ROW_28_611 VGND VPWR sky130_fd_sc_hd__tapvpwrvgnd_1
XFILLER_0_67_310 VGND VGND VPWR VPWR sky130_fd_sc_hd__decap_8
XTAP_TAPCELL_ROW_56_964 VGND VPWR sky130_fd_sc_hd__tapvpwrvgnd_1
XFILLER_0_103_39 VPWR VGND VPWR VGND sky130_ef_sc_hd__decap_12
XFILLER_0_55_538 VPWR VGND VPWR VGND sky130_ef_sc_hd__decap_12
XFILLER_0_12_15 VPWR VGND VPWR VGND sky130_ef_sc_hd__decap_12
XFILLER_0_82_379 VGND VGND VPWR VPWR sky130_fd_sc_hd__decap_4
XFILLER_0_70_508 VGND VGND VPWR VPWR sky130_fd_sc_hd__decap_4
XFILLER_0_23_402 VGND VGND VPWR VPWR sky130_fd_sc_hd__decap_4
XFILLER_0_112_109 VPWR VGND VPWR VGND sky130_ef_sc_hd__decap_12
XFILLER_0_106_684 VGND VGND VPWR VPWR sky130_fd_sc_hd__decap_3
XFILLER_0_105_161 VGND VGND VPWR VPWR sky130_fd_sc_hd__decap_6
XTAP_TAPCELL_ROW_97_1476 VGND VPWR sky130_fd_sc_hd__tapvpwrvgnd_1
XFILLER_0_2_307 VGND VGND VPWR VPWR sky130_fd_sc_hd__fill_1
XFILLER_0_23_468 VGND VGND VPWR VPWR sky130_fd_sc_hd__fill_1
XFILLER_0_50_265 VGND VGND VPWR VPWR sky130_fd_sc_hd__decap_8
XFILLER_0_120_153 VPWR VGND VPWR VGND sky130_ef_sc_hd__decap_12
XFILLER_0_120_197 VPWR VGND VPWR VGND sky130_ef_sc_hd__decap_12
XFILLER_0_78_608 VGND VGND VPWR VPWR sky130_fd_sc_hd__decap_8
X_05640_ _00598_ _00623_ _00624_ VGND VGND VPWR VPWR _00625_ sky130_fd_sc_hd__o21ai_2
XFILLER_0_53_44 VGND VGND VPWR VPWR sky130_fd_sc_hd__decap_4
XFILLER_0_86_641 VGND VGND VPWR VPWR sky130_fd_sc_hd__decap_3
X_05571_ _00556_ _00561_ VGND VGND VPWR VPWR _00562_ sky130_fd_sc_hd__xor2_2
XTAP_TAPCELL_ROW_106_1583 VGND VPWR sky130_fd_sc_hd__tapvpwrvgnd_1
XFILLER_0_58_365 VPWR VGND VPWR VGND sky130_ef_sc_hd__decap_12
XFILLER_0_19_719 VGND VGND VPWR VPWR sky130_fd_sc_hd__decap_4
Xclkbuf_leaf_43_clk clknet_2_0__leaf_clk VGND VGND VPWR VPWR clknet_leaf_43_clk sky130_fd_sc_hd__clkbuf_8
X_07310_ _02118_ _02119_ _04759_ VGND VGND VPWR VPWR _02120_ sky130_fd_sc_hd__mux2_1
X_08290_ _03075_ _03079_ VGND VGND VPWR VPWR _03080_ sky130_fd_sc_hd__nand2_2
XFILLER_0_46_549 VGND VGND VPWR VPWR sky130_fd_sc_hd__fill_1
X_07241_ _04757_ _02020_ VGND VGND VPWR VPWR _02051_ sky130_fd_sc_hd__nor2_2
X_07172_ _01981_ _01987_ VGND VGND VPWR VPWR _01990_ sky130_fd_sc_hd__nand2_2
XFILLER_0_42_722 VGND VGND VPWR VPWR sky130_fd_sc_hd__fill_2
X_06123_ _01067_ _01068_ tanh_inst.divider.i\[1\] VGND VGND VPWR VPWR _01069_ sky130_fd_sc_hd__mux2_1
XFILLER_0_5_167 VGND VGND VPWR VPWR sky130_fd_sc_hd__fill_1
X_06054_ mac_inst.z\[31\] _00995_ _01002_ VGND VGND VPWR VPWR _01004_ sky130_fd_sc_hd__o21ai_2
XFILLER_0_112_698 VGND VGND VPWR VPWR sky130_fd_sc_hd__fill_2
XFILLER_0_111_164 VGND VGND VPWR VPWR sky130_fd_sc_hd__decap_4
XFILLER_0_1_373 VPWR VGND VPWR VGND sky130_ef_sc_hd__decap_12
XTAP_TAPCELL_ROW_70_1137 VGND VPWR sky130_fd_sc_hd__tapvpwrvgnd_1
X_09813_ _04239_ _04242_ _04382_ _04533_ VGND VGND VPWR VPWR _04535_ sky130_fd_sc_hd__a211o_2
XTAP_TAPCELL_ROW_6_339 VGND VPWR sky130_fd_sc_hd__tapvpwrvgnd_1
X_06956_ tanh_inst.divider.z_\[-21\] _01092_ _01798_ _01088_ VGND VGND VPWR VPWR _00200_
+ sky130_fd_sc_hd__a22o_2
X_09744_ _04463_ _04467_ VGND VGND VPWR VPWR _04468_ sky130_fd_sc_hd__and2_2
X_06887_ _01060_ _01767_ VGND VGND VPWR VPWR _01768_ sky130_fd_sc_hd__and2_2
X_05907_ mac_inst.z\[31\] _00867_ _00865_ VGND VGND VPWR VPWR _00869_ sky130_fd_sc_hd__o21ai_2
X_09675_ _04396_ _04400_ VGND VGND VPWR VPWR _04401_ sky130_fd_sc_hd__nand2_2
X_08626_ tanh_inst.divider.y\[5\] tanh_inst.divider.x\[5\] VGND VGND VPWR VPWR _03407_
+ sky130_fd_sc_hd__nand2_2
X_05838_ _00779_ _00790_ _00791_ VGND VGND VPWR VPWR _00805_ sky130_fd_sc_hd__nand3_2
XTAP_TAPCELL_ROW_53_923 VGND VPWR sky130_fd_sc_hd__tapvpwrvgnd_1
XFILLER_0_77_685 VGND VGND VPWR VPWR sky130_fd_sc_hd__decap_4
X_05769_ _00708_ _00718_ _00731_ _00740_ VGND VGND VPWR VPWR _00741_ sky130_fd_sc_hd__and4_2
Xclkbuf_leaf_34_clk clknet_2_1__leaf_clk VGND VGND VPWR VPWR clknet_leaf_34_clk sky130_fd_sc_hd__clkbuf_8
XFILLER_0_37_505 VGND VGND VPWR VPWR sky130_fd_sc_hd__decap_4
XFILLER_0_49_354 VPWR VGND VPWR VGND sky130_ef_sc_hd__decap_12
XFILLER_0_49_376 VGND VGND VPWR VPWR sky130_fd_sc_hd__decap_3
X_08557_ tanh_inst.divider.y\[3\] tanh_inst.divider.x\[3\] VGND VGND VPWR VPWR _03340_
+ sky130_fd_sc_hd__nand2_2
XFILLER_0_92_633 VGND VGND VPWR VPWR sky130_fd_sc_hd__fill_2
XFILLER_0_76_195 VGND VGND VPWR VPWR sky130_fd_sc_hd__fill_1
XFILLER_0_37_549 VGND VGND VPWR VPWR sky130_fd_sc_hd__fill_1
X_08488_ _04791_ _03262_ _03271_ _03272_ VGND VGND VPWR VPWR _03273_ sky130_fd_sc_hd__a22o_2
X_07508_ tanh_inst.LOOKUP.index\[2\] _02314_ _02313_ VGND VGND VPWR VPWR _02315_ sky130_fd_sc_hd__o21a_2
XTAP_TAPCELL_ROW_81_1277 VGND VPWR sky130_fd_sc_hd__tapvpwrvgnd_1
XTAP_TAPCELL_ROW_33_680 VGND VPWR sky130_fd_sc_hd__tapvpwrvgnd_1
X_07439_ _02245_ _02246_ tanh_inst.LOOKUP.index\[2\] VGND VGND VPWR VPWR _02247_ sky130_fd_sc_hd__mux2_1
XFILLER_0_91_165 VGND VGND VPWR VPWR sky130_fd_sc_hd__decap_3
X_10450_ clknet_leaf_8_clk _00307_ VGND VGND VPWR VPWR tanh_inst.divider.y\[-14\]
+ sky130_fd_sc_hd__dfxtp_2
XFILLER_0_17_273 VGND VGND VPWR VPWR sky130_fd_sc_hd__decap_6
X_09109_ _03821_ _03822_ _03819_ VGND VGND VPWR VPWR _03850_ sky130_fd_sc_hd__a21oi_2
XFILLER_0_60_541 VGND VGND VPWR VPWR sky130_fd_sc_hd__fill_1
X_10381_ clknet_leaf_9_clk _00238_ VGND VGND VPWR VPWR tanh_inst.divider.x\[-19\]
+ sky130_fd_sc_hd__dfxtp_2
XFILLER_0_5_690 VGND VGND VPWR VPWR sky130_fd_sc_hd__decap_3
XFILLER_0_102_153 VPWR VGND VPWR VGND sky130_ef_sc_hd__decap_12
XFILLER_0_60_585 VGND VGND VPWR VPWR sky130_fd_sc_hd__decap_3
XFILLER_0_20_449 VGND VGND VPWR VPWR sky130_fd_sc_hd__fill_1
XFILLER_0_2_3 VPWR VGND VPWR VGND sky130_ef_sc_hd__decap_12
XFILLER_0_102_197 VGND VGND VPWR VPWR sky130_fd_sc_hd__fill_1
XFILLER_0_87_405 VGND VGND VPWR VPWR sky130_fd_sc_hd__decap_4
XFILLER_0_59_107 VGND VGND VPWR VPWR sky130_fd_sc_hd__decap_4
XFILLER_0_68_641 VGND VGND VPWR VPWR sky130_fd_sc_hd__decap_3
XFILLER_0_114_27 VGND VGND VPWR VPWR sky130_fd_sc_hd__fill_1
Xclkbuf_leaf_25_clk clknet_2_3__leaf_clk VGND VGND VPWR VPWR clknet_leaf_25_clk sky130_fd_sc_hd__clkbuf_8
XFILLER_0_67_151 VGND VGND VPWR VPWR sky130_fd_sc_hd__decap_3
XFILLER_0_67_195 VGND VGND VPWR VPWR sky130_fd_sc_hd__decap_3
XFILLER_0_23_69 VPWR VGND VPWR VGND sky130_ef_sc_hd__decap_12
XTAP_TAPCELL_ROW_99_1505 VGND VPWR sky130_fd_sc_hd__tapvpwrvgnd_1
XFILLER_0_55_357 VGND VGND VPWR VPWR sky130_fd_sc_hd__decap_4
XFILLER_0_82_187 VGND VGND VPWR VPWR sky130_fd_sc_hd__decap_8
XFILLER_0_82_165 VGND VGND VPWR VPWR sky130_fd_sc_hd__decap_4
XFILLER_0_70_327 VGND VGND VPWR VPWR sky130_fd_sc_hd__fill_1
XFILLER_0_11_405 VGND VGND VPWR VPWR sky130_fd_sc_hd__decap_8
XTAP_TAPCELL_ROW_11_396 VGND VPWR sky130_fd_sc_hd__tapvpwrvgnd_1
XFILLER_0_121_440 VGND VGND VPWR VPWR sky130_fd_sc_hd__decap_8
XFILLER_0_11_449 VPWR VGND VPWR VGND sky130_ef_sc_hd__decap_12
XPHY_EDGE_ROW_39_Left_161 VGND VGND VPWR VPWR sky130_fd_sc_hd__decap_3
X_07790_ tanh_inst.divider.x\[-15\] _02579_ VGND VGND VPWR VPWR _02591_ sky130_fd_sc_hd__or2_2
X_06810_ tanh_inst.z_\[7\] _01667_ _01702_ VGND VGND VPWR VPWR _01703_ sky130_fd_sc_hd__mux2_1
XTAP_TAPCELL_ROW_108_1612 VGND VPWR sky130_fd_sc_hd__tapvpwrvgnd_1
XFILLER_0_3_57 VPWR VGND VPWR VGND sky130_ef_sc_hd__decap_12
X_06741_ _01639_ _01641_ VGND VGND VPWR VPWR _01642_ sky130_fd_sc_hd__nor2_2
X_09460_ tanh_inst.divider.y\[-10\] _02014_ VGND VGND VPWR VPWR _04192_ sky130_fd_sc_hd__or2_2
X_06672_ _01502_ _01579_ _01580_ _01469_ mac_y_out[6] VGND VGND VPWR VPWR _00134_
+ sky130_fd_sc_hd__a32o_2
X_08411_ _03196_ _03197_ _02014_ VGND VGND VPWR VPWR _03198_ sky130_fd_sc_hd__o21ai_2
XPHY_EDGE_ROW_48_Left_170 VGND VGND VPWR VPWR sky130_fd_sc_hd__decap_3
Xclkbuf_leaf_16_clk clknet_2_3__leaf_clk VGND VGND VPWR VPWR clknet_leaf_16_clk sky130_fd_sc_hd__clkbuf_8
X_09391_ _04052_ _04082_ _04124_ _04122_ _04081_ VGND VGND VPWR VPWR _04125_ sky130_fd_sc_hd__o311a_2
XTAP_TAPCELL_ROW_19_496 VGND VPWR sky130_fd_sc_hd__tapvpwrvgnd_1
X_05623_ mac_inst.z\[31\] _00608_ VGND VGND VPWR VPWR _00609_ sky130_fd_sc_hd__and2_2
XFILLER_0_80_53 VPWR VGND VPWR VGND sky130_ef_sc_hd__decap_12
X_08342_ tanh_inst.divider.y\[-2\] tanh_inst.divider.x\[-2\] VGND VGND VPWR VPWR _03130_
+ sky130_fd_sc_hd__nand2_2
X_05554_ mac_inst.y\[17\] _00534_ _00535_ _00526_ mac_inst.y\[16\] VGND VGND VPWR
+ VPWR _00547_ sky130_fd_sc_hd__o311a_2
XFILLER_0_46_313 VGND VGND VPWR VPWR sky130_fd_sc_hd__fill_1
XFILLER_0_117_713 VGND VGND VPWR VPWR sky130_fd_sc_hd__decap_8
XFILLER_0_104_82 VGND VGND VPWR VPWR sky130_fd_sc_hd__fill_2
XFILLER_0_80_97 VGND VGND VPWR VPWR sky130_fd_sc_hd__decap_6
XFILLER_0_58_195 VGND VGND VPWR VPWR sky130_fd_sc_hd__fill_1
X_05485_ _00481_ _00483_ VGND VGND VPWR VPWR _00484_ sky130_fd_sc_hd__xnor2_2
X_08273_ _02999_ _03003_ _02977_ VGND VGND VPWR VPWR _03063_ sky130_fd_sc_hd__a21oi_2
XFILLER_0_104_93 VGND VGND VPWR VPWR sky130_fd_sc_hd__fill_1
X_07224_ tanh_inst.divider.y\[-11\] _02028_ _02029_ VGND VGND VPWR VPWR _02034_ sky130_fd_sc_hd__o21a_2
XFILLER_0_34_519 VGND VGND VPWR VPWR sky130_fd_sc_hd__decap_4
XTAP_TAPCELL_ROW_119_1752 VGND VPWR sky130_fd_sc_hd__tapvpwrvgnd_1
XFILLER_0_104_418 VGND VGND VPWR VPWR sky130_fd_sc_hd__fill_2
XFILLER_0_80_3 VGND VGND VPWR VPWR sky130_fd_sc_hd__decap_6
XFILLER_0_73_198 VGND VGND VPWR VPWR sky130_fd_sc_hd__decap_8
XFILLER_0_61_349 VGND VGND VPWR VPWR sky130_fd_sc_hd__decap_6
XFILLER_0_54_390 VGND VGND VPWR VPWR sky130_fd_sc_hd__decap_8
XFILLER_0_14_221 VPWR VGND VPWR VGND sky130_ef_sc_hd__decap_12
XFILLER_0_27_593 VGND VGND VPWR VPWR sky130_fd_sc_hd__fill_2
X_07155_ tanh_inst.divider.z_\[1\] _01975_ VGND VGND VPWR VPWR _01976_ sky130_fd_sc_hd__xnor2_2
XFILLER_0_89_73 VGND VGND VPWR VPWR sky130_fd_sc_hd__fill_1
XFILLER_0_14_265 VPWR VGND VPWR VGND sky130_ef_sc_hd__decap_12
X_06106_ _01051_ _01052_ VGND VGND VPWR VPWR _01053_ sky130_fd_sc_hd__or2_2
X_07086_ _01913_ _01914_ _01088_ _00182_ VGND VGND VPWR VPWR _00214_ sky130_fd_sc_hd__o2bb2a_2
XFILLER_0_2_660 VGND VGND VPWR VPWR sky130_fd_sc_hd__fill_1
X_06037_ _00987_ _00988_ mac_inst.z\[27\] VGND VGND VPWR VPWR _00989_ sky130_fd_sc_hd__a21o_2
XFILLER_0_1_181 VPWR VGND VPWR VGND sky130_ef_sc_hd__decap_12
XFILLER_0_100_679 VGND VGND VPWR VPWR sky130_fd_sc_hd__decap_4
X_07988_ tanh_inst.divider.x\[-11\] _02014_ _02784_ _01470_ VGND VGND VPWR VPWR _00246_
+ sky130_fd_sc_hd__o211a_2
XPHY_EDGE_ROW_114_Right_114 VGND VGND VPWR VPWR sky130_fd_sc_hd__decap_3
X_06939_ tanh_inst.divider.z_\[-23\] _01092_ _01783_ _01088_ VGND VGND VPWR VPWR _00198_
+ sky130_fd_sc_hd__a22o_2
X_09727_ _04386_ _04450_ _04419_ VGND VGND VPWR VPWR _04451_ sky130_fd_sc_hd__a21o_2
XFILLER_0_69_449 VGND VGND VPWR VPWR sky130_fd_sc_hd__decap_6
X_09658_ _04270_ _04311_ _04381_ _04383_ _04348_ VGND VGND VPWR VPWR _04384_ sky130_fd_sc_hd__o32a_2
X_09589_ _04765_ _04308_ VGND VGND VPWR VPWR _04317_ sky130_fd_sc_hd__nor2_2
X_08609_ _03283_ _03284_ _03347_ tanh_inst.z_\[7\] VGND VGND VPWR VPWR _03391_ sky130_fd_sc_hd__a31o_2
XFILLER_0_92_441 VPWR VGND VPWR VGND sky130_ef_sc_hd__decap_12
XFILLER_0_80_614 VGND VGND VPWR VPWR sky130_fd_sc_hd__decap_3
XFILLER_0_65_688 VGND VGND VPWR VPWR sky130_fd_sc_hd__decap_6
XFILLER_0_9_281 VPWR VGND VPWR VGND sky130_ef_sc_hd__decap_12
XFILLER_0_80_669 VGND VGND VPWR VPWR sky130_fd_sc_hd__decap_8
XFILLER_0_45_390 VGND VGND VPWR VPWR sky130_fd_sc_hd__fill_2
XFILLER_0_100_29 VPWR VGND VPWR VGND sky130_ef_sc_hd__decap_12
X_10433_ clknet_leaf_40_clk _00290_ _00000_ VGND VGND VPWR VPWR mac_inst.i\[25\] sky130_fd_sc_hd__dfrtp_2
X_10364_ clknet_leaf_17_clk _00221_ VGND VGND VPWR VPWR tanh_inst.divider.z_\[0\]
+ sky130_fd_sc_hd__dfxtp_2
XTAP_TAPCELL_ROW_94_1435 VGND VPWR sky130_fd_sc_hd__tapvpwrvgnd_1
X_10295_ clknet_leaf_29_clk _00152_ VGND VGND VPWR VPWR tanh_inst.z_\[0\] sky130_fd_sc_hd__dfxtp_2
XFILLER_0_109_27 VPWR VGND VPWR VGND sky130_ef_sc_hd__decap_12
XTAP_TAPCELL_ROW_36_709 VGND VPWR sky130_fd_sc_hd__tapvpwrvgnd_1
XFILLER_0_34_46 VPWR VGND VPWR VGND sky130_ef_sc_hd__decap_12
XFILLER_0_87_268 VGND VGND VPWR VPWR sky130_fd_sc_hd__fill_2
XTAP_TAPCELL_ROW_103_1553 VGND VPWR sky130_fd_sc_hd__tapvpwrvgnd_1
XFILLER_0_56_622 VGND VGND VPWR VPWR sky130_fd_sc_hd__fill_1
XFILLER_0_55_110 VGND VGND VPWR VPWR sky130_fd_sc_hd__fill_2
XTAP_TAPCELL_ROW_16_466 VGND VPWR sky130_fd_sc_hd__tapvpwrvgnd_1
XFILLER_0_55_132 VPWR VGND VPWR VGND sky130_ef_sc_hd__decap_12
XFILLER_0_119_3 VPWR VGND VPWR VGND sky130_ef_sc_hd__decap_12
XFILLER_0_71_669 VGND VGND VPWR VPWR sky130_fd_sc_hd__decap_3
XFILLER_0_55_187 VGND VGND VPWR VPWR sky130_fd_sc_hd__decap_8
X_05270_ mac_inst.i\[11\] mac_inst.i\[10\] _04970_ _04784_ VGND VGND VPWR VPWR _04971_
+ sky130_fd_sc_hd__a31o_2
XFILLER_0_36_390 VGND VGND VPWR VPWR sky130_fd_sc_hd__decap_4
XFILLER_0_43_349 VGND VGND VPWR VPWR sky130_fd_sc_hd__decap_4
XFILLER_0_59_43 VPWR VGND VPWR VGND sky130_ef_sc_hd__decap_12
XFILLER_0_24_585 VGND VGND VPWR VPWR sky130_fd_sc_hd__decap_3
XFILLER_0_24_596 VPWR VGND VPWR VGND sky130_ef_sc_hd__decap_12
XFILLER_0_121_281 VPWR VGND VPWR VGND sky130_ef_sc_hd__decap_12
Xclkbuf_leaf_5_clk clknet_2_2__leaf_clk VGND VGND VPWR VPWR clknet_leaf_5_clk sky130_fd_sc_hd__clkbuf_8
XTAP_TAPCELL_ROW_114_1682 VGND VPWR sky130_fd_sc_hd__tapvpwrvgnd_1
XFILLER_0_11_279 VGND VGND VPWR VPWR sky130_fd_sc_hd__fill_1
X_08960_ tanh_inst.divider.x\[7\] _03652_ _03653_ _03650_ _04759_ _04760_ VGND VGND
+ VPWR VPWR _03704_ sky130_fd_sc_hd__mux4_2
XTAP_TAPCELL_ROW_114_1693 VGND VPWR sky130_fd_sc_hd__tapvpwrvgnd_1
X_07911_ _02702_ _02707_ VGND VGND VPWR VPWR _02709_ sky130_fd_sc_hd__nor2_2
X_08891_ _03633_ _03635_ tanh_inst.LOOKUP.index\[2\] VGND VGND VPWR VPWR _03636_ sky130_fd_sc_hd__mux2_1
X_07842_ _01525_ _02247_ _02257_ _01477_ VGND VGND VPWR VPWR _02642_ sky130_fd_sc_hd__o22a_2
X_09512_ _03973_ _03993_ _04092_ _04240_ _04241_ VGND VGND VPWR VPWR _04242_ sky130_fd_sc_hd__a41oi_2
X_07773_ _02564_ _02572_ VGND VGND VPWR VPWR _02575_ sky130_fd_sc_hd__nand2_2
X_06724_ _01616_ _01626_ _01625_ VGND VGND VPWR VPWR _01627_ sky130_fd_sc_hd__a21oi_2
X_09443_ tanh_inst.divider.y\[-10\] _04173_ VGND VGND VPWR VPWR _04175_ sky130_fd_sc_hd__xnor2_2
X_06655_ _01564_ VGND VGND VPWR VPWR _01565_ sky130_fd_sc_hd__inv_2
X_09374_ _04030_ _04106_ _04107_ _04071_ VGND VGND VPWR VPWR _04108_ sky130_fd_sc_hd__a211o_2
XFILLER_0_115_81 VPWR VGND VPWR VGND sky130_ef_sc_hd__decap_12
XTAP_TAPCELL_ROW_65_1069 VGND VPWR sky130_fd_sc_hd__tapvpwrvgnd_1
X_05606_ _00592_ _00593_ VGND VGND VPWR VPWR _05606_/X sky130_fd_sc_hd__xor2_2
XFILLER_0_47_633 VGND VGND VPWR VPWR sky130_fd_sc_hd__decap_3
XFILLER_0_117_510 VGND VGND VPWR VPWR sky130_fd_sc_hd__decap_4
X_06586_ _01500_ VGND VGND VPWR VPWR _01501_ sky130_fd_sc_hd__inv_2
XFILLER_0_19_335 VGND VGND VPWR VPWR sky130_fd_sc_hd__fill_1
XFILLER_0_19_357 VGND VGND VPWR VPWR sky130_fd_sc_hd__decap_3
X_08325_ _03113_ VGND VGND VPWR VPWR _03114_ sky130_fd_sc_hd__inv_2
XFILLER_0_74_463 VPWR VGND VPWR VGND sky130_ef_sc_hd__decap_12
X_05537_ _04911_ _04994_ VGND VGND VPWR VPWR _00531_ sky130_fd_sc_hd__and2_2
XFILLER_0_47_688 VGND VGND VPWR VPWR sky130_fd_sc_hd__decap_3
XFILLER_0_61_113 VGND VGND VPWR VPWR sky130_fd_sc_hd__fill_2
XFILLER_0_6_251 VGND VGND VPWR VPWR sky130_fd_sc_hd__fill_1
XFILLER_0_34_338 VGND VGND VPWR VPWR sky130_fd_sc_hd__fill_1
X_05468_ _00465_ _00467_ VGND VGND VPWR VPWR _00468_ sky130_fd_sc_hd__xnor2_2
X_08256_ tanh_inst.divider.y\[-4\] tanh_inst.divider.x\[-4\] VGND VGND VPWR VPWR _03046_
+ sky130_fd_sc_hd__or2_2
XFILLER_0_104_215 VGND VGND VPWR VPWR sky130_fd_sc_hd__decap_6
X_07207_ _02016_ _02017_ _01469_ VGND VGND VPWR VPWR _00232_ sky130_fd_sc_hd__a21oi_2
XFILLER_0_61_146 VGND VGND VPWR VPWR sky130_fd_sc_hd__decap_8
X_08187_ _02924_ _02929_ _02893_ VGND VGND VPWR VPWR _02979_ sky130_fd_sc_hd__a21o_2
X_07138_ tanh_inst.divider.z_\[-1\] _01960_ VGND VGND VPWR VPWR _01961_ sky130_fd_sc_hd__nand2_2
XFILLER_0_15_596 VPWR VGND VPWR VGND sky130_ef_sc_hd__decap_12
X_05399_ _00376_ _00377_ _00392_ mac_inst.z\[31\] VGND VGND VPWR VPWR _00404_ sky130_fd_sc_hd__a31o_2
XFILLER_0_112_292 VGND VGND VPWR VPWR sky130_fd_sc_hd__decap_6
X_07069_ _01887_ _01892_ _01899_ VGND VGND VPWR VPWR _01900_ sky130_fd_sc_hd__a21o_2
X_10080_ clknet_leaf_11_clk _00097_ VGND VGND VPWR VPWR tanh_inst.divider.y_\[-13\]
+ sky130_fd_sc_hd__dfxtp_2
XFILLER_0_85_717 VGND VGND VPWR VPWR sky130_fd_sc_hd__decap_6
XFILLER_0_97_599 VGND VGND VPWR VPWR sky130_fd_sc_hd__decap_3
XFILLER_0_37_110 VGND VGND VPWR VPWR sky130_fd_sc_hd__fill_2
XTAP_TAPCELL_ROW_13_425 VGND VPWR sky130_fd_sc_hd__tapvpwrvgnd_1
XFILLER_0_25_305 VPWR VGND VPWR VGND sky130_ef_sc_hd__decap_12
XFILLER_0_20_15 VPWR VGND VPWR VGND sky130_ef_sc_hd__decap_12
XTAP_TAPCELL_ROW_41_778 VGND VPWR sky130_fd_sc_hd__tapvpwrvgnd_1
XFILLER_0_111_39 VPWR VGND VPWR VGND sky130_ef_sc_hd__decap_12
X_10416_ clknet_leaf_37_clk _00273_ _00000_ VGND VGND VPWR VPWR mac_inst.i\[8\] sky130_fd_sc_hd__dfrtp_2
XFILLER_0_0_405 VPWR VGND VPWR VGND sky130_ef_sc_hd__decap_12
X_10347_ clknet_leaf_15_clk _00204_ VGND VGND VPWR VPWR tanh_inst.divider.z_\[-17\]
+ sky130_fd_sc_hd__dfxtp_2
XFILLER_0_103_281 VGND VGND VPWR VPWR sky130_fd_sc_hd__fill_2
XFILLER_0_0_449 VPWR VGND VPWR VGND sky130_ef_sc_hd__decap_12
X_10278_ clknet_leaf_21_clk _00135_ VGND VGND VPWR VPWR tanh_inst.z_\[-17\] sky130_fd_sc_hd__dfxtp_2
XFILLER_0_29_57 VGND VGND VPWR VPWR sky130_fd_sc_hd__decap_4
XFILLER_0_29_68 VGND VGND VPWR VPWR sky130_fd_sc_hd__decap_8
XFILLER_0_88_533 VGND VGND VPWR VPWR sky130_fd_sc_hd__fill_1
XTAP_TAPCELL_ROW_49_878 VGND VPWR sky130_fd_sc_hd__tapvpwrvgnd_1
X_06440_ tanh_inst.divider.y\[-3\] tanh_inst.div_en tanh_inst.divider.y_\[-3\] _01092_
+ VGND VGND VPWR VPWR _01366_ sky130_fd_sc_hd__a22o_2
XFILLER_0_88_599 VPWR VGND VPWR VGND sky130_ef_sc_hd__decap_12
XFILLER_0_75_216 VGND VGND VPWR VPWR sky130_fd_sc_hd__fill_1
XFILLER_0_8_527 VGND VGND VPWR VPWR sky130_fd_sc_hd__decap_4
XFILLER_0_0_69 VPWR VGND VPWR VGND sky130_ef_sc_hd__decap_12
X_06371_ _01299_ _01301_ VGND VGND VPWR VPWR _01302_ sky130_fd_sc_hd__xnor2_2
XFILLER_0_29_688 VGND VGND VPWR VPWR sky130_fd_sc_hd__fill_2
X_09090_ tanh_inst.divider.x\[7\] _03603_ _02025_ VGND VGND VPWR VPWR _03831_ sky130_fd_sc_hd__mux2_1
XFILLER_0_83_293 VPWR VGND VPWR VGND sky130_ef_sc_hd__decap_12
XFILLER_0_71_433 VGND VGND VPWR VPWR sky130_fd_sc_hd__fill_2
XFILLER_0_71_411 VGND VGND VPWR VPWR sky130_fd_sc_hd__decap_6
X_08110_ _02902_ _02903_ VGND VGND VPWR VPWR _02904_ sky130_fd_sc_hd__nand2_2
XFILLER_0_56_485 VPWR VGND VPWR VGND sky130_ef_sc_hd__decap_12
X_05322_ _04788_ mac_inst.i\[5\] VGND VGND VPWR VPWR _05021_ sky130_fd_sc_hd__nand2_2
X_08041_ _02022_ _02486_ _02052_ VGND VGND VPWR VPWR _02836_ sky130_fd_sc_hd__o21a_2
X_05253_ mac_inst.i\[20\] _04952_ _04953_ VGND VGND VPWR VPWR _04954_ sky130_fd_sc_hd__and3_2
XTAP_TAPCELL_ROW_116_1711 VGND VPWR sky130_fd_sc_hd__tapvpwrvgnd_1
XFILLER_0_24_360 VGND VGND VPWR VPWR sky130_fd_sc_hd__decap_4
X_05184_ mac_inst.x\[11\] _04852_ _04853_ VGND VGND VPWR VPWR _04888_ sky130_fd_sc_hd__a21oi_2
X_09992_ _04763_ _04707_ VGND VGND VPWR VPWR _04708_ sky130_fd_sc_hd__nor2_2
X_08943_ tanh_inst.divider.x\[-22\] _03686_ VGND VGND VPWR VPWR _03687_ sky130_fd_sc_hd__xnor2_2
XFILLER_0_86_85 VPWR VGND VPWR VGND sky130_ef_sc_hd__decap_12
XFILLER_0_43_3 VGND VGND VPWR VPWR sky130_fd_sc_hd__decap_4
X_08874_ _03616_ _03617_ _03571_ VGND VGND VPWR VPWR _03619_ sky130_fd_sc_hd__a21o_2
X_07825_ tanh_inst.divider.y\[-14\] tanh_inst.divider.x\[-14\] VGND VGND VPWR VPWR
+ _02625_ sky130_fd_sc_hd__nor2_2
XFILLER_0_98_319 VGND VGND VPWR VPWR sky130_fd_sc_hd__decap_3
X_07756_ _02463_ _02556_ VGND VGND VPWR VPWR _02558_ sky130_fd_sc_hd__or2_2
X_06707_ _01609_ _01611_ VGND VGND VPWR VPWR _01612_ sky130_fd_sc_hd__nand2_2
X_09426_ tanh_inst.divider.y\[-11\] _02014_ _04148_ _04158_ _01470_ VGND VGND VPWR
+ VPWR _00310_ sky130_fd_sc_hd__o221a_2
X_07687_ _02022_ _02489_ _02488_ VGND VGND VPWR VPWR _02490_ sky130_fd_sc_hd__o21a_2
X_06638_ tanh_inst.z_\[-21\] _01548_ VGND VGND VPWR VPWR _01550_ sky130_fd_sc_hd__nor2_2
XFILLER_0_47_430 VGND VGND VPWR VPWR sky130_fd_sc_hd__decap_3
X_09357_ _02671_ _04059_ _04035_ VGND VGND VPWR VPWR _04091_ sky130_fd_sc_hd__a21o_2
X_06569_ tanh_inst.LOOKUP.index\[1\] tanh_inst.LOOKUP.index\[0\] VGND VGND VPWR VPWR
+ _01484_ sky130_fd_sc_hd__nand2b_2
XFILLER_0_62_400 VPWR VGND VPWR VGND sky130_ef_sc_hd__decap_12
XFILLER_0_47_474 VGND VGND VPWR VPWR sky130_fd_sc_hd__decap_6
X_09288_ tanh_inst.divider.x\[-14\] _04023_ VGND VGND VPWR VPWR _04024_ sky130_fd_sc_hd__nor2_2
X_08308_ tanh_inst.divider.y\[-3\] tanh_inst.divider.x\[-3\] VGND VGND VPWR VPWR _03097_
+ sky130_fd_sc_hd__nand2_2
XFILLER_0_105_513 VGND VGND VPWR VPWR sky130_fd_sc_hd__decap_6
X_08239_ tanh_inst.divider.x\[-4\] _03028_ VGND VGND VPWR VPWR _03029_ sky130_fd_sc_hd__and2_2
XTAP_TAPCELL_ROW_78_1238 VGND VPWR sky130_fd_sc_hd__tapvpwrvgnd_1
XTAP_TAPCELL_ROW_91_1405 VGND VPWR sky130_fd_sc_hd__tapvpwrvgnd_1
XFILLER_0_30_363 VGND VGND VPWR VPWR sky130_fd_sc_hd__fill_1
X_10201_ x_in[27] _00000_ VGND VGND VPWR VPWR mac_inst.x\[27\] sky130_fd_sc_hd__dlxtn_1
XFILLER_0_100_240 VGND VGND VPWR VPWR sky130_fd_sc_hd__fill_1
X_10063_ rst VGND VGND VPWR VPWR _00082_ sky130_fd_sc_hd__inv_2
XTAP_TAPCELL_ROW_89_1378 VGND VPWR sky130_fd_sc_hd__tapvpwrvgnd_1
XFILLER_0_15_15 VPWR VGND VPWR VGND sky130_ef_sc_hd__decap_12
XTAP_TAPCELL_ROW_46_837 VGND VPWR sky130_fd_sc_hd__tapvpwrvgnd_1
XFILLER_0_85_558 VGND VGND VPWR VPWR sky130_fd_sc_hd__fill_2
XTAP_TAPCELL_ROW_26_583 VGND VPWR sky130_fd_sc_hd__tapvpwrvgnd_1
XTAP_TAPCELL_ROW_100_1512 VGND VPWR sky130_fd_sc_hd__tapvpwrvgnd_1
XFILLER_0_72_208 VGND VGND VPWR VPWR sky130_fd_sc_hd__decap_4
XFILLER_0_53_400 VPWR VGND VPWR VGND sky130_ef_sc_hd__decap_12
XFILLER_0_25_113 VPWR VGND VPWR VGND sky130_ef_sc_hd__decap_12
XFILLER_0_108_395 VGND VGND VPWR VPWR sky130_fd_sc_hd__fill_2
XFILLER_0_80_241 VGND VGND VPWR VPWR sky130_fd_sc_hd__decap_8
XFILLER_0_41_617 VGND VGND VPWR VPWR sky130_fd_sc_hd__decap_4
XFILLER_0_111_505 VGND VGND VPWR VPWR sky130_fd_sc_hd__decap_4
XFILLER_0_40_138 VGND VGND VPWR VPWR sky130_fd_sc_hd__fill_2
XTAP_TAPCELL_ROW_111_1652 VGND VPWR sky130_fd_sc_hd__tapvpwrvgnd_1
X_05940_ _00891_ _00898_ VGND VGND VPWR VPWR _00899_ sky130_fd_sc_hd__nand2_2
X_05871_ _00830_ _00832_ VGND VGND VPWR VPWR _00836_ sky130_fd_sc_hd__and2_2
X_07610_ tanh_inst.z_\[7\] _02413_ _02414_ _02019_ _02403_ VGND VGND VPWR VPWR _02415_
+ sky130_fd_sc_hd__o311a_2
X_08590_ _04791_ _03371_ VGND VGND VPWR VPWR _03372_ sky130_fd_sc_hd__nor2_2
X_07541_ tanh_inst.divider.x\[-20\] _02345_ VGND VGND VPWR VPWR _02347_ sky130_fd_sc_hd__xnor2_2
XFILLER_0_88_330 VGND VGND VPWR VPWR sky130_fd_sc_hd__decap_6
XFILLER_0_88_385 VGND VGND VPWR VPWR sky130_fd_sc_hd__fill_1
XFILLER_0_72_54 VGND VGND VPWR VPWR sky130_fd_sc_hd__decap_6
X_07472_ _02024_ _02275_ _02278_ VGND VGND VPWR VPWR _02279_ sky130_fd_sc_hd__a21oi_2
X_06423_ _01303_ _01313_ _01315_ _01326_ _01338_ VGND VGND VPWR VPWR _01350_ sky130_fd_sc_hd__a2111o_2
X_09211_ _03948_ _03949_ VGND VGND VPWR VPWR _03950_ sky130_fd_sc_hd__and2b_2
XTAP_TAPCELL_ROW_62_1039 VGND VPWR sky130_fd_sc_hd__tapvpwrvgnd_1
XFILLER_0_17_614 VGND VGND VPWR VPWR sky130_fd_sc_hd__fill_2
XFILLER_0_29_474 VGND VGND VPWR VPWR sky130_fd_sc_hd__fill_1
X_06354_ _01284_ _01286_ VGND VGND VPWR VPWR _01287_ sky130_fd_sc_hd__xor2_2
X_09142_ _03880_ _03881_ VGND VGND VPWR VPWR _03882_ sky130_fd_sc_hd__nand2_2
XFILLER_0_8_357 VGND VGND VPWR VPWR sky130_fd_sc_hd__decap_6
XFILLER_0_17_647 VGND VGND VPWR VPWR sky130_fd_sc_hd__fill_1
XFILLER_0_29_496 VGND VGND VPWR VPWR sky130_fd_sc_hd__fill_1
XFILLER_0_44_411 VGND VGND VPWR VPWR sky130_fd_sc_hd__decap_8
XFILLER_0_44_433 VPWR VGND VPWR VGND sky130_ef_sc_hd__decap_12
X_05305_ mac_inst.i\[0\] mac_inst.x\[2\] _04852_ _05004_ VGND VGND VPWR VPWR _05005_
+ sky130_fd_sc_hd__a31o_2
X_06285_ _01211_ _01212_ _01209_ VGND VGND VPWR VPWR _01223_ sky130_fd_sc_hd__a21bo_2
XFILLER_0_114_343 VGND VGND VPWR VPWR sky130_fd_sc_hd__fill_1
X_09073_ _01525_ _03814_ _03813_ _03812_ VGND VGND VPWR VPWR _03815_ sky130_fd_sc_hd__o211a_2
XFILLER_0_32_639 VGND VGND VPWR VPWR sky130_fd_sc_hd__decap_4
XFILLER_0_44_477 VGND VGND VPWR VPWR sky130_fd_sc_hd__decap_6
XFILLER_0_71_296 VGND VGND VPWR VPWR sky130_fd_sc_hd__decap_8
X_08024_ _01525_ _02471_ _02818_ _04757_ _02819_ VGND VGND VPWR VPWR _02820_ sky130_fd_sc_hd__o221a_2
X_05236_ mac_inst.i\[5\] _04936_ VGND VGND VPWR VPWR _04937_ sky130_fd_sc_hd__nor2_2
XFILLER_0_97_51 VGND VGND VPWR VPWR sky130_fd_sc_hd__decap_4
XFILLER_0_12_363 VGND VGND VPWR VPWR sky130_fd_sc_hd__fill_1
X_05167_ mac_inst.x\[27\] _04852_ _04853_ VGND VGND VPWR VPWR _04871_ sky130_fd_sc_hd__a21o_2
XFILLER_0_110_560 VGND VGND VPWR VPWR sky130_fd_sc_hd__fill_1
XTAP_TAPCELL_ROW_73_1179 VGND VPWR sky130_fd_sc_hd__tapvpwrvgnd_1
X_09975_ _04690_ _04691_ VGND VGND VPWR VPWR _04692_ sky130_fd_sc_hd__or2_2
X_05098_ tanh_counter\[2\] _04804_ _00000_ VGND VGND VPWR VPWR _04815_ sky130_fd_sc_hd__o21ai_2
X_08926_ _02025_ _03669_ VGND VGND VPWR VPWR _03670_ sky130_fd_sc_hd__nor2_2
XFILLER_0_99_617 VGND VGND VPWR VPWR sky130_fd_sc_hd__decap_4
X_08857_ tanh_inst.divider.x\[6\] _02028_ _03508_ tanh_inst.LOOKUP.index\[0\] VGND
+ VGND VPWR VPWR _03602_ sky130_fd_sc_hd__o211a_2
XFILLER_0_99_639 VGND VGND VPWR VPWR sky130_fd_sc_hd__fill_2
X_07808_ _02571_ _02574_ _02607_ VGND VGND VPWR VPWR _02609_ sky130_fd_sc_hd__a21oi_2
X_08788_ _02028_ _03533_ _03508_ VGND VGND VPWR VPWR _03534_ sky130_fd_sc_hd__o21ai_2
X_07739_ _02540_ _02539_ VGND VGND VPWR VPWR _02541_ sky130_fd_sc_hd__nand2b_2
XFILLER_0_79_385 VGND VGND VPWR VPWR sky130_fd_sc_hd__decap_6
XFILLER_0_67_503 VGND VGND VPWR VPWR sky130_fd_sc_hd__fill_1
XFILLER_0_39_205 VGND VGND VPWR VPWR sky130_fd_sc_hd__decap_4
XFILLER_0_67_547 VPWR VGND VPWR VGND sky130_ef_sc_hd__decap_12
X_09409_ _02766_ _04131_ VGND VGND VPWR VPWR _04142_ sky130_fd_sc_hd__nand2_2
XFILLER_0_54_219 VGND VGND VPWR VPWR sky130_fd_sc_hd__decap_4
XTAP_TAPCELL_ROW_23_553 VGND VPWR sky130_fd_sc_hd__tapvpwrvgnd_1
XFILLER_0_62_230 VGND VGND VPWR VPWR sky130_fd_sc_hd__fill_1
XTAP_TAPCELL_ROW_51_895 VGND VPWR sky130_fd_sc_hd__tapvpwrvgnd_1
XFILLER_0_105_398 VGND VGND VPWR VPWR sky130_fd_sc_hd__decap_6
XFILLER_0_50_469 VGND VGND VPWR VPWR sky130_fd_sc_hd__decap_6
XFILLER_0_30_182 VGND VGND VPWR VPWR sky130_fd_sc_hd__decap_3
XFILLER_0_117_27 VPWR VGND VPWR VGND sky130_ef_sc_hd__decap_12
X_10046_ _04755_ _04756_ _01469_ VGND VGND VPWR VPWR _00332_ sky130_fd_sc_hd__a21o_2
XTAP_TAPCELL_ROW_59_995 VGND VPWR sky130_fd_sc_hd__tapvpwrvgnd_1
XFILLER_0_58_525 VGND VGND VPWR VPWR sky130_fd_sc_hd__decap_6
XPHY_EDGE_ROW_11_Left_133 VGND VGND VPWR VPWR sky130_fd_sc_hd__decap_3
XFILLER_0_85_344 VGND VGND VPWR VPWR sky130_fd_sc_hd__decap_4
XFILLER_0_42_24 VGND VGND VPWR VPWR sky130_fd_sc_hd__decap_4
XFILLER_0_42_57 VGND VGND VPWR VPWR sky130_fd_sc_hd__fill_1
XFILLER_0_5_305 VPWR VGND VPWR VGND sky130_ef_sc_hd__decap_12
XFILLER_0_53_230 VGND VGND VPWR VPWR sky130_fd_sc_hd__fill_2
XFILLER_0_53_241 VGND VGND VPWR VPWR sky130_fd_sc_hd__decap_4
XFILLER_0_81_561 VGND VGND VPWR VPWR sky130_fd_sc_hd__decap_3
XFILLER_0_13_105 VGND VGND VPWR VPWR sky130_fd_sc_hd__decap_6
XFILLER_0_5_349 VPWR VGND VPWR VGND sky130_ef_sc_hd__decap_12
XFILLER_0_26_477 VGND VGND VPWR VPWR sky130_fd_sc_hd__decap_6
XFILLER_0_101_3 VPWR VGND VPWR VGND sky130_ef_sc_hd__decap_12
XFILLER_0_13_149 VPWR VGND VPWR VGND sky130_ef_sc_hd__decap_12
XFILLER_0_1_500 VGND VGND VPWR VPWR sky130_fd_sc_hd__decap_4
X_06070_ _01016_ _01017_ VGND VGND VPWR VPWR _01018_ sky130_fd_sc_hd__xor2_2
XPHY_EDGE_ROW_20_Left_142 VGND VGND VPWR VPWR sky130_fd_sc_hd__decap_3
XFILLER_0_41_447 VGND VGND VPWR VPWR sky130_fd_sc_hd__fill_1
XFILLER_0_53_296 VGND VGND VPWR VPWR sky130_fd_sc_hd__fill_1
XFILLER_0_67_32 VPWR VGND VPWR VGND sky130_ef_sc_hd__decap_12
XFILLER_0_21_193 VPWR VGND VPWR VGND sky130_ef_sc_hd__decap_12
X_06972_ tanh_inst.divider.z_\[-19\] _01812_ VGND VGND VPWR VPWR _01813_ sky130_fd_sc_hd__nor2_2
X_09760_ tanh_inst.divider.x\[-1\] _04482_ VGND VGND VPWR VPWR _04483_ sky130_fd_sc_hd__nor2_2
X_05923_ _00882_ _00883_ VGND VGND VPWR VPWR _00884_ sky130_fd_sc_hd__and2b_2
X_08711_ _00001_ _00690_ _00952_ mac_inst.i\[1\] VGND VGND VPWR VPWR _00266_ sky130_fd_sc_hd__a2bb2o_2
X_09691_ _04414_ _04415_ VGND VGND VPWR VPWR _04416_ sky130_fd_sc_hd__and2b_2
X_08642_ _03421_ _03422_ VGND VGND VPWR VPWR _03423_ sky130_fd_sc_hd__and2b_2
XFILLER_0_96_609 VGND VGND VPWR VPWR sky130_fd_sc_hd__fill_1
X_05854_ _00802_ _00812_ VGND VGND VPWR VPWR _00820_ sky130_fd_sc_hd__nand2_2
XFILLER_0_107_93 VPWR VGND VPWR VGND sky130_ef_sc_hd__decap_12
X_05785_ _00744_ _00747_ _00745_ VGND VGND VPWR VPWR _00756_ sky130_fd_sc_hd__o21a_2
X_08573_ _02019_ _03346_ _03353_ _03355_ _02015_ VGND VGND VPWR VPWR _03356_ sky130_fd_sc_hd__a221o_2
X_07524_ _02329_ _02330_ VGND VGND VPWR VPWR _02331_ sky130_fd_sc_hd__nand2_2
XFILLER_0_76_333 VGND VGND VPWR VPWR sky130_fd_sc_hd__decap_4
XFILLER_0_119_446 VGND VGND VPWR VPWR sky130_fd_sc_hd__fill_2
X_07455_ tanh_inst.divider.x\[-22\] _02261_ VGND VGND VPWR VPWR _02263_ sky130_fd_sc_hd__or2_2
XFILLER_0_8_121 VPWR VGND VPWR VGND sky130_ef_sc_hd__decap_12
XFILLER_0_49_569 VGND VGND VPWR VPWR sky130_fd_sc_hd__decap_3
X_06406_ _01300_ _01333_ tanh_inst.divider.y_\[7\] VGND VGND VPWR VPWR _01334_ sky130_fd_sc_hd__a21oi_2
XFILLER_0_45_720 VGND VGND VPWR VPWR sky130_fd_sc_hd__decap_4
X_07386_ _02193_ _02194_ VGND VGND VPWR VPWR _02195_ sky130_fd_sc_hd__xnor2_2
XFILLER_0_8_165 VPWR VGND VPWR VGND sky130_ef_sc_hd__decap_12
XTAP_TAPCELL_ROW_20_512 VGND VPWR sky130_fd_sc_hd__tapvpwrvgnd_1
XFILLER_0_32_90 VPWR VGND VPWR VGND sky130_ef_sc_hd__decap_12
X_06337_ tanh_inst.divider.y_\[-11\] _01269_ VGND VGND VPWR VPWR _01271_ sky130_fd_sc_hd__nor2_2
X_09125_ _02018_ _03865_ _02015_ VGND VGND VPWR VPWR _03866_ sky130_fd_sc_hd__a21o_2
X_06268_ _01194_ _01195_ tanh_inst.divider.y_\[7\] VGND VGND VPWR VPWR _01207_ sky130_fd_sc_hd__a21oi_2
X_09056_ _03782_ _03797_ VGND VGND VPWR VPWR _03798_ sky130_fd_sc_hd__or2_2
X_08007_ _02712_ _02763_ VGND VGND VPWR VPWR _02803_ sky130_fd_sc_hd__nor2_2
X_05219_ _04781_ mac_inst.i\[2\] VGND VGND VPWR VPWR _04923_ sky130_fd_sc_hd__nand2_2
X_06199_ _04777_ _01030_ VGND VGND VPWR VPWR _01142_ sky130_fd_sc_hd__nand2_2
X_09958_ _02019_ _04648_ _04664_ _04675_ VGND VGND VPWR VPWR _04676_ sky130_fd_sc_hd__o22a_2
X_08909_ tanh_inst.divider.x\[4\] tanh_inst.divider.x\[5\] tanh_inst.divider.x\[6\]
+ tanh_inst.divider.x\[7\] tanh_inst.LOOKUP.index\[0\] tanh_inst.LOOKUP.index\[1\]
+ VGND VGND VPWR VPWR _03654_ sky130_fd_sc_hd__mux4_2
X_09889_ _02018_ _04583_ _04584_ VGND VGND VPWR VPWR _04609_ sky130_fd_sc_hd__and3_2
XFILLER_0_99_447 VGND VGND VPWR VPWR sky130_fd_sc_hd__fill_1
XTAP_TAPCELL_ROW_86_1337 VGND VPWR sky130_fd_sc_hd__tapvpwrvgnd_1
XTAP_TAPCELL_ROW_28_612 VGND VPWR sky130_fd_sc_hd__tapvpwrvgnd_1
XFILLER_0_79_160 VGND VGND VPWR VPWR sky130_fd_sc_hd__decap_8
XTAP_TAPCELL_ROW_56_965 VGND VPWR sky130_fd_sc_hd__tapvpwrvgnd_1
XFILLER_0_94_141 VGND VGND VPWR VPWR sky130_fd_sc_hd__decap_8
XFILLER_0_27_208 VGND VGND VPWR VPWR sky130_fd_sc_hd__decap_3
XFILLER_0_12_27 VGND VGND VPWR VPWR sky130_fd_sc_hd__fill_1
XFILLER_0_51_723 VGND VGND VPWR VPWR sky130_fd_sc_hd__fill_1
XFILLER_0_120_121 VPWR VGND VPWR VGND sky130_ef_sc_hd__decap_12
XTAP_TAPCELL_ROW_97_1477 VGND VPWR sky130_fd_sc_hd__tapvpwrvgnd_1
XFILLER_0_120_165 VPWR VGND VPWR VGND sky130_ef_sc_hd__decap_12
XFILLER_0_37_57 VGND VGND VPWR VPWR sky130_fd_sc_hd__decap_4
X_10029_ _04791_ _04705_ _04706_ VGND VGND VPWR VPWR _04744_ sky130_fd_sc_hd__a21bo_2
X_05570_ _04911_ _00372_ _00509_ VGND VGND VPWR VPWR _00561_ sky130_fd_sc_hd__a21oi_2
XTAP_TAPCELL_ROW_106_1584 VGND VPWR sky130_fd_sc_hd__tapvpwrvgnd_1
XFILLER_0_58_377 VPWR VGND VPWR VGND sky130_ef_sc_hd__decap_12
XFILLER_0_39_580 VGND VGND VPWR VPWR sky130_fd_sc_hd__decap_3
X_07240_ _02038_ _02049_ _02025_ VGND VGND VPWR VPWR _02050_ sky130_fd_sc_hd__mux2_1
XFILLER_0_26_230 VPWR VGND VPWR VGND sky130_ef_sc_hd__decap_12
X_07171_ _01088_ _00192_ _01988_ _01989_ VGND VGND VPWR VPWR _00224_ sky130_fd_sc_hd__o22a_2
XFILLER_0_5_113 VPWR VGND VPWR VGND sky130_ef_sc_hd__decap_12
X_06122_ tanh_inst.divider.x\[3\] tanh_inst.divider.x\[4\] tanh_inst.divider.i\[0\]
+ VGND VGND VPWR VPWR _01068_ sky130_fd_sc_hd__mux2_1
XFILLER_0_111_143 VGND VGND VPWR VPWR sky130_fd_sc_hd__fill_2
X_06053_ _00995_ _01002_ VGND VGND VPWR VPWR _01003_ sky130_fd_sc_hd__and2_2
XFILLER_0_1_385 VGND VGND VPWR VPWR sky130_fd_sc_hd__decap_6
XTAP_TAPCELL_ROW_70_1138 VGND VPWR sky130_fd_sc_hd__tapvpwrvgnd_1
XFILLER_0_10_697 VGND VGND VPWR VPWR sky130_fd_sc_hd__decap_3
X_09812_ _04384_ _04533_ VGND VGND VPWR VPWR _04534_ sky130_fd_sc_hd__or2_2
XFILLER_0_94_41 VGND VGND VPWR VPWR sky130_fd_sc_hd__decap_6
X_06955_ _01796_ _01797_ VGND VGND VPWR VPWR _01798_ sky130_fd_sc_hd__xnor2_2
XFILLER_0_94_85 VPWR VGND VPWR VGND sky130_ef_sc_hd__decap_12
X_09743_ _04465_ _04466_ VGND VGND VPWR VPWR _04467_ sky130_fd_sc_hd__nand2_2
X_06886_ _04777_ _01765_ VGND VGND VPWR VPWR _01767_ sky130_fd_sc_hd__nor2_2
X_05906_ mac_inst.z\[31\] _00867_ VGND VGND VPWR VPWR _00868_ sky130_fd_sc_hd__nor2_2
X_09674_ _04398_ _04399_ VGND VGND VPWR VPWR _04400_ sky130_fd_sc_hd__nand2_2
XFILLER_0_96_428 VPWR VGND VPWR VGND sky130_ef_sc_hd__decap_12
XFILLER_0_96_417 VGND VGND VPWR VPWR sky130_fd_sc_hd__decap_3
X_08625_ tanh_inst.divider.y\[5\] tanh_inst.divider.x\[5\] VGND VGND VPWR VPWR _03406_
+ sky130_fd_sc_hd__nor2_2
X_05837_ _00803_ VGND VGND VPWR VPWR _00804_ sky130_fd_sc_hd__inv_2
XFILLER_0_49_311 VGND VGND VPWR VPWR sky130_fd_sc_hd__decap_8
X_08556_ tanh_inst.divider.y\[3\] tanh_inst.divider.x\[3\] VGND VGND VPWR VPWR _03339_
+ sky130_fd_sc_hd__nor2_2
XTAP_TAPCELL_ROW_53_924 VGND VPWR sky130_fd_sc_hd__tapvpwrvgnd_1
XFILLER_0_92_601 VPWR VGND VPWR VGND sky130_ef_sc_hd__decap_12
X_05768_ mac_inst.i\[2\] _04944_ _00691_ _00717_ VGND VGND VPWR VPWR _00740_ sky130_fd_sc_hd__or4_2
X_07507_ tanh_inst.divider.y\[3\] tanh_inst.divider.y\[4\] tanh_inst.divider.y\[5\]
+ tanh_inst.divider.y\[6\] tanh_inst.LOOKUP.index\[0\] tanh_inst.LOOKUP.index\[1\]
+ VGND VGND VPWR VPWR _02314_ sky130_fd_sc_hd__mux4_2
XFILLER_0_49_344 VGND VGND VPWR VPWR sky130_fd_sc_hd__fill_1
XFILLER_0_49_366 VGND VGND VPWR VPWR sky130_fd_sc_hd__fill_1
XFILLER_0_91_111 VGND VGND VPWR VPWR sky130_fd_sc_hd__fill_1
X_05699_ _04977_ _00675_ VGND VGND VPWR VPWR _00676_ sky130_fd_sc_hd__or2_2
X_08487_ _03269_ _03270_ tanh_inst.z_\[7\] VGND VGND VPWR VPWR _03272_ sky130_fd_sc_hd__o21a_2
XTAP_TAPCELL_ROW_81_1278 VGND VPWR sky130_fd_sc_hd__tapvpwrvgnd_1
XFILLER_0_64_369 VGND VGND VPWR VPWR sky130_fd_sc_hd__fill_1
XTAP_TAPCELL_ROW_33_670 VGND VPWR sky130_fd_sc_hd__tapvpwrvgnd_1
X_07438_ tanh_inst.divider.y\[-2\] tanh_inst.divider.y\[-1\] tanh_inst.divider.y\[0\]
+ tanh_inst.divider.y\[1\] tanh_inst.LOOKUP.index\[0\] tanh_inst.LOOKUP.index\[1\]
+ VGND VGND VPWR VPWR _02246_ sky130_fd_sc_hd__mux4_2
XFILLER_0_107_449 VGND VGND VPWR VPWR sky130_fd_sc_hd__decap_4
X_07369_ tanh_inst.divider.y\[-7\] tanh_inst.divider.y\[-6\] tanh_inst.divider.y\[-5\]
+ tanh_inst.divider.y\[-4\] tanh_inst.LOOKUP.index\[0\] tanh_inst.LOOKUP.index\[1\]
+ VGND VGND VPWR VPWR _02178_ sky130_fd_sc_hd__mux4_2
XFILLER_0_33_701 VGND VGND VPWR VPWR sky130_fd_sc_hd__fill_2
X_09108_ _02018_ _03848_ VGND VGND VPWR VPWR _03849_ sky130_fd_sc_hd__nor2_2
XFILLER_0_60_531 VGND VGND VPWR VPWR sky130_fd_sc_hd__fill_1
X_10380_ clknet_leaf_9_clk _00237_ VGND VGND VPWR VPWR tanh_inst.divider.x\[-20\]
+ sky130_fd_sc_hd__dfxtp_2
XFILLER_0_103_655 VGND VGND VPWR VPWR sky130_fd_sc_hd__decap_3
X_09039_ _03742_ _03744_ _03687_ _03688_ VGND VGND VPWR VPWR _03781_ sky130_fd_sc_hd__o211a_2
XFILLER_0_102_165 VPWR VGND VPWR VGND sky130_ef_sc_hd__decap_12
XFILLER_0_95_461 VPWR VGND VPWR VGND sky130_ef_sc_hd__decap_12
XFILLER_0_23_15 VPWR VGND VPWR VGND sky130_ef_sc_hd__decap_12
XFILLER_0_43_509 VGND VGND VPWR VPWR sky130_fd_sc_hd__fill_1
XFILLER_0_24_701 VGND VGND VPWR VPWR sky130_fd_sc_hd__fill_2
XFILLER_0_63_391 VGND VGND VPWR VPWR sky130_fd_sc_hd__fill_1
XFILLER_0_3_617 VGND VGND VPWR VPWR sky130_fd_sc_hd__decap_4
XFILLER_0_23_200 VPWR VGND VPWR VGND sky130_ef_sc_hd__decap_12
XFILLER_0_106_493 VPWR VGND VPWR VGND sky130_ef_sc_hd__decap_12
XTAP_TAPCELL_ROW_11_397 VGND VPWR sky130_fd_sc_hd__tapvpwrvgnd_1
XFILLER_0_11_428 VGND VGND VPWR VPWR sky130_fd_sc_hd__fill_1
XFILLER_0_121_485 VGND VGND VPWR VPWR sky130_fd_sc_hd__fill_2
XFILLER_0_48_78 VGND VGND VPWR VPWR sky130_fd_sc_hd__fill_1
XTAP_TAPCELL_ROW_108_1613 VGND VPWR sky130_fd_sc_hd__tapvpwrvgnd_1
XFILLER_0_3_69 VPWR VGND VPWR VGND sky130_ef_sc_hd__decap_12
X_06740_ tanh_inst.z_\[-10\] _01638_ VGND VGND VPWR VPWR _01641_ sky130_fd_sc_hd__nor2_2
X_06671_ _01565_ _01577_ _01576_ VGND VGND VPWR VPWR _01580_ sky130_fd_sc_hd__a21o_2
XFILLER_0_78_406 VGND VGND VPWR VPWR sky130_fd_sc_hd__decap_3
X_08410_ _03122_ _03128_ _03195_ _02019_ VGND VGND VPWR VPWR _03197_ sky130_fd_sc_hd__a31o_2
X_05622_ _00509_ _00607_ VGND VGND VPWR VPWR _00608_ sky130_fd_sc_hd__or2_2
X_09390_ _03983_ _04011_ _04012_ VGND VGND VPWR VPWR _04124_ sky130_fd_sc_hd__a21o_2
XFILLER_0_58_141 VGND VGND VPWR VPWR sky130_fd_sc_hd__decap_6
XTAP_TAPCELL_ROW_19_497 VGND VPWR sky130_fd_sc_hd__tapvpwrvgnd_1
XFILLER_0_80_65 VPWR VGND VPWR VGND sky130_ef_sc_hd__decap_12
X_08341_ _02053_ _02440_ _02834_ VGND VGND VPWR VPWR _03129_ sky130_fd_sc_hd__o21a_2
XFILLER_0_73_111 VGND VGND VPWR VPWR sky130_fd_sc_hd__fill_1
XFILLER_0_58_163 VPWR VGND VPWR VGND sky130_ef_sc_hd__decap_12
XFILLER_0_19_539 VGND VGND VPWR VPWR sky130_fd_sc_hd__decap_3
X_05553_ mac_inst.y\[18\] _00543_ VGND VGND VPWR VPWR _00546_ sky130_fd_sc_hd__xor2_2
XFILLER_0_73_122 VGND VGND VPWR VPWR sky130_fd_sc_hd__fill_1
X_05484_ mac_inst.z\[31\] _00482_ VGND VGND VPWR VPWR _00483_ sky130_fd_sc_hd__or2_2
X_08272_ _02899_ _02900_ _03061_ VGND VGND VPWR VPWR _03062_ sky130_fd_sc_hd__a21boi_2
X_07223_ tanh_inst.divider.y\[-10\] _02028_ _02029_ VGND VGND VPWR VPWR _02033_ sky130_fd_sc_hd__o21ai_2
XFILLER_0_13_81 VPWR VGND VPWR VGND sky130_ef_sc_hd__decap_12
XTAP_TAPCELL_ROW_30_640 VGND VPWR sky130_fd_sc_hd__tapvpwrvgnd_1
XTAP_TAPCELL_ROW_119_1753 VGND VPWR sky130_fd_sc_hd__tapvpwrvgnd_1
XFILLER_0_15_723 VGND VGND VPWR VPWR sky130_fd_sc_hd__fill_1
XFILLER_0_42_531 VGND VGND VPWR VPWR sky130_fd_sc_hd__fill_1
X_07154_ tanh_inst.divider.y_\[7\] _01965_ VGND VGND VPWR VPWR _01975_ sky130_fd_sc_hd__or2_2
XFILLER_0_14_233 VPWR VGND VPWR VGND sky130_ef_sc_hd__decap_12
XFILLER_0_112_452 VGND VGND VPWR VPWR sky130_fd_sc_hd__fill_1
X_06105_ tanh_inst.divider.y_\[-23\] tanh_inst.divider.y_\[-24\] tanh_inst.divider.y_\[-21\]
+ tanh_inst.divider.y_\[-22\] VGND VGND VPWR VPWR _01052_ sky130_fd_sc_hd__or4_2
X_07085_ _01903_ _01906_ _01912_ _01060_ VGND VGND VPWR VPWR _01914_ sky130_fd_sc_hd__o31a_2
XFILLER_0_73_3 VGND VGND VPWR VPWR sky130_fd_sc_hd__decap_8
XFILLER_0_14_277 VPWR VGND VPWR VGND sky130_ef_sc_hd__decap_12
XFILLER_0_42_586 VGND VGND VPWR VPWR sky130_fd_sc_hd__fill_2
X_06036_ _04795_ _00986_ VGND VGND VPWR VPWR _00988_ sky130_fd_sc_hd__or2_2
XFILLER_0_1_193 VPWR VGND VPWR VGND sky130_ef_sc_hd__decap_12
X_07987_ _02018_ _02772_ _02782_ _02783_ _02014_ VGND VGND VPWR VPWR _02784_ sky130_fd_sc_hd__o221ai_2
X_06938_ _01781_ _01782_ VGND VGND VPWR VPWR _01783_ sky130_fd_sc_hd__xnor2_2
X_09726_ _03101_ _04406_ _04379_ VGND VGND VPWR VPWR _04450_ sky130_fd_sc_hd__o21a_2
XTAP_TAPCELL_ROW_38_740 VGND VPWR sky130_fd_sc_hd__tapvpwrvgnd_1
X_06869_ tanh_inst.z_\[5\] _01667_ VGND VGND VPWR VPWR _01755_ sky130_fd_sc_hd__nor2_2
X_09657_ _03003_ _04334_ _04309_ VGND VGND VPWR VPWR _04383_ sky130_fd_sc_hd__o21a_2
X_08608_ _03388_ _03389_ _02019_ VGND VGND VPWR VPWR _03390_ sky130_fd_sc_hd__o21a_2
X_09588_ _04314_ _04315_ VGND VGND VPWR VPWR _04316_ sky130_fd_sc_hd__nand2_2
XFILLER_0_77_483 VPWR VGND VPWR VGND sky130_ef_sc_hd__decap_12
XFILLER_0_77_472 VGND VGND VPWR VPWR sky130_fd_sc_hd__decap_4
X_08539_ _03308_ _03322_ tanh_inst.z_\[7\] VGND VGND VPWR VPWR _03323_ sky130_fd_sc_hd__mux2_1
XFILLER_0_92_453 VGND VGND VPWR VPWR sky130_fd_sc_hd__decap_8
XFILLER_0_65_667 VGND VGND VPWR VPWR sky130_fd_sc_hd__decap_4
XFILLER_0_65_656 VGND VGND VPWR VPWR sky130_fd_sc_hd__decap_4
XFILLER_0_107_213 VGND VGND VPWR VPWR sky130_fd_sc_hd__decap_4
XFILLER_0_64_177 VGND VGND VPWR VPWR sky130_fd_sc_hd__decap_8
XFILLER_0_9_293 VPWR VGND VPWR VGND sky130_ef_sc_hd__decap_12
X_10432_ clknet_leaf_40_clk _00289_ _00000_ VGND VGND VPWR VPWR mac_inst.i\[24\] sky130_fd_sc_hd__dfrtp_2
X_10363_ clknet_leaf_17_clk _00220_ VGND VGND VPWR VPWR tanh_inst.divider.z_\[-1\]
+ sky130_fd_sc_hd__dfxtp_2
XTAP_TAPCELL_ROW_94_1436 VGND VPWR sky130_fd_sc_hd__tapvpwrvgnd_1
XFILLER_0_60_361 VGND VGND VPWR VPWR sky130_fd_sc_hd__decap_3
XFILLER_0_60_394 VPWR VGND VPWR VGND sky130_ef_sc_hd__decap_12
X_10294_ clknet_leaf_29_clk _00151_ VGND VGND VPWR VPWR tanh_inst.z_\[-1\] sky130_fd_sc_hd__dfxtp_2
XFILLER_0_109_39 VPWR VGND VPWR VGND sky130_ef_sc_hd__decap_12
XFILLER_0_18_15 VPWR VGND VPWR VGND sky130_ef_sc_hd__decap_12
XFILLER_0_34_58 VPWR VGND VPWR VGND sky130_ef_sc_hd__decap_12
XTAP_TAPCELL_ROW_103_1554 VGND VPWR sky130_fd_sc_hd__tapvpwrvgnd_1
XTAP_TAPCELL_ROW_16_456 VGND VPWR sky130_fd_sc_hd__tapvpwrvgnd_1
XFILLER_0_83_442 VGND VGND VPWR VPWR sky130_fd_sc_hd__fill_1
XFILLER_0_83_420 VGND VGND VPWR VPWR sky130_fd_sc_hd__decap_8
XFILLER_0_68_494 VGND VGND VPWR VPWR sky130_fd_sc_hd__fill_1
XTAP_TAPCELL_ROW_16_467 VGND VPWR sky130_fd_sc_hd__tapvpwrvgnd_1
XFILLER_0_28_325 VGND VGND VPWR VPWR sky130_fd_sc_hd__fill_1
XFILLER_0_55_166 VGND VGND VPWR VPWR sky130_fd_sc_hd__fill_2
XFILLER_0_55_144 VGND VGND VPWR VPWR sky130_fd_sc_hd__decap_4
XFILLER_0_28_369 VGND VGND VPWR VPWR sky130_fd_sc_hd__fill_1
XFILLER_0_50_35 VGND VGND VPWR VPWR sky130_fd_sc_hd__fill_1
XFILLER_0_50_46 VGND VGND VPWR VPWR sky130_fd_sc_hd__fill_1
XFILLER_0_70_125 VPWR VGND VPWR VGND sky130_ef_sc_hd__decap_12
XFILLER_0_3_447 VGND VGND VPWR VPWR sky130_fd_sc_hd__fill_1
XFILLER_0_3_469 VGND VGND VPWR VPWR sky130_fd_sc_hd__fill_1
XFILLER_0_59_77 VGND VGND VPWR VPWR sky130_fd_sc_hd__decap_3
XFILLER_0_59_55 VGND VGND VPWR VPWR sky130_fd_sc_hd__fill_1
XFILLER_0_11_225 VPWR VGND VPWR VGND sky130_ef_sc_hd__decap_12
XFILLER_0_121_293 VPWR VGND VPWR VGND sky130_ef_sc_hd__decap_12
XTAP_TAPCELL_ROW_114_1683 VGND VPWR sky130_fd_sc_hd__tapvpwrvgnd_1
X_07910_ _02702_ _02707_ VGND VGND VPWR VPWR _02708_ sky130_fd_sc_hd__nand2_2
X_08890_ tanh_inst.divider.x\[7\] _03634_ _04760_ VGND VGND VPWR VPWR _03635_ sky130_fd_sc_hd__mux2_1
XFILLER_0_75_54 VGND VGND VPWR VPWR sky130_fd_sc_hd__fill_2
X_07841_ tanh_inst.LOOKUP.index\[3\] _02250_ _02509_ VGND VGND VPWR VPWR _02641_ sky130_fd_sc_hd__o21ai_2
X_07772_ _02564_ _02572_ VGND VGND VPWR VPWR _02574_ sky130_fd_sc_hd__or2_2
XPHY_EDGE_ROW_3_Left_125 VGND VGND VPWR VPWR sky130_fd_sc_hd__decap_3
X_09511_ _04090_ _04094_ _04144_ _04238_ VGND VGND VPWR VPWR _04241_ sky130_fd_sc_hd__nor4b_2
X_06723_ _01601_ _01608_ _01610_ _01615_ _01607_ VGND VGND VPWR VPWR _01626_ sky130_fd_sc_hd__a311o_2
X_09442_ tanh_inst.divider.y\[-10\] _04173_ VGND VGND VPWR VPWR _04174_ sky130_fd_sc_hd__nand2_2
X_06654_ tanh_inst.z_\[-19\] _01563_ VGND VGND VPWR VPWR _01564_ sky130_fd_sc_hd__nor2_2
XFILLER_0_66_409 VGND VGND VPWR VPWR sky130_fd_sc_hd__fill_2
X_09373_ _04022_ _04024_ _04069_ _04028_ VGND VGND VPWR VPWR _04107_ sky130_fd_sc_hd__o31a_2
X_06585_ _01494_ _01497_ _01499_ VGND VGND VPWR VPWR _01500_ sky130_fd_sc_hd__or3_2
X_05605_ _00580_ _00585_ _00579_ VGND VGND VPWR VPWR _00593_ sky130_fd_sc_hd__a21o_2
XFILLER_0_115_93 VPWR VGND VPWR VGND sky130_ef_sc_hd__decap_12
X_08324_ tanh_inst.divider.x\[-3\] _03110_ VGND VGND VPWR VPWR _03113_ sky130_fd_sc_hd__xnor2_2
X_05536_ _00527_ _00530_ VGND VGND VPWR VPWR _05536_/X sky130_fd_sc_hd__xor2_2
XFILLER_0_46_122 VGND VGND VPWR VPWR sky130_fd_sc_hd__fill_1
XFILLER_0_74_475 VGND VGND VPWR VPWR sky130_fd_sc_hd__fill_1
XFILLER_0_117_555 VGND VGND VPWR VPWR sky130_fd_sc_hd__decap_4
X_05467_ mac_inst.z\[31\] _00466_ VGND VGND VPWR VPWR _00467_ sky130_fd_sc_hd__or2_2
X_08255_ _03037_ _03043_ VGND VGND VPWR VPWR _03045_ sky130_fd_sc_hd__or2_2
X_07206_ tanh_inst.IS_Z_ZERO _02012_ _01500_ VGND VGND VPWR VPWR _02017_ sky130_fd_sc_hd__mux2_1
XFILLER_0_61_169 VGND VGND VPWR VPWR sky130_fd_sc_hd__decap_8
XFILLER_0_27_391 VGND VGND VPWR VPWR sky130_fd_sc_hd__fill_1
X_05398_ _04836_ _00400_ _00402_ VGND VGND VPWR VPWR _00403_ sky130_fd_sc_hd__o21ai_2
X_08186_ _02954_ _02976_ VGND VGND VPWR VPWR _02978_ sky130_fd_sc_hd__xor2_2
X_07137_ tanh_inst.divider.i\[2\] _01031_ _01035_ _01959_ VGND VGND VPWR VPWR _01960_
+ sky130_fd_sc_hd__o31a_2
X_07068_ _01897_ _01898_ VGND VGND VPWR VPWR _01899_ sky130_fd_sc_hd__nand2_2
XFILLER_0_100_477 VGND VGND VPWR VPWR sky130_fd_sc_hd__decap_6
X_06019_ mac_inst.z\[25\] _00972_ VGND VGND VPWR VPWR _00973_ sky130_fd_sc_hd__nand2_2
XFILLER_0_97_523 VGND VGND VPWR VPWR sky130_fd_sc_hd__decap_8
X_09709_ _04368_ _04377_ _04431_ _02018_ VGND VGND VPWR VPWR _04434_ sky130_fd_sc_hd__o31a_2
XFILLER_0_38_634 VGND VGND VPWR VPWR sky130_fd_sc_hd__decap_8
XFILLER_0_38_645 VPWR VGND VPWR VGND sky130_ef_sc_hd__decap_12
XPHY_EDGE_ROW_67_Left_189 VGND VGND VPWR VPWR sky130_fd_sc_hd__decap_3
XTAP_TAPCELL_ROW_13_426 VGND VPWR sky130_fd_sc_hd__tapvpwrvgnd_1
XFILLER_0_37_166 VGND VGND VPWR VPWR sky130_fd_sc_hd__fill_2
XFILLER_0_25_317 VPWR VGND VPWR VGND sky130_ef_sc_hd__decap_12
XFILLER_0_37_199 VGND VGND VPWR VPWR sky130_fd_sc_hd__fill_1
XTAP_TAPCELL_ROW_41_779 VGND VPWR sky130_fd_sc_hd__tapvpwrvgnd_1
XFILLER_0_80_456 VGND VGND VPWR VPWR sky130_fd_sc_hd__fill_1
XFILLER_0_20_27 VGND VGND VPWR VPWR sky130_fd_sc_hd__fill_1
XFILLER_0_40_309 VPWR VGND VPWR VGND sky130_ef_sc_hd__decap_12
XFILLER_0_21_501 VGND VGND VPWR VPWR sky130_fd_sc_hd__decap_3
X_10415_ clknet_leaf_37_clk _00272_ _00000_ VGND VGND VPWR VPWR mac_inst.i\[7\] sky130_fd_sc_hd__dfrtp_2
XFILLER_0_110_208 VGND VGND VPWR VPWR sky130_fd_sc_hd__decap_8
XFILLER_0_0_417 VGND VGND VPWR VPWR sky130_fd_sc_hd__decap_3
X_10346_ clknet_leaf_15_clk _00203_ VGND VGND VPWR VPWR tanh_inst.divider.z_\[-18\]
+ sky130_fd_sc_hd__dfxtp_2
X_10277_ clknet_leaf_20_clk _00134_ VGND VGND VPWR VPWR tanh_inst.z_\[-18\] sky130_fd_sc_hd__dfxtp_2
XPHY_EDGE_ROW_76_Left_198 VGND VGND VPWR VPWR sky130_fd_sc_hd__decap_3
XFILLER_0_45_46 VGND VGND VPWR VPWR sky130_fd_sc_hd__decap_8
XTAP_TAPCELL_ROW_49_879 VGND VPWR sky130_fd_sc_hd__tapvpwrvgnd_1
XFILLER_0_0_15 VPWR VGND VPWR VGND sky130_ef_sc_hd__decap_12
XFILLER_0_88_589 VGND VGND VPWR VPWR sky130_fd_sc_hd__fill_1
X_06370_ tanh_inst.divider.y_\[7\] _01300_ VGND VGND VPWR VPWR _01301_ sky130_fd_sc_hd__or2_2
XFILLER_0_56_475 VGND VGND VPWR VPWR sky130_fd_sc_hd__fill_1
XFILLER_0_8_539 VGND VGND VPWR VPWR sky130_fd_sc_hd__decap_8
XFILLER_0_56_497 VPWR VGND VPWR VGND sky130_ef_sc_hd__decap_12
XFILLER_0_4_701 VGND VGND VPWR VPWR sky130_fd_sc_hd__fill_2
X_05321_ _04788_ mac_inst.i\[5\] VGND VGND VPWR VPWR _05020_ sky130_fd_sc_hd__and2_2
XFILLER_0_28_188 VGND VGND VPWR VPWR sky130_fd_sc_hd__fill_1
X_08040_ _02022_ _02489_ VGND VGND VPWR VPWR _02835_ sky130_fd_sc_hd__nand2_2
XFILLER_0_9_57 VPWR VGND VPWR VGND sky130_ef_sc_hd__decap_12
X_05252_ mac_inst.i\[19\] mac_inst.i\[18\] VGND VGND VPWR VPWR _04953_ sky130_fd_sc_hd__and2_2
XFILLER_0_43_158 VGND VGND VPWR VPWR sky130_fd_sc_hd__fill_1
XTAP_TAPCELL_ROW_116_1712 VGND VPWR sky130_fd_sc_hd__tapvpwrvgnd_1
XFILLER_0_43_169 VPWR VGND VPWR VGND sky130_ef_sc_hd__decap_12
X_05183_ mac_inst.x\[8\] _04852_ _04853_ VGND VGND VPWR VPWR _04887_ sky130_fd_sc_hd__a21o_2
X_09991_ _04705_ _04706_ VGND VGND VPWR VPWR _04707_ sky130_fd_sc_hd__xnor2_2
X_08942_ tanh_inst.divider.y\[-22\] _03684_ VGND VGND VPWR VPWR _03686_ sky130_fd_sc_hd__xor2_2
XFILLER_0_86_97 VGND VGND VPWR VPWR sky130_fd_sc_hd__decap_4
X_08873_ _03571_ _03616_ _03617_ VGND VGND VPWR VPWR _03618_ sky130_fd_sc_hd__and3_2
XFILLER_0_36_3 VPWR VGND VPWR VGND sky130_ef_sc_hd__decap_12
X_07824_ _02620_ _02621_ _02622_ tanh_inst.z_\[7\] VGND VGND VPWR VPWR _02624_ sky130_fd_sc_hd__o31ai_2
XFILLER_0_79_501 VGND VGND VPWR VPWR sky130_fd_sc_hd__decap_3
X_07755_ _02360_ _02363_ _02412_ _02556_ _02410_ VGND VGND VPWR VPWR _02557_ sky130_fd_sc_hd__a311oi_2
XFILLER_0_79_556 VGND VGND VPWR VPWR sky130_fd_sc_hd__decap_4
X_07686_ _02280_ _02282_ _02025_ VGND VGND VPWR VPWR _02489_ sky130_fd_sc_hd__mux2_1
X_06706_ _01601_ _01610_ VGND VGND VPWR VPWR _01611_ sky130_fd_sc_hd__nand2_2
X_09425_ _04156_ _04157_ _02014_ VGND VGND VPWR VPWR _04158_ sky130_fd_sc_hd__o21ai_2
X_06637_ tanh_inst.z_\[-21\] _01548_ VGND VGND VPWR VPWR _01549_ sky130_fd_sc_hd__and2_2
XFILLER_0_19_111 VGND VGND VPWR VPWR sky130_fd_sc_hd__fill_1
X_09356_ _04088_ _04089_ VGND VGND VPWR VPWR _04090_ sky130_fd_sc_hd__or2_2
XFILLER_0_81_209 VPWR VGND VPWR VGND sky130_ef_sc_hd__decap_12
X_06568_ _01474_ _01482_ tanh_inst.LOOKUP.index\[0\] VGND VGND VPWR VPWR _01483_ sky130_fd_sc_hd__a21o_2
XFILLER_0_47_442 VGND VGND VPWR VPWR sky130_fd_sc_hd__decap_6
XFILLER_0_117_330 VGND VGND VPWR VPWR sky130_fd_sc_hd__decap_6
X_09287_ _04766_ _04021_ VGND VGND VPWR VPWR _04023_ sky130_fd_sc_hd__xnor2_2
X_06499_ tanh_inst.divider.y\[2\] tanh_inst.div_en tanh_inst.divider.y_\[2\] _01092_
+ VGND VGND VPWR VPWR _01420_ sky130_fd_sc_hd__a22o_2
XFILLER_0_62_434 VPWR VGND VPWR VGND sky130_ef_sc_hd__decap_12
XFILLER_0_62_412 VGND VGND VPWR VPWR sky130_fd_sc_hd__decap_8
X_08307_ tanh_inst.divider.y\[-3\] tanh_inst.divider.x\[-3\] VGND VGND VPWR VPWR _03096_
+ sky130_fd_sc_hd__nor2_2
X_05519_ _00512_ _00514_ VGND VGND VPWR VPWR _00515_ sky130_fd_sc_hd__xor2_2
XFILLER_0_35_637 VGND VGND VPWR VPWR sky130_fd_sc_hd__decap_4
XFILLER_0_105_503 VGND VGND VPWR VPWR sky130_fd_sc_hd__fill_1
X_08238_ _02053_ _02344_ _02834_ VGND VGND VPWR VPWR _03028_ sky130_fd_sc_hd__o21a_2
XFILLER_0_62_467 VGND VGND VPWR VPWR sky130_fd_sc_hd__decap_8
XFILLER_0_50_607 VGND VGND VPWR VPWR sky130_fd_sc_hd__fill_1
XTAP_TAPCELL_ROW_78_1239 VGND VPWR sky130_fd_sc_hd__tapvpwrvgnd_1
XFILLER_0_15_361 VGND VGND VPWR VPWR sky130_fd_sc_hd__decap_8
XFILLER_0_22_309 VPWR VGND VPWR VGND sky130_ef_sc_hd__decap_12
XFILLER_0_50_629 VPWR VGND VPWR VGND sky130_ef_sc_hd__decap_12
X_10200_ x_in[26] _00000_ VGND VGND VPWR VPWR mac_inst.x\[26\] sky130_fd_sc_hd__dlxtn_1
X_08169_ _02933_ _02935_ _02958_ VGND VGND VPWR VPWR _02961_ sky130_fd_sc_hd__or3_2
XFILLER_0_30_342 VGND VGND VPWR VPWR sky130_fd_sc_hd__decap_8
X_10062_ rst VGND VGND VPWR VPWR _00081_ sky130_fd_sc_hd__inv_2
XFILLER_0_89_309 VGND VGND VPWR VPWR sky130_fd_sc_hd__fill_1
XTAP_TAPCELL_ROW_89_1379 VGND VPWR sky130_fd_sc_hd__tapvpwrvgnd_1
XFILLER_0_106_29 VPWR VGND VPWR VGND sky130_ef_sc_hd__decap_12
XFILLER_0_97_342 VPWR VGND VPWR VGND sky130_ef_sc_hd__decap_12
XFILLER_0_15_27 VPWR VGND VPWR VGND sky130_ef_sc_hd__decap_12
XTAP_TAPCELL_ROW_46_838 VGND VPWR sky130_fd_sc_hd__tapvpwrvgnd_1
XTAP_TAPCELL_ROW_100_1513 VGND VPWR sky130_fd_sc_hd__tapvpwrvgnd_1
XTAP_TAPCELL_ROW_26_584 VGND VPWR sky130_fd_sc_hd__tapvpwrvgnd_1
XFILLER_0_26_615 VGND VGND VPWR VPWR sky130_fd_sc_hd__decap_4
XFILLER_0_31_15 VPWR VGND VPWR VGND sky130_ef_sc_hd__decap_12
XFILLER_0_25_125 VGND VGND VPWR VPWR sky130_fd_sc_hd__decap_3
XFILLER_0_53_412 VGND VGND VPWR VPWR sky130_fd_sc_hd__decap_8
XFILLER_0_53_434 VGND VGND VPWR VPWR sky130_fd_sc_hd__fill_1
XFILLER_0_80_220 VGND VGND VPWR VPWR sky130_fd_sc_hd__decap_3
XFILLER_0_25_169 VGND VGND VPWR VPWR sky130_fd_sc_hd__decap_8
XFILLER_0_41_629 VGND VGND VPWR VPWR sky130_fd_sc_hd__decap_4
XPHY_EDGE_ROW_84_Left_206 VGND VGND VPWR VPWR sky130_fd_sc_hd__decap_3
XFILLER_0_0_225 VPWR VGND VPWR VGND sky130_ef_sc_hd__decap_12
X_10329_ clknet_leaf_18_clk _00186_ VGND VGND VPWR VPWR tanh_out[21] sky130_fd_sc_hd__dfxtp_2
XTAP_TAPCELL_ROW_111_1653 VGND VPWR sky130_fd_sc_hd__tapvpwrvgnd_1
X_05870_ _00830_ _00832_ VGND VGND VPWR VPWR _00835_ sky130_fd_sc_hd__nor2_2
X_07540_ tanh_inst.divider.x\[-20\] _02345_ VGND VGND VPWR VPWR _02346_ sky130_fd_sc_hd__and2_2
XFILLER_0_72_11 VGND VGND VPWR VPWR sky130_fd_sc_hd__fill_1
XPHY_EDGE_ROW_93_Left_215 VGND VGND VPWR VPWR sky130_fd_sc_hd__decap_3
X_07471_ _02025_ _02277_ _02022_ VGND VGND VPWR VPWR _02278_ sky130_fd_sc_hd__a21o_2
X_06422_ _01326_ _01338_ VGND VGND VPWR VPWR _01349_ sky130_fd_sc_hd__nor2_2
XFILLER_0_91_518 VGND VGND VPWR VPWR sky130_fd_sc_hd__decap_4
X_09210_ tanh_inst.divider.y\[-17\] _03947_ VGND VGND VPWR VPWR _03949_ sky130_fd_sc_hd__or2_2
XFILLER_0_63_209 VGND VGND VPWR VPWR sky130_fd_sc_hd__decap_6
X_06353_ _01255_ _01260_ _01273_ _01285_ VGND VGND VPWR VPWR _01286_ sky130_fd_sc_hd__a31o_2
X_09141_ tanh_inst.divider.x\[-19\] _03841_ _03840_ VGND VGND VPWR VPWR _03881_ sky130_fd_sc_hd__o21ai_2
XFILLER_0_44_401 VGND VGND VPWR VPWR sky130_fd_sc_hd__fill_1
X_09072_ _03574_ _03647_ tanh_inst.LOOKUP.index\[2\] VGND VGND VPWR VPWR _03814_ sky130_fd_sc_hd__mux2_1
X_05304_ _04783_ mac_inst.x\[1\] _04852_ _04853_ mac_inst.i\[1\] VGND VGND VPWR VPWR
+ _05004_ sky130_fd_sc_hd__a311o_2
XFILLER_0_44_445 VPWR VGND VPWR VGND sky130_ef_sc_hd__decap_12
X_06284_ _01220_ _01221_ VGND VGND VPWR VPWR _01222_ sky130_fd_sc_hd__and2b_2
XFILLER_0_112_83 VGND VGND VPWR VPWR sky130_fd_sc_hd__fill_1
X_08023_ _01477_ _02467_ VGND VGND VPWR VPWR _02819_ sky130_fd_sc_hd__or2_2
XFILLER_0_4_531 VGND VGND VPWR VPWR sky130_fd_sc_hd__fill_1
XFILLER_0_21_81 VPWR VGND VPWR VGND sky130_ef_sc_hd__decap_12
X_05235_ mac_inst.i\[2\] mac_inst.i\[0\] mac_inst.i\[1\] mac_inst.i\[3\] mac_inst.i\[4\]
+ VGND VGND VPWR VPWR _04936_ sky130_fd_sc_hd__o311a_2
XFILLER_0_25_681 VGND VGND VPWR VPWR sky130_fd_sc_hd__fill_2
X_05166_ mac_inst.x\[24\] _04852_ _04853_ VGND VGND VPWR VPWR _04870_ sky130_fd_sc_hd__a21o_2
XFILLER_0_97_85 VGND VGND VPWR VPWR sky130_fd_sc_hd__decap_4
XFILLER_0_110_572 VGND VGND VPWR VPWR sky130_fd_sc_hd__fill_2
XTAP_TAPCELL_ROW_73_1169 VGND VPWR sky130_fd_sc_hd__tapvpwrvgnd_1
X_09974_ _04650_ _04653_ _04689_ VGND VGND VPWR VPWR _04691_ sky130_fd_sc_hd__nor3_2
X_05097_ _04806_ _04814_ VGND VGND VPWR VPWR _00337_ sky130_fd_sc_hd__nor2_2
X_08925_ _03516_ _03525_ _03527_ _03518_ tanh_inst.LOOKUP.index\[1\] tanh_inst.LOOKUP.index\[0\]
+ VGND VGND VPWR VPWR _03669_ sky130_fd_sc_hd__mux4_2
X_08856_ tanh_inst.divider.x\[5\] _02028_ _03508_ _04761_ VGND VGND VPWR VPWR _03601_
+ sky130_fd_sc_hd__o211a_2
XFILLER_0_98_128 VGND VGND VPWR VPWR sky130_fd_sc_hd__decap_3
X_07807_ _02571_ _02574_ _02607_ VGND VGND VPWR VPWR _02608_ sky130_fd_sc_hd__and3_2
X_08787_ tanh_inst.divider.x\[-22\] tanh_inst.divider.x\[-21\] tanh_inst.LOOKUP.index\[0\]
+ VGND VGND VPWR VPWR _03533_ sky130_fd_sc_hd__mux2_1
X_05999_ _04789_ _00952_ VGND VGND VPWR VPWR _00953_ sky130_fd_sc_hd__nor2_2
X_07738_ _04767_ _02493_ _02492_ VGND VGND VPWR VPWR _02540_ sky130_fd_sc_hd__a21oi_2
XFILLER_0_94_301 VGND VGND VPWR VPWR sky130_fd_sc_hd__decap_6
XFILLER_0_67_559 VGND VGND VPWR VPWR sky130_fd_sc_hd__fill_1
X_07669_ _02471_ _02472_ tanh_inst.LOOKUP.index\[3\] VGND VGND VPWR VPWR _02473_ sky130_fd_sc_hd__mux2_1
X_09408_ _04103_ _04110_ _04139_ _04791_ VGND VGND VPWR VPWR _04141_ sky130_fd_sc_hd__a31o_2
XFILLER_0_109_105 VGND VGND VPWR VPWR sky130_fd_sc_hd__decap_6
X_09339_ _04028_ _04033_ _04072_ tanh_inst.z_\[7\] VGND VGND VPWR VPWR _04074_ sky130_fd_sc_hd__o31a_2
XFILLER_0_75_592 VGND VGND VPWR VPWR sky130_fd_sc_hd__decap_6
XTAP_TAPCELL_ROW_23_554 VGND VPWR sky130_fd_sc_hd__tapvpwrvgnd_1
XPHY_EDGE_ROW_109_Right_109 VGND VGND VPWR VPWR sky130_fd_sc_hd__decap_3
XFILLER_0_47_294 VPWR VGND VPWR VGND sky130_ef_sc_hd__decap_12
XTAP_TAPCELL_ROW_51_896 VGND VPWR sky130_fd_sc_hd__tapvpwrvgnd_1
XFILLER_0_90_584 VGND VGND VPWR VPWR sky130_fd_sc_hd__decap_4
XFILLER_0_62_253 VGND VGND VPWR VPWR sky130_fd_sc_hd__fill_2
XFILLER_0_22_139 VGND VGND VPWR VPWR sky130_fd_sc_hd__fill_1
XFILLER_0_31_673 VGND VGND VPWR VPWR sky130_fd_sc_hd__decap_6
X_10045_ tanh_inst.LOOKUP.index\[3\] _04753_ VGND VGND VPWR VPWR _04756_ sky130_fd_sc_hd__or2_2
XFILLER_0_26_15 VPWR VGND VPWR VGND sky130_ef_sc_hd__decap_12
XFILLER_0_117_39 VPWR VGND VPWR VGND sky130_ef_sc_hd__decap_12
XTAP_TAPCELL_ROW_59_996 VGND VPWR sky130_fd_sc_hd__tapvpwrvgnd_1
XFILLER_0_98_684 VGND VGND VPWR VPWR sky130_fd_sc_hd__decap_3
XFILLER_0_98_695 VGND VGND VPWR VPWR sky130_fd_sc_hd__decap_4
XFILLER_0_73_518 VGND VGND VPWR VPWR sky130_fd_sc_hd__fill_2
XFILLER_0_109_650 VGND VGND VPWR VPWR sky130_fd_sc_hd__decap_4
XFILLER_0_26_401 VGND VGND VPWR VPWR sky130_fd_sc_hd__fill_1
XFILLER_0_81_551 VGND VGND VPWR VPWR sky130_fd_sc_hd__decap_8
XFILLER_0_5_317 VPWR VGND VPWR VGND sky130_ef_sc_hd__decap_12
XFILLER_0_38_294 VGND VGND VPWR VPWR sky130_fd_sc_hd__fill_1
XFILLER_0_53_220 VGND VGND VPWR VPWR sky130_fd_sc_hd__decap_4
XFILLER_0_14_607 VGND VGND VPWR VPWR sky130_fd_sc_hd__fill_1
XFILLER_0_67_11 VGND VGND VPWR VPWR sky130_fd_sc_hd__fill_1
XFILLER_0_21_161 VGND VGND VPWR VPWR sky130_fd_sc_hd__decap_6
XFILLER_0_67_55 VGND VGND VPWR VPWR sky130_fd_sc_hd__fill_1
XFILLER_0_67_44 VGND VGND VPWR VPWR sky130_fd_sc_hd__decap_4
X_06971_ tanh_inst.divider.y_\[7\] _01809_ _01811_ VGND VGND VPWR VPWR _01812_ sky130_fd_sc_hd__a21o_2
X_05922_ _00868_ _00878_ mac_inst.z\[18\] VGND VGND VPWR VPWR _00883_ sky130_fd_sc_hd__o21ai_2
X_08710_ _04783_ _04983_ VGND VGND VPWR VPWR _00265_ sky130_fd_sc_hd__xnor2_2
X_09690_ _04388_ _04391_ _04413_ VGND VGND VPWR VPWR _04415_ sky130_fd_sc_hd__o21ai_2
X_08641_ _03358_ _03361_ _03420_ VGND VGND VPWR VPWR _03422_ sky130_fd_sc_hd__or3_2
X_05853_ _00817_ _00818_ VGND VGND VPWR VPWR _00819_ sky130_fd_sc_hd__nand2_2
XFILLER_0_83_87 VGND VGND VPWR VPWR sky130_fd_sc_hd__fill_1
XFILLER_0_83_65 VGND VGND VPWR VPWR sky130_fd_sc_hd__fill_2
XFILLER_0_89_673 VGND VGND VPWR VPWR sky130_fd_sc_hd__decap_6
XFILLER_0_88_161 VGND VGND VPWR VPWR sky130_fd_sc_hd__fill_2
X_05784_ _00752_ _00754_ VGND VGND VPWR VPWR _00755_ sky130_fd_sc_hd__nand2_2
X_08572_ _02019_ _03354_ VGND VGND VPWR VPWR _03355_ sky130_fd_sc_hd__nor2_2
XFILLER_0_49_515 VGND VGND VPWR VPWR sky130_fd_sc_hd__decap_6
XFILLER_0_88_172 VGND VGND VPWR VPWR sky130_fd_sc_hd__fill_1
X_07523_ _02263_ _02265_ _02262_ VGND VGND VPWR VPWR _02330_ sky130_fd_sc_hd__a21o_2
XFILLER_0_119_425 VGND VGND VPWR VPWR sky130_fd_sc_hd__decap_4
XFILLER_0_76_378 VGND VGND VPWR VPWR sky130_fd_sc_hd__decap_6
X_07454_ tanh_inst.divider.x\[-22\] _02261_ VGND VGND VPWR VPWR _02262_ sky130_fd_sc_hd__and2_2
XFILLER_0_9_623 VGND VGND VPWR VPWR sky130_fd_sc_hd__fill_2
X_06405_ _01320_ _01321_ VGND VGND VPWR VPWR _01333_ sky130_fd_sc_hd__nor2_2
XFILLER_0_8_133 VGND VGND VPWR VPWR sky130_fd_sc_hd__decap_6
X_07385_ _02113_ _02122_ tanh_inst.z_\[7\] VGND VGND VPWR VPWR _02194_ sky130_fd_sc_hd__a21o_2
XFILLER_0_8_177 VPWR VGND VPWR VGND sky130_ef_sc_hd__decap_12
XTAP_TAPCELL_ROW_20_513 VGND VPWR sky130_fd_sc_hd__tapvpwrvgnd_1
X_06336_ tanh_inst.divider.y_\[-11\] _01269_ VGND VGND VPWR VPWR _01270_ sky130_fd_sc_hd__nand2_2
X_09124_ _03850_ _03864_ VGND VGND VPWR VPWR _03865_ sky130_fd_sc_hd__xnor2_2
XFILLER_0_72_551 VGND VGND VPWR VPWR sky130_fd_sc_hd__decap_8
X_06267_ tanh_inst.divider.i\[4\] _01204_ _01205_ VGND VGND VPWR VPWR _01206_ sky130_fd_sc_hd__a21bo_2
X_09055_ _03796_ VGND VGND VPWR VPWR _03797_ sky130_fd_sc_hd__inv_2
X_08006_ _02800_ _02801_ VGND VGND VPWR VPWR _02802_ sky130_fd_sc_hd__nand2_2
XFILLER_0_13_651 VGND VGND VPWR VPWR sky130_fd_sc_hd__decap_4
X_05218_ mac_inst.i\[3\] _04782_ VGND VGND VPWR VPWR _04922_ sky130_fd_sc_hd__nor2_2
X_06198_ tanh_inst.divider.i\[2\] _01030_ VGND VGND VPWR VPWR _01141_ sky130_fd_sc_hd__nand2_2
X_05149_ _04841_ _04844_ _04850_ mac_inst.x\[31\] VGND VGND VPWR VPWR _04853_ sky130_fd_sc_hd__o31a_2
X_09957_ _04791_ _04673_ _04674_ _02018_ VGND VGND VPWR VPWR _04675_ sky130_fd_sc_hd__a31o_2
X_08908_ tanh_inst.divider.x\[6\] tanh_inst.divider.x\[7\] tanh_inst.LOOKUP.index\[0\]
+ VGND VGND VPWR VPWR _03653_ sky130_fd_sc_hd__mux2_1
X_09888_ _04591_ _04607_ tanh_inst.z_\[7\] VGND VGND VPWR VPWR _04608_ sky130_fd_sc_hd__mux2_1
X_08839_ tanh_inst.divider.y\[-23\] _02015_ VGND VGND VPWR VPWR _03584_ sky130_fd_sc_hd__nand2_2
XTAP_TAPCELL_ROW_28_613 VGND VPWR sky130_fd_sc_hd__tapvpwrvgnd_1
XTAP_TAPCELL_ROW_86_1338 VGND VPWR sky130_fd_sc_hd__tapvpwrvgnd_1
XTAP_TAPCELL_ROW_56_966 VGND VPWR sky130_fd_sc_hd__tapvpwrvgnd_1
XTAP_TAPCELL_ROW_0_260 VGND VPWR sky130_fd_sc_hd__tapvpwrvgnd_1
XFILLER_0_95_654 VGND VGND VPWR VPWR sky130_fd_sc_hd__fill_1
XFILLER_0_82_348 VPWR VGND VPWR VGND sky130_ef_sc_hd__decap_12
XFILLER_0_82_337 VGND VGND VPWR VPWR sky130_fd_sc_hd__fill_1
XFILLER_0_121_601 VPWR VGND VPWR VGND sky130_ef_sc_hd__decap_12
XFILLER_0_90_392 VGND VGND VPWR VPWR sky130_fd_sc_hd__decap_3
XFILLER_0_2_309 VPWR VGND VPWR VGND sky130_ef_sc_hd__decap_12
XTAP_TAPCELL_ROW_97_1478 VGND VPWR sky130_fd_sc_hd__tapvpwrvgnd_1
XFILLER_0_121_645 VPWR VGND VPWR VGND sky130_ef_sc_hd__decap_12
XFILLER_0_120_133 VGND VGND VPWR VPWR sky130_fd_sc_hd__decap_6
XFILLER_0_10_109 VPWR VGND VPWR VGND sky130_ef_sc_hd__decap_12
XFILLER_0_31_470 VGND VGND VPWR VPWR sky130_fd_sc_hd__decap_3
XFILLER_0_120_177 VPWR VGND VPWR VGND sky130_ef_sc_hd__decap_12
XFILLER_0_101_391 VGND VGND VPWR VPWR sky130_fd_sc_hd__fill_1
XTAP_TAPCELL_ROW_8_360 VGND VPWR sky130_fd_sc_hd__tapvpwrvgnd_1
X_10028_ _04709_ _04711_ _04708_ VGND VGND VPWR VPWR _04743_ sky130_fd_sc_hd__a21oi_2
XTAP_TAPCELL_ROW_106_1585 VGND VPWR sky130_fd_sc_hd__tapvpwrvgnd_1
XFILLER_0_58_389 VGND VGND VPWR VPWR sky130_fd_sc_hd__decap_4
XFILLER_0_18_209 VPWR VGND VPWR VGND sky130_ef_sc_hd__decap_12
XFILLER_0_73_359 VPWR VGND VPWR VGND sky130_ef_sc_hd__decap_12
XFILLER_0_73_337 VGND VGND VPWR VPWR sky130_fd_sc_hd__decap_4
X_07170_ _01979_ _01985_ _01987_ _01059_ VGND VGND VPWR VPWR _01989_ sky130_fd_sc_hd__a31o_2
XFILLER_0_6_637 VGND VGND VPWR VPWR sky130_fd_sc_hd__decap_6
XFILLER_0_5_125 VPWR VGND VPWR VGND sky130_ef_sc_hd__decap_12
XFILLER_0_26_242 VGND VGND VPWR VPWR sky130_fd_sc_hd__decap_8
XFILLER_0_26_253 VPWR VGND VPWR VGND sky130_ef_sc_hd__decap_12
X_06121_ tanh_inst.divider.x\[1\] tanh_inst.divider.x\[2\] tanh_inst.divider.i\[0\]
+ VGND VGND VPWR VPWR _01067_ sky130_fd_sc_hd__mux2_1
XFILLER_0_5_169 VPWR VGND VPWR VGND sky130_ef_sc_hd__decap_12
XFILLER_0_14_448 VGND VGND VPWR VPWR sky130_fd_sc_hd__decap_8
XFILLER_0_111_111 VGND VGND VPWR VPWR sky130_fd_sc_hd__fill_1
X_06052_ mac_inst.i\[2\] _00665_ _00716_ _00847_ VGND VGND VPWR VPWR _01002_ sky130_fd_sc_hd__or4_2
XFILLER_0_112_645 VGND VGND VPWR VPWR sky130_fd_sc_hd__fill_2
XFILLER_0_111_155 VGND VGND VPWR VPWR sky130_fd_sc_hd__fill_1
XFILLER_0_78_98 VGND VGND VPWR VPWR sky130_fd_sc_hd__fill_1
X_09811_ _04449_ _04474_ _04532_ _04475_ VGND VGND VPWR VPWR _04533_ sky130_fd_sc_hd__or4b_2
XTAP_TAPCELL_ROW_70_1139 VGND VPWR sky130_fd_sc_hd__tapvpwrvgnd_1
X_09742_ _04394_ _04414_ _04415_ VGND VGND VPWR VPWR _04466_ sky130_fd_sc_hd__o21a_2
X_06954_ _01787_ _01788_ _01786_ VGND VGND VPWR VPWR _01797_ sky130_fd_sc_hd__o21ai_2
X_06885_ tanh_inst.div_en _01764_ _01766_ VGND VGND VPWR VPWR _00161_ sky130_fd_sc_hd__nor3_2
XFILLER_0_94_97 VPWR VGND VPWR VGND sky130_ef_sc_hd__decap_12
X_09673_ _04322_ _04341_ _04397_ _04326_ _04343_ VGND VGND VPWR VPWR _04399_ sky130_fd_sc_hd__o221a_2
X_05905_ _00825_ _00838_ _00849_ _00865_ VGND VGND VPWR VPWR _00867_ sky130_fd_sc_hd__and4_2
X_08624_ _03382_ _03383_ _03380_ VGND VGND VPWR VPWR _03405_ sky130_fd_sc_hd__o21a_2
X_05836_ _00801_ _00802_ VGND VGND VPWR VPWR _00803_ sky130_fd_sc_hd__and2_2
X_05767_ _00737_ _00739_ VGND VGND VPWR VPWR _05767_/X sky130_fd_sc_hd__xor2_2
X_08555_ _03299_ _03301_ _03298_ VGND VGND VPWR VPWR _03338_ sky130_fd_sc_hd__a21oi_2
XTAP_TAPCELL_ROW_53_925 VGND VPWR sky130_fd_sc_hd__tapvpwrvgnd_1
X_07506_ tanh_inst.divider.y\[7\] tanh_inst.LOOKUP.index\[2\] VGND VGND VPWR VPWR
+ _02313_ sky130_fd_sc_hd__nand2b_2
XFILLER_0_92_613 VPWR VGND VPWR VGND sky130_ef_sc_hd__decap_12
XFILLER_0_64_315 VGND VGND VPWR VPWR sky130_fd_sc_hd__decap_6
XFILLER_0_9_420 VGND VGND VPWR VPWR sky130_fd_sc_hd__decap_4
X_05698_ _04783_ mac_inst.i\[1\] VGND VGND VPWR VPWR _00675_ sky130_fd_sc_hd__nand2_2
X_08486_ _03269_ _03270_ VGND VGND VPWR VPWR _03271_ sky130_fd_sc_hd__nand2_2
XTAP_TAPCELL_ROW_81_1279 VGND VPWR sky130_fd_sc_hd__tapvpwrvgnd_1
XFILLER_0_76_197 VGND VGND VPWR VPWR sky130_fd_sc_hd__fill_2
XTAP_TAPCELL_ROW_33_671 VGND VPWR sky130_fd_sc_hd__tapvpwrvgnd_1
X_07437_ tanh_inst.divider.y\[-6\] tanh_inst.divider.y\[-5\] tanh_inst.divider.y\[-4\]
+ tanh_inst.divider.y\[-3\] tanh_inst.LOOKUP.index\[0\] tanh_inst.LOOKUP.index\[1\]
+ VGND VGND VPWR VPWR _02245_ sky130_fd_sc_hd__mux4_2
XFILLER_0_91_178 VGND VGND VPWR VPWR sky130_fd_sc_hd__decap_4
X_07368_ tanh_inst.z_\[7\] _02163_ _02164_ _02176_ _02018_ VGND VGND VPWR VPWR _02177_
+ sky130_fd_sc_hd__a311o_2
X_06319_ tanh_inst.divider.y_\[-12\] _01252_ VGND VGND VPWR VPWR _01254_ sky130_fd_sc_hd__or2_2
X_09107_ tanh_inst.z_\[7\] _03839_ _03846_ _03847_ VGND VGND VPWR VPWR _03848_ sky130_fd_sc_hd__o22a_2
X_07299_ tanh_inst.LOOKUP.index\[2\] tanh_inst.LOOKUP.index\[1\] VGND VGND VPWR VPWR
+ _02109_ sky130_fd_sc_hd__nand2b_2
XFILLER_0_5_670 VGND VGND VPWR VPWR sky130_fd_sc_hd__fill_2
XFILLER_0_102_122 VPWR VGND VPWR VGND sky130_ef_sc_hd__decap_12
X_09038_ _01470_ _03780_ VGND VGND VPWR VPWR _00300_ sky130_fd_sc_hd__and2_2
XFILLER_0_102_177 VPWR VGND VPWR VGND sky130_ef_sc_hd__decap_12
XTAP_TAPCELL_ROW_5_330 VGND VPWR sky130_fd_sc_hd__tapvpwrvgnd_1
XFILLER_0_99_223 VGND VGND VPWR VPWR sky130_fd_sc_hd__fill_1
XFILLER_0_68_610 VPWR VGND VPWR VGND sky130_ef_sc_hd__decap_12
XFILLER_0_114_29 VPWR VGND VPWR VGND sky130_ef_sc_hd__decap_12
XFILLER_0_68_654 VGND VGND VPWR VPWR sky130_fd_sc_hd__decap_3
XFILLER_0_23_27 VPWR VGND VPWR VGND sky130_ef_sc_hd__decap_12
XFILLER_0_95_484 VGND VGND VPWR VPWR sky130_fd_sc_hd__fill_1
XFILLER_0_95_473 VGND VGND VPWR VPWR sky130_fd_sc_hd__fill_2
XFILLER_0_67_164 VGND VGND VPWR VPWR sky130_fd_sc_hd__decap_4
XFILLER_0_82_112 VGND VGND VPWR VPWR sky130_fd_sc_hd__decap_3
XFILLER_0_55_337 VGND VGND VPWR VPWR sky130_fd_sc_hd__fill_1
XFILLER_0_36_540 VGND VGND VPWR VPWR sky130_fd_sc_hd__decap_4
XFILLER_0_23_212 VPWR VGND VPWR VGND sky130_ef_sc_hd__decap_12
XTAP_TAPCELL_ROW_11_398 VGND VPWR sky130_fd_sc_hd__tapvpwrvgnd_1
XFILLER_0_3_629 VGND VGND VPWR VPWR sky130_fd_sc_hd__decap_8
XFILLER_0_2_139 VGND VGND VPWR VPWR sky130_fd_sc_hd__fill_1
XFILLER_0_3_15 VPWR VGND VPWR VGND sky130_ef_sc_hd__decap_12
XTAP_TAPCELL_ROW_108_1614 VGND VPWR sky130_fd_sc_hd__tapvpwrvgnd_1
X_06670_ _01578_ VGND VGND VPWR VPWR _01579_ sky130_fd_sc_hd__inv_2
X_05621_ _04911_ _00441_ VGND VGND VPWR VPWR _00607_ sky130_fd_sc_hd__and2_2
XTAP_TAPCELL_ROW_19_498 VGND VPWR sky130_fd_sc_hd__tapvpwrvgnd_1
X_08340_ _03124_ _03126_ VGND VGND VPWR VPWR _03128_ sky130_fd_sc_hd__nand2_2
X_05552_ mac_inst.y\[18\] _00543_ VGND VGND VPWR VPWR _00545_ sky130_fd_sc_hd__nor2_2
XFILLER_0_80_77 VGND VGND VPWR VPWR sky130_fd_sc_hd__decap_6
X_05483_ _00465_ _00466_ VGND VGND VPWR VPWR _00482_ sky130_fd_sc_hd__and2_2
X_08271_ _02978_ _02981_ _03005_ VGND VGND VPWR VPWR _03061_ sky130_fd_sc_hd__and3_2
X_07222_ tanh_inst.divider.y\[-10\] _02028_ _02029_ VGND VGND VPWR VPWR _02032_ sky130_fd_sc_hd__o21a_2
XFILLER_0_13_93 VPWR VGND VPWR VGND sky130_ef_sc_hd__decap_12
X_07153_ _01088_ _01973_ _01974_ _01092_ tanh_inst.divider.z_\[0\] VGND VGND VPWR
+ VPWR _00221_ sky130_fd_sc_hd__a32o_2
XTAP_TAPCELL_ROW_30_641 VGND VPWR sky130_fd_sc_hd__tapvpwrvgnd_1
XTAP_TAPCELL_ROW_119_1754 VGND VPWR sky130_fd_sc_hd__tapvpwrvgnd_1
X_06104_ tanh_inst.divider.y_\[-19\] tanh_inst.divider.y_\[-20\] tanh_inst.divider.y_\[-17\]
+ tanh_inst.divider.y_\[-18\] VGND VGND VPWR VPWR _01051_ sky130_fd_sc_hd__or4_2
XFILLER_0_14_245 VGND VGND VPWR VPWR sky130_fd_sc_hd__decap_6
XFILLER_0_120_83 VGND VGND VPWR VPWR sky130_fd_sc_hd__fill_1
X_07084_ _01903_ _01906_ _01912_ VGND VGND VPWR VPWR _01913_ sky130_fd_sc_hd__o21ai_2
XFILLER_0_14_289 VPWR VGND VPWR VGND sky130_ef_sc_hd__decap_12
XFILLER_0_112_475 VGND VGND VPWR VPWR sky130_fd_sc_hd__fill_1
XFILLER_0_100_604 VGND VGND VPWR VPWR sky130_fd_sc_hd__fill_1
XFILLER_0_66_3 VPWR VGND VPWR VGND sky130_ef_sc_hd__decap_12
XFILLER_0_1_161 VGND VGND VPWR VPWR sky130_fd_sc_hd__decap_6
X_06035_ _00772_ _00846_ _00971_ _00986_ VGND VGND VPWR VPWR _00987_ sky130_fd_sc_hd__a211o_2
XFILLER_0_10_484 VPWR VGND VPWR VGND sky130_ef_sc_hd__decap_12
X_07986_ _02740_ _02748_ _02781_ _02019_ VGND VGND VPWR VPWR _02783_ sky130_fd_sc_hd__a31o_2
X_06937_ tanh_inst.divider.z_\[-24\] _01773_ VGND VGND VPWR VPWR _01782_ sky130_fd_sc_hd__nor2_2
X_09725_ _03138_ _04447_ VGND VGND VPWR VPWR _04449_ sky130_fd_sc_hd__xnor2_2
XFILLER_0_69_407 VGND VGND VPWR VPWR sky130_fd_sc_hd__fill_1
X_09656_ _04246_ _04272_ _04381_ VGND VGND VPWR VPWR _04382_ sky130_fd_sc_hd__or3_2
X_06868_ _01745_ _01749_ _01744_ VGND VGND VPWR VPWR _01754_ sky130_fd_sc_hd__a21oi_2
X_08607_ _03375_ _03379_ _03387_ tanh_inst.z_\[7\] VGND VGND VPWR VPWR _03389_ sky130_fd_sc_hd__a31o_2
XTAP_TAPCELL_ROW_38_741 VGND VPWR sky130_fd_sc_hd__tapvpwrvgnd_1
X_06799_ _01662_ _01693_ _01692_ VGND VGND VPWR VPWR _01694_ sky130_fd_sc_hd__a21o_2
X_09587_ _04310_ _04312_ _04313_ _04791_ VGND VGND VPWR VPWR _04315_ sky130_fd_sc_hd__o31a_2
X_05819_ mac_inst.z\[31\] _00785_ _00783_ VGND VGND VPWR VPWR _00787_ sky130_fd_sc_hd__o21ai_2
XFILLER_0_65_624 VGND VGND VPWR VPWR sky130_fd_sc_hd__decap_6
X_08538_ _03317_ _03321_ VGND VGND VPWR VPWR _03322_ sky130_fd_sc_hd__xnor2_2
XFILLER_0_92_421 VGND VGND VPWR VPWR sky130_fd_sc_hd__decap_6
XFILLER_0_77_495 VGND VGND VPWR VPWR sky130_fd_sc_hd__decap_4
XFILLER_0_64_112 VGND VGND VPWR VPWR sky130_fd_sc_hd__decap_4
XFILLER_0_9_261 VPWR VGND VPWR VGND sky130_ef_sc_hd__decap_12
X_08469_ _03251_ _03253_ VGND VGND VPWR VPWR _03254_ sky130_fd_sc_hd__nand2_2
XFILLER_0_52_307 VGND VGND VPWR VPWR sky130_fd_sc_hd__fill_1
XFILLER_0_107_269 VGND VGND VPWR VPWR sky130_fd_sc_hd__decap_4
XFILLER_0_18_595 VGND VGND VPWR VPWR sky130_fd_sc_hd__fill_1
X_10431_ clknet_leaf_40_clk _00288_ _00000_ VGND VGND VPWR VPWR mac_inst.i\[23\] sky130_fd_sc_hd__dfrtp_2
X_10362_ clknet_leaf_17_clk _00219_ VGND VGND VPWR VPWR tanh_inst.divider.z_\[-2\]
+ sky130_fd_sc_hd__dfxtp_2
XTAP_TAPCELL_ROW_94_1437 VGND VPWR sky130_fd_sc_hd__tapvpwrvgnd_1
X_10293_ clknet_leaf_28_clk _00150_ VGND VGND VPWR VPWR tanh_inst.z_\[-2\] sky130_fd_sc_hd__dfxtp_2
XFILLER_0_18_27 VGND VGND VPWR VPWR sky130_fd_sc_hd__fill_1
XPHY_EDGE_ROW_16_Right_16 VGND VGND VPWR VPWR sky130_fd_sc_hd__decap_3
XFILLER_0_34_15 VPWR VGND VPWR VGND sky130_ef_sc_hd__decap_12
XTAP_TAPCELL_ROW_103_1544 VGND VPWR sky130_fd_sc_hd__tapvpwrvgnd_1
XFILLER_0_68_484 VGND VGND VPWR VPWR sky130_fd_sc_hd__decap_3
XTAP_TAPCELL_ROW_16_457 VGND VPWR sky130_fd_sc_hd__tapvpwrvgnd_1
XTAP_TAPCELL_ROW_103_1555 VGND VPWR sky130_fd_sc_hd__tapvpwrvgnd_1
XFILLER_0_95_281 VGND VGND VPWR VPWR sky130_fd_sc_hd__decap_4
XTAP_TAPCELL_ROW_16_468 VGND VPWR sky130_fd_sc_hd__tapvpwrvgnd_1
XFILLER_0_83_465 VPWR VGND VPWR VGND sky130_ef_sc_hd__decap_12
XFILLER_0_70_159 VGND VGND VPWR VPWR sky130_fd_sc_hd__fill_1
XFILLER_0_70_137 VGND VGND VPWR VPWR sky130_fd_sc_hd__decap_3
XPHY_EDGE_ROW_25_Right_25 VGND VGND VPWR VPWR sky130_fd_sc_hd__decap_3
XFILLER_0_106_280 VGND VGND VPWR VPWR sky130_fd_sc_hd__fill_1
XFILLER_0_24_565 VPWR VGND VPWR VGND sky130_ef_sc_hd__decap_12
XFILLER_0_11_237 VPWR VGND VPWR VGND sky130_ef_sc_hd__decap_12
XTAP_TAPCELL_ROW_114_1684 VGND VPWR sky130_fd_sc_hd__tapvpwrvgnd_1
X_07840_ _02623_ _02624_ _02639_ VGND VGND VPWR VPWR _02640_ sky130_fd_sc_hd__o21ai_2
X_07771_ _02564_ _02572_ VGND VGND VPWR VPWR _02573_ sky130_fd_sc_hd__nor2_2
X_09510_ _04090_ _04142_ _04143_ _04238_ VGND VGND VPWR VPWR _04240_ sky130_fd_sc_hd__and4b_2
XTAP_TAPCELL_ROW_69_1130 VGND VPWR sky130_fd_sc_hd__tapvpwrvgnd_1
XPHY_EDGE_ROW_34_Right_34 VGND VGND VPWR VPWR sky130_fd_sc_hd__decap_3
X_06722_ _01623_ _01624_ VGND VGND VPWR VPWR _01625_ sky130_fd_sc_hd__and2b_2
X_09441_ tanh_inst.divider.x\[7\] _03873_ _03874_ _03869_ _02023_ _02052_ VGND VGND
+ VPWR VPWR _04173_ sky130_fd_sc_hd__mux4_2
X_06653_ tanh_inst.z_\[7\] _01544_ _01546_ VGND VGND VPWR VPWR _01563_ sky130_fd_sc_hd__mux2_1
XTAP_TAPCELL_ROW_35_700 VGND VPWR sky130_fd_sc_hd__tapvpwrvgnd_1
X_09372_ _04029_ _04072_ VGND VGND VPWR VPWR _04106_ sky130_fd_sc_hd__and2_2
X_06584_ _01495_ _01496_ _01498_ VGND VGND VPWR VPWR _01499_ sky130_fd_sc_hd__or3_2
X_05604_ mac_inst.y\[23\] _00590_ VGND VGND VPWR VPWR _00592_ sky130_fd_sc_hd__xor2_2
XFILLER_0_74_421 VGND VGND VPWR VPWR sky130_fd_sc_hd__decap_8
XFILLER_0_19_337 VPWR VGND VPWR VGND sky130_ef_sc_hd__decap_12
X_08323_ tanh_inst.divider.x\[-3\] _03111_ VGND VGND VPWR VPWR _03112_ sky130_fd_sc_hd__or2_2
X_05535_ _00504_ _00506_ _00528_ _00529_ VGND VGND VPWR VPWR _00530_ sky130_fd_sc_hd__a31o_2
XFILLER_0_34_307 VGND VGND VPWR VPWR sky130_fd_sc_hd__fill_1
XFILLER_0_117_567 VGND VGND VPWR VPWR sky130_fd_sc_hd__fill_1
XFILLER_0_6_253 VPWR VGND VPWR VGND sky130_ef_sc_hd__decap_12
X_05466_ _00419_ _00420_ _00453_ _00454_ VGND VGND VPWR VPWR _00466_ sky130_fd_sc_hd__and4_2
XFILLER_0_34_318 VGND VGND VPWR VPWR sky130_fd_sc_hd__fill_1
X_08254_ _03037_ _03043_ VGND VGND VPWR VPWR _03044_ sky130_fd_sc_hd__nand2_2
XPHY_EDGE_ROW_43_Right_43 VGND VGND VPWR VPWR sky130_fd_sc_hd__decap_3
XFILLER_0_46_178 VPWR VGND VPWR VGND sky130_ef_sc_hd__decap_12
XPHY_EDGE_ROW_104_Left_226 VGND VGND VPWR VPWR sky130_fd_sc_hd__decap_3
X_07205_ tanh_inst.div_en _02014_ VGND VGND VPWR VPWR _02016_ sky130_fd_sc_hd__nand2_2
X_05397_ _04912_ _00401_ _05021_ VGND VGND VPWR VPWR _00402_ sky130_fd_sc_hd__o21a_2
X_08185_ _02954_ _02976_ VGND VGND VPWR VPWR _02977_ sky130_fd_sc_hd__nand2_2
X_07136_ tanh_inst.divider.y_\[7\] _01031_ _01830_ _01942_ VGND VGND VPWR VPWR _01959_
+ sky130_fd_sc_hd__o31a_2
XFILLER_0_42_362 VGND VGND VPWR VPWR sky130_fd_sc_hd__fill_2
X_07067_ _01893_ _01895_ tanh_inst.divider.z_\[-9\] VGND VGND VPWR VPWR _01898_ sky130_fd_sc_hd__a21o_2
X_06018_ _04795_ _04941_ _00970_ mac_inst.i\[30\] VGND VGND VPWR VPWR _00972_ sky130_fd_sc_hd__a22o_2
XFILLER_0_30_579 VGND VGND VPWR VPWR sky130_fd_sc_hd__decap_8
XPHY_EDGE_ROW_113_Left_235 VGND VGND VPWR VPWR sky130_fd_sc_hd__decap_3
XPHY_EDGE_ROW_52_Right_52 VGND VGND VPWR VPWR sky130_fd_sc_hd__decap_3
X_07969_ _02764_ _02765_ VGND VGND VPWR VPWR _02766_ sky130_fd_sc_hd__xnor2_2
X_09708_ _04368_ _04377_ _04431_ VGND VGND VPWR VPWR _04433_ sky130_fd_sc_hd__o21ai_2
X_09639_ _04791_ _04364_ VGND VGND VPWR VPWR _04365_ sky130_fd_sc_hd__nand2_2
XFILLER_0_84_229 VGND VGND VPWR VPWR sky130_fd_sc_hd__fill_1
XFILLER_0_38_602 VGND VGND VPWR VPWR sky130_fd_sc_hd__decap_4
XFILLER_0_108_501 VGND VGND VPWR VPWR sky130_fd_sc_hd__decap_8
XPHY_EDGE_ROW_61_Right_61 VGND VGND VPWR VPWR sky130_fd_sc_hd__decap_3
XTAP_TAPCELL_ROW_13_427 VGND VPWR sky130_fd_sc_hd__tapvpwrvgnd_1
XFILLER_0_37_156 VGND VGND VPWR VPWR sky130_fd_sc_hd__decap_4
XFILLER_0_80_413 VGND VGND VPWR VPWR sky130_fd_sc_hd__decap_6
XFILLER_0_18_370 VPWR VGND VPWR VGND sky130_ef_sc_hd__decap_12
XFILLER_0_25_329 VGND VGND VPWR VPWR sky130_fd_sc_hd__decap_6
XTAP_TAPCELL_ROW_41_769 VGND VPWR sky130_fd_sc_hd__tapvpwrvgnd_1
XFILLER_0_108_589 VGND VGND VPWR VPWR sky130_fd_sc_hd__decap_4
XFILLER_0_52_137 VGND VGND VPWR VPWR sky130_fd_sc_hd__decap_3
X_10414_ clknet_leaf_36_clk _00271_ _00000_ VGND VGND VPWR VPWR mac_inst.i\[6\] sky130_fd_sc_hd__dfrtp_2
XFILLER_0_21_535 VGND VGND VPWR VPWR sky130_fd_sc_hd__decap_6
X_10345_ clknet_leaf_15_clk _00202_ VGND VGND VPWR VPWR tanh_inst.divider.z_\[-19\]
+ sky130_fd_sc_hd__dfxtp_2
XFILLER_0_0_429 VPWR VGND VPWR VGND sky130_ef_sc_hd__decap_12
XFILLER_0_21_568 VPWR VGND VPWR VGND sky130_ef_sc_hd__decap_12
XFILLER_0_29_15 VPWR VGND VPWR VGND sky130_ef_sc_hd__decap_12
X_10276_ clknet_leaf_20_clk _00133_ VGND VGND VPWR VPWR tanh_inst.z_\[-19\] sky130_fd_sc_hd__dfxtp_2
XPHY_EDGE_ROW_70_Right_70 VGND VGND VPWR VPWR sky130_fd_sc_hd__decap_3
XTAP_TAPCELL_ROW_49_869 VGND VPWR sky130_fd_sc_hd__tapvpwrvgnd_1
XFILLER_0_0_27 VGND VGND VPWR VPWR sky130_fd_sc_hd__fill_1
XFILLER_0_29_613 VGND VGND VPWR VPWR sky130_fd_sc_hd__decap_3
XFILLER_0_118_309 VGND VGND VPWR VPWR sky130_fd_sc_hd__fill_2
XTAP_TAPCELL_ROW_64_1060 VGND VPWR sky130_fd_sc_hd__tapvpwrvgnd_1
XFILLER_0_61_57 VGND VGND VPWR VPWR sky130_fd_sc_hd__decap_4
XFILLER_0_56_432 VGND VGND VPWR VPWR sky130_fd_sc_hd__fill_2
XFILLER_0_56_421 VGND VGND VPWR VPWR sky130_fd_sc_hd__decap_3
XFILLER_0_8_507 VGND VGND VPWR VPWR sky130_fd_sc_hd__fill_2
XFILLER_0_29_635 VGND VGND VPWR VPWR sky130_fd_sc_hd__fill_1
XFILLER_0_56_443 VGND VGND VPWR VPWR sky130_fd_sc_hd__fill_1
XFILLER_0_16_307 VGND VGND VPWR VPWR sky130_fd_sc_hd__fill_1
X_05320_ _05015_ _05018_ _04781_ VGND VGND VPWR VPWR _05019_ sky130_fd_sc_hd__mux2_1
XFILLER_0_29_679 VGND VGND VPWR VPWR sky130_fd_sc_hd__fill_1
XFILLER_0_43_126 VGND VGND VPWR VPWR sky130_fd_sc_hd__fill_2
XFILLER_0_44_627 VGND VGND VPWR VPWR sky130_fd_sc_hd__fill_1
XFILLER_0_71_457 VPWR VGND VPWR VGND sky130_ef_sc_hd__decap_12
XFILLER_0_71_446 VGND VGND VPWR VPWR sky130_fd_sc_hd__fill_2
XFILLER_0_9_69 VPWR VGND VPWR VGND sky130_ef_sc_hd__decap_12
X_05251_ mac_inst.i\[17\] mac_inst.i\[16\] _04840_ _04938_ VGND VGND VPWR VPWR _04952_
+ sky130_fd_sc_hd__or4_2
XTAP_TAPCELL_ROW_116_1713 VGND VPWR sky130_fd_sc_hd__tapvpwrvgnd_1
XFILLER_0_71_479 VPWR VGND VPWR VGND sky130_ef_sc_hd__decap_12
XFILLER_0_3_223 VGND VGND VPWR VPWR sky130_fd_sc_hd__fill_1
X_05182_ mac_inst.x\[8\] _04852_ _04853_ VGND VGND VPWR VPWR _04886_ sky130_fd_sc_hd__a21oi_2
XFILLER_0_101_209 VGND VGND VPWR VPWR sky130_fd_sc_hd__decap_4
XFILLER_0_10_83 VGND VGND VPWR VPWR sky130_fd_sc_hd__fill_1
X_09990_ _04791_ _04696_ _04697_ VGND VGND VPWR VPWR _04706_ sky130_fd_sc_hd__a21oi_2
X_08941_ tanh_inst.divider.y\[-22\] _03684_ VGND VGND VPWR VPWR _03685_ sky130_fd_sc_hd__and2_2
X_08872_ _03614_ _03615_ tanh_inst.divider.x\[-23\] VGND VGND VPWR VPWR _03617_ sky130_fd_sc_hd__o21ai_2
XFILLER_0_86_76 VGND VGND VPWR VPWR sky130_fd_sc_hd__decap_8
X_07823_ _02621_ _02622_ _02620_ VGND VGND VPWR VPWR _02623_ sky130_fd_sc_hd__o21a_2
XFILLER_0_19_81 VPWR VGND VPWR VGND sky130_ef_sc_hd__decap_12
X_07754_ _02462_ _02507_ VGND VGND VPWR VPWR _02556_ sky130_fd_sc_hd__or2_2
XFILLER_0_29_3 VPWR VGND VPWR VGND sky130_ef_sc_hd__decap_12
X_06705_ _01594_ _01595_ _01600_ _01591_ VGND VGND VPWR VPWR _01610_ sky130_fd_sc_hd__a211o_2
X_07685_ _04762_ _02022_ VGND VGND VPWR VPWR _02488_ sky130_fd_sc_hd__nand2_2
XFILLER_0_94_505 VGND VGND VPWR VPWR sky130_fd_sc_hd__fill_1
X_09424_ _04120_ _04127_ _04155_ _02019_ VGND VGND VPWR VPWR _04157_ sky130_fd_sc_hd__a31o_2
X_06636_ _01543_ _01547_ VGND VGND VPWR VPWR _01548_ sky130_fd_sc_hd__xnor2_2
XFILLER_0_59_281 VPWR VGND VPWR VGND sky130_ef_sc_hd__decap_12
XFILLER_0_47_410 VGND VGND VPWR VPWR sky130_fd_sc_hd__decap_3
X_09355_ _02721_ _04087_ VGND VGND VPWR VPWR _04089_ sky130_fd_sc_hd__and2_2
X_06567_ tanh_inst.LOOKUP.index\[4\] tanh_inst.LOOKUP.index\[3\] tanh_inst.LOOKUP.index\[2\]
+ tanh_inst.LOOKUP.index\[1\] VGND VGND VPWR VPWR _01482_ sky130_fd_sc_hd__or4_2
XFILLER_0_117_353 VGND VGND VPWR VPWR sky130_fd_sc_hd__fill_1
XFILLER_0_117_342 VGND VGND VPWR VPWR sky130_fd_sc_hd__decap_4
X_09286_ _04766_ _04021_ VGND VGND VPWR VPWR _04022_ sky130_fd_sc_hd__nor2_2
X_06498_ _01416_ _01417_ _01415_ VGND VGND VPWR VPWR _01419_ sky130_fd_sc_hd__o21ai_2
XFILLER_0_19_167 VGND VGND VPWR VPWR sky130_fd_sc_hd__fill_1
X_05518_ _00465_ _00466_ _00513_ mac_inst.z\[31\] VGND VGND VPWR VPWR _00514_ sky130_fd_sc_hd__a31o_2
X_08306_ _03093_ _03094_ VGND VGND VPWR VPWR _03095_ sky130_fd_sc_hd__xnor2_2
XFILLER_0_74_295 VGND VGND VPWR VPWR sky130_fd_sc_hd__fill_2
XFILLER_0_62_446 VPWR VGND VPWR VGND sky130_ef_sc_hd__decap_12
X_05449_ _04781_ _05024_ VGND VGND VPWR VPWR _00450_ sky130_fd_sc_hd__nand2_2
XFILLER_0_34_126 VGND VGND VPWR VPWR sky130_fd_sc_hd__decap_3
XFILLER_0_34_137 VGND VGND VPWR VPWR sky130_fd_sc_hd__decap_3
XFILLER_0_34_148 VPWR VGND VPWR VGND sky130_ef_sc_hd__decap_12
X_08237_ tanh_inst.divider.x\[-5\] _02014_ _03027_ _01470_ VGND VGND VPWR VPWR _00252_
+ sky130_fd_sc_hd__o211a_2
XFILLER_0_105_559 VGND VGND VPWR VPWR sky130_fd_sc_hd__fill_1
X_08168_ _02959_ VGND VGND VPWR VPWR _02960_ sky130_fd_sc_hd__inv_2
X_07119_ _01943_ VGND VGND VPWR VPWR _01944_ sky130_fd_sc_hd__inv_2
X_08099_ _02868_ _02892_ VGND VGND VPWR VPWR _02893_ sky130_fd_sc_hd__nand2b_2
XFILLER_0_30_398 VPWR VGND VPWR VGND sky130_ef_sc_hd__decap_12
X_10061_ rst VGND VGND VPWR VPWR _00080_ sky130_fd_sc_hd__inv_2
XTAP_TAPCELL_ROW_89_1369 VGND VPWR sky130_fd_sc_hd__tapvpwrvgnd_1
XFILLER_0_15_39 VPWR VGND VPWR VGND sky130_ef_sc_hd__decap_12
XTAP_TAPCELL_ROW_46_839 VGND VPWR sky130_fd_sc_hd__tapvpwrvgnd_1
XFILLER_0_97_354 VPWR VGND VPWR VGND sky130_ef_sc_hd__decap_12
XFILLER_0_85_505 VGND VGND VPWR VPWR sky130_fd_sc_hd__decap_4
XFILLER_0_57_207 VPWR VGND VPWR VGND sky130_ef_sc_hd__decap_12
XFILLER_0_38_421 VPWR VGND VPWR VGND sky130_ef_sc_hd__decap_12
XTAP_TAPCELL_ROW_100_1514 VGND VPWR sky130_fd_sc_hd__tapvpwrvgnd_1
XTAP_TAPCELL_ROW_26_585 VGND VPWR sky130_fd_sc_hd__tapvpwrvgnd_1
XFILLER_0_31_27 VGND VGND VPWR VPWR sky130_fd_sc_hd__decap_6
XFILLER_0_65_295 VGND VGND VPWR VPWR sky130_fd_sc_hd__decap_8
XFILLER_0_26_649 VGND VGND VPWR VPWR sky130_fd_sc_hd__fill_1
XFILLER_0_41_608 VGND VGND VPWR VPWR sky130_fd_sc_hd__decap_8
XFILLER_0_34_660 VPWR VGND VPWR VGND sky130_ef_sc_hd__decap_12
XFILLER_0_40_107 VGND VGND VPWR VPWR sky130_fd_sc_hd__decap_6
XFILLER_0_34_693 VGND VGND VPWR VPWR sky130_fd_sc_hd__decap_6
XFILLER_0_0_237 VPWR VGND VPWR VGND sky130_ef_sc_hd__decap_12
X_10328_ clknet_leaf_18_clk _00185_ VGND VGND VPWR VPWR tanh_out[20] sky130_fd_sc_hd__dfxtp_2
XFILLER_0_21_387 VGND VGND VPWR VPWR sky130_fd_sc_hd__decap_4
XTAP_TAPCELL_ROW_111_1654 VGND VPWR sky130_fd_sc_hd__tapvpwrvgnd_1
XFILLER_0_56_46 VGND VGND VPWR VPWR sky130_fd_sc_hd__fill_1
X_10259_ clknet_leaf_32_clk mac_inst.x\[21\] _00000_ VGND VGND VPWR VPWR mac_x_out[21]
+ sky130_fd_sc_hd__dfrtp_2
XFILLER_0_88_321 VGND VGND VPWR VPWR sky130_fd_sc_hd__decap_4
XFILLER_0_72_23 VGND VGND VPWR VPWR sky130_fd_sc_hd__decap_4
XFILLER_0_88_376 VGND VGND VPWR VPWR sky130_fd_sc_hd__fill_1
X_07470_ _02146_ _02151_ _02026_ VGND VGND VPWR VPWR _02277_ sky130_fd_sc_hd__mux2_1
X_06421_ _01345_ _01347_ VGND VGND VPWR VPWR _01348_ sky130_fd_sc_hd__nor2_2
X_06352_ _01253_ _01270_ _01271_ VGND VGND VPWR VPWR _01285_ sky130_fd_sc_hd__a21oi_2
XFILLER_0_118_139 VGND VGND VPWR VPWR sky130_fd_sc_hd__fill_1
X_09140_ tanh_inst.divider.x\[-18\] _03878_ VGND VGND VPWR VPWR _03880_ sky130_fd_sc_hd__xor2_2
X_06283_ tanh_inst.divider.y_\[-15\] _01219_ VGND VGND VPWR VPWR _01221_ sky130_fd_sc_hd__nand2_2
XFILLER_0_114_301 VGND VGND VPWR VPWR sky130_fd_sc_hd__decap_6
X_09071_ _01486_ _03573_ _03578_ _01480_ VGND VGND VPWR VPWR _03813_ sky130_fd_sc_hd__o22a_2
X_05303_ _05001_ _05002_ _04789_ VGND VGND VPWR VPWR _05003_ sky130_fd_sc_hd__a21o_2
XFILLER_0_44_457 VPWR VGND VPWR VGND sky130_ef_sc_hd__decap_12
X_08022_ tanh_inst.LOOKUP.index\[3\] _02472_ _02509_ VGND VGND VPWR VPWR _02818_ sky130_fd_sc_hd__o21a_2
XFILLER_0_12_321 VPWR VGND VPWR VGND sky130_ef_sc_hd__decap_12
X_05234_ _04781_ _04933_ VGND VGND VPWR VPWR _04935_ sky130_fd_sc_hd__nor2_2
XFILLER_0_21_93 VPWR VGND VPWR VGND sky130_ef_sc_hd__decap_12
XFILLER_0_31_129 VGND VGND VPWR VPWR sky130_fd_sc_hd__fill_1
X_05165_ mac_inst.x\[25\] _04852_ _04853_ VGND VGND VPWR VPWR _04869_ sky130_fd_sc_hd__a21o_2
XFILLER_0_40_641 VGND VGND VPWR VPWR sky130_fd_sc_hd__decap_3
XFILLER_0_97_75 VGND VGND VPWR VPWR sky130_fd_sc_hd__fill_1
X_09973_ _04650_ _04653_ _04689_ VGND VGND VPWR VPWR _04690_ sky130_fd_sc_hd__o21a_2
XFILLER_0_12_365 VPWR VGND VPWR VGND sky130_ef_sc_hd__decap_12
X_05096_ tanh_counter\[3\] _04805_ _00000_ VGND VGND VPWR VPWR _04814_ sky130_fd_sc_hd__o21ai_2
X_08924_ _03666_ _03667_ _02025_ VGND VGND VPWR VPWR _03668_ sky130_fd_sc_hd__mux2_1
X_08855_ _04769_ _02027_ VGND VGND VPWR VPWR _03600_ sky130_fd_sc_hd__nand2_2
X_08786_ _03524_ _03529_ _03531_ _03526_ tanh_inst.LOOKUP.index\[0\] tanh_inst.LOOKUP.index\[1\]
+ VGND VGND VPWR VPWR _03532_ sky130_fd_sc_hd__mux4_2
X_07806_ _02605_ _02606_ VGND VGND VPWR VPWR _02607_ sky130_fd_sc_hd__nand2_2
XPHY_EDGE_ROW_2_Right_2 VGND VGND VPWR VPWR sky130_fd_sc_hd__decap_3
X_07737_ _02537_ _02538_ VGND VGND VPWR VPWR _02539_ sky130_fd_sc_hd__nor2_2
X_05998_ mac_inst.i\[0\] _04983_ VGND VGND VPWR VPWR _00952_ sky130_fd_sc_hd__nand2_2
XFILLER_0_79_354 VPWR VGND VPWR VGND sky130_ef_sc_hd__decap_12
XFILLER_0_67_505 VPWR VGND VPWR VGND sky130_ef_sc_hd__decap_12
XFILLER_0_1_81 VPWR VGND VPWR VGND sky130_ef_sc_hd__decap_12
X_07668_ tanh_inst.LOOKUP.index\[2\] _02248_ _02313_ VGND VGND VPWR VPWR _02472_ sky130_fd_sc_hd__o21a_2
X_09407_ _04103_ _04110_ _04139_ VGND VGND VPWR VPWR _04140_ sky130_fd_sc_hd__a21oi_2
X_07599_ _02357_ _02358_ _02355_ VGND VGND VPWR VPWR _02404_ sky130_fd_sc_hd__o21a_2
X_06619_ _01530_ _01531_ _01477_ VGND VGND VPWR VPWR _01532_ sky130_fd_sc_hd__and3b_2
X_09338_ _04028_ _04033_ _04072_ VGND VGND VPWR VPWR _04073_ sky130_fd_sc_hd__o21ai_2
XTAP_TAPCELL_ROW_23_544 VGND VPWR sky130_fd_sc_hd__tapvpwrvgnd_1
XTAP_TAPCELL_ROW_23_555 VGND VPWR sky130_fd_sc_hd__tapvpwrvgnd_1
XFILLER_0_117_161 VGND VGND VPWR VPWR sky130_fd_sc_hd__decap_6
XFILLER_0_62_210 VGND VGND VPWR VPWR sky130_fd_sc_hd__fill_1
XFILLER_0_35_435 VPWR VGND VPWR VGND sky130_ef_sc_hd__decap_12
XTAP_TAPCELL_ROW_51_897 VGND VPWR sky130_fd_sc_hd__tapvpwrvgnd_1
XFILLER_0_62_276 VPWR VGND VPWR VGND sky130_ef_sc_hd__decap_12
XFILLER_0_7_381 VGND VGND VPWR VPWR sky130_fd_sc_hd__decap_4
X_09269_ tanh_inst.LOOKUP.index\[3\] _03636_ _03938_ VGND VGND VPWR VPWR _04006_ sky130_fd_sc_hd__o21ai_2
XFILLER_0_105_367 VGND VGND VPWR VPWR sky130_fd_sc_hd__fill_2
XFILLER_0_15_181 VPWR VGND VPWR VGND sky130_ef_sc_hd__decap_12
X_10044_ tanh_inst.LOOKUP.index\[3\] _04753_ VGND VGND VPWR VPWR _04755_ sky130_fd_sc_hd__nand2_2
XFILLER_0_89_107 VGND VGND VPWR VPWR sky130_fd_sc_hd__decap_4
XFILLER_0_26_27 VGND VGND VPWR VPWR sky130_fd_sc_hd__fill_1
XFILLER_0_98_652 VGND VGND VPWR VPWR sky130_fd_sc_hd__decap_8
XFILLER_0_98_641 VGND VGND VPWR VPWR sky130_fd_sc_hd__decap_3
XTAP_TAPCELL_ROW_59_997 VGND VPWR sky130_fd_sc_hd__tapvpwrvgnd_1
XFILLER_0_42_15 VGND VGND VPWR VPWR sky130_fd_sc_hd__fill_2
XTAP_TAPCELL_ROW_61_1030 VGND VPWR sky130_fd_sc_hd__tapvpwrvgnd_1
XFILLER_0_109_662 VGND VGND VPWR VPWR sky130_fd_sc_hd__decap_8
XFILLER_0_108_161 VGND VGND VPWR VPWR sky130_fd_sc_hd__decap_3
XFILLER_0_5_329 VGND VGND VPWR VPWR sky130_fd_sc_hd__decap_6
XFILLER_0_53_210 VGND VGND VPWR VPWR sky130_fd_sc_hd__decap_3
XFILLER_0_109_695 VGND VGND VPWR VPWR sky130_fd_sc_hd__decap_4
XFILLER_0_41_449 VGND VGND VPWR VPWR sky130_fd_sc_hd__decap_8
XFILLER_0_6_15 VPWR VGND VPWR VGND sky130_ef_sc_hd__decap_12
XFILLER_0_111_337 VGND VGND VPWR VPWR sky130_fd_sc_hd__decap_3
X_06970_ _01792_ _01810_ VGND VGND VPWR VPWR _01811_ sky130_fd_sc_hd__and2_2
XFILLER_0_67_89 VGND VGND VPWR VPWR sky130_fd_sc_hd__decap_3
X_05921_ mac_inst.z\[18\] _00881_ VGND VGND VPWR VPWR _00882_ sky130_fd_sc_hd__nor2_2
X_08640_ _03358_ _03361_ _03420_ VGND VGND VPWR VPWR _03421_ sky130_fd_sc_hd__o21a_2
X_05852_ _00786_ _00814_ mac_inst.z\[13\] VGND VGND VPWR VPWR _00818_ sky130_fd_sc_hd__o21ai_2
XFILLER_0_107_51 VGND VGND VPWR VPWR sky130_fd_sc_hd__decap_4
X_05783_ mac_inst.z\[8\] _00751_ VGND VGND VPWR VPWR _00754_ sky130_fd_sc_hd__nand2_2
X_08571_ _03286_ _03294_ _03351_ _03352_ VGND VGND VPWR VPWR _03354_ sky130_fd_sc_hd__o211a_2
X_07522_ _02328_ VGND VGND VPWR VPWR _02329_ sky130_fd_sc_hd__inv_2
XFILLER_0_76_346 VPWR VGND VPWR VGND sky130_ef_sc_hd__decap_12
X_07453_ _02259_ _02260_ VGND VGND VPWR VPWR _02261_ sky130_fd_sc_hd__xnor2_2
X_06404_ tanh_inst.divider.i\[4\] _01121_ _01289_ VGND VGND VPWR VPWR _01332_ sky130_fd_sc_hd__o21ai_2
XFILLER_0_57_571 VGND VGND VPWR VPWR sky130_fd_sc_hd__decap_4
XFILLER_0_45_711 VGND VGND VPWR VPWR sky130_fd_sc_hd__fill_1
XFILLER_0_106_109 VPWR VGND VPWR VGND sky130_ef_sc_hd__decap_12
X_09123_ _03862_ _03863_ VGND VGND VPWR VPWR _03864_ sky130_fd_sc_hd__nor2_2
X_07384_ _04757_ _02185_ _02188_ _02192_ VGND VGND VPWR VPWR _02193_ sky130_fd_sc_hd__o211ai_2
XFILLER_0_17_446 VGND VGND VPWR VPWR sky130_fd_sc_hd__fill_2
XTAP_TAPCELL_ROW_20_514 VGND VPWR sky130_fd_sc_hd__tapvpwrvgnd_1
XFILLER_0_32_81 VGND VGND VPWR VPWR sky130_fd_sc_hd__decap_3
X_06335_ _01266_ _01268_ VGND VGND VPWR VPWR _01269_ sky130_fd_sc_hd__xnor2_2
XFILLER_0_115_632 VGND VGND VPWR VPWR sky130_fd_sc_hd__decap_4
XFILLER_0_96_3 VPWR VGND VPWR VGND sky130_ef_sc_hd__decap_12
XFILLER_0_8_189 VGND VGND VPWR VPWR sky130_fd_sc_hd__decap_6
XFILLER_0_44_243 VGND VGND VPWR VPWR sky130_fd_sc_hd__decap_4
XFILLER_0_115_654 VGND VGND VPWR VPWR sky130_fd_sc_hd__decap_4
X_06266_ _01021_ _01039_ _01042_ _01031_ VGND VGND VPWR VPWR _01205_ sky130_fd_sc_hd__o22a_2
X_09054_ _03793_ _03794_ VGND VGND VPWR VPWR _03796_ sky130_fd_sc_hd__xor2_2
X_08005_ tanh_inst.divider.y\[-10\] tanh_inst.divider.x\[-10\] VGND VGND VPWR VPWR
+ _02801_ sky130_fd_sc_hd__nand2_2
X_05217_ _04913_ _04915_ _04917_ _04919_ mac_inst.i\[0\] mac_inst.i\[1\] VGND VGND
+ VPWR VPWR _04921_ sky130_fd_sc_hd__mux4_2
XFILLER_0_114_197 VGND VGND VPWR VPWR sky130_fd_sc_hd__fill_2
X_06197_ _01138_ _01139_ tanh_inst.divider.i\[3\] VGND VGND VPWR VPWR _01140_ sky130_fd_sc_hd__mux2_1
XFILLER_0_12_195 VGND VGND VPWR VPWR sky130_fd_sc_hd__fill_1
X_05148_ _04841_ _04844_ _04850_ VGND VGND VPWR VPWR _04852_ sky130_fd_sc_hd__nor3_2
X_09956_ _04669_ _04672_ VGND VGND VPWR VPWR _04674_ sky130_fd_sc_hd__or2_2
X_05079_ mac_inst.z\[22\] VGND VGND VPWR VPWR _04803_ sky130_fd_sc_hd__inv_2
X_09887_ _04601_ _04605_ VGND VGND VPWR VPWR _04607_ sky130_fd_sc_hd__xor2_2
X_08907_ tanh_inst.divider.x\[4\] tanh_inst.divider.x\[5\] tanh_inst.LOOKUP.index\[0\]
+ VGND VGND VPWR VPWR _03652_ sky130_fd_sc_hd__mux2_1
XFILLER_0_99_427 VPWR VGND VPWR VGND sky130_ef_sc_hd__decap_12
XFILLER_0_99_405 VPWR VGND VPWR VGND sky130_ef_sc_hd__decap_12
X_08838_ _01469_ _03583_ VGND VGND VPWR VPWR _00297_ sky130_fd_sc_hd__nor2_2
XTAP_TAPCELL_ROW_28_614 VGND VPWR sky130_fd_sc_hd__tapvpwrvgnd_1
X_08769_ tanh_inst.divider.x\[-16\] _02028_ _03508_ VGND VGND VPWR VPWR _03515_ sky130_fd_sc_hd__o21a_2
XTAP_TAPCELL_ROW_86_1339 VGND VPWR sky130_fd_sc_hd__tapvpwrvgnd_1
XTAP_TAPCELL_ROW_56_956 VGND VPWR sky130_fd_sc_hd__tapvpwrvgnd_1
Xclkbuf_leaf_37_clk clknet_2_1__leaf_clk VGND VGND VPWR VPWR clknet_leaf_37_clk sky130_fd_sc_hd__clkbuf_8
XFILLER_0_95_633 VPWR VGND VPWR VGND sky130_ef_sc_hd__decap_12
XTAP_TAPCELL_ROW_56_967 VGND VPWR sky130_fd_sc_hd__tapvpwrvgnd_1
XTAP_TAPCELL_ROW_0_250 VGND VPWR sky130_fd_sc_hd__tapvpwrvgnd_1
XTAP_TAPCELL_ROW_0_261 VGND VPWR sky130_fd_sc_hd__tapvpwrvgnd_1
XFILLER_0_63_541 VGND VGND VPWR VPWR sky130_fd_sc_hd__fill_2
XFILLER_0_12_29 VPWR VGND VPWR VGND sky130_ef_sc_hd__decap_12
XFILLER_0_35_221 VGND VGND VPWR VPWR sky130_fd_sc_hd__decap_3
XFILLER_0_106_632 VGND VGND VPWR VPWR sky130_fd_sc_hd__decap_6
XFILLER_0_8_690 VGND VGND VPWR VPWR sky130_fd_sc_hd__decap_4
XFILLER_0_106_654 VPWR VGND VPWR VGND sky130_ef_sc_hd__decap_12
XFILLER_0_90_371 VGND VGND VPWR VPWR sky130_fd_sc_hd__fill_1
XTAP_TAPCELL_ROW_97_1479 VGND VPWR sky130_fd_sc_hd__tapvpwrvgnd_1
XFILLER_0_121_657 VPWR VGND VPWR VGND sky130_ef_sc_hd__decap_12
XFILLER_0_120_189 VGND VGND VPWR VPWR sky130_fd_sc_hd__decap_6
XTAP_TAPCELL_ROW_8_361 VGND VPWR sky130_fd_sc_hd__tapvpwrvgnd_1
XFILLER_0_37_15 VGND VGND VPWR VPWR sky130_fd_sc_hd__fill_1
X_10027_ _02018_ _04741_ VGND VGND VPWR VPWR _04742_ sky130_fd_sc_hd__nor2_2
Xclkbuf_leaf_28_clk clknet_2_1__leaf_clk VGND VGND VPWR VPWR clknet_leaf_28_clk sky130_fd_sc_hd__clkbuf_8
XFILLER_0_86_633 VGND VGND VPWR VPWR sky130_fd_sc_hd__decap_8
XFILLER_0_85_110 VGND VGND VPWR VPWR sky130_fd_sc_hd__fill_2
XFILLER_0_58_302 VGND VGND VPWR VPWR sky130_fd_sc_hd__decap_3
XTAP_TAPCELL_ROW_106_1586 VGND VPWR sky130_fd_sc_hd__tapvpwrvgnd_1
XFILLER_0_85_176 VGND VGND VPWR VPWR sky130_fd_sc_hd__fill_1
XFILLER_0_73_316 VPWR VGND VPWR VGND sky130_ef_sc_hd__decap_12
XFILLER_0_6_627 VGND VGND VPWR VPWR sky130_fd_sc_hd__decap_4
XFILLER_0_6_616 VGND VGND VPWR VPWR sky130_fd_sc_hd__decap_4
XFILLER_0_109_481 VGND VGND VPWR VPWR sky130_fd_sc_hd__decap_4
XFILLER_0_5_137 VPWR VGND VPWR VGND sky130_ef_sc_hd__decap_12
XFILLER_0_26_265 VPWR VGND VPWR VGND sky130_ef_sc_hd__decap_12
XFILLER_0_42_714 VGND VGND VPWR VPWR sky130_fd_sc_hd__decap_8
X_06120_ _01064_ _01065_ tanh_inst.divider.i\[2\] VGND VGND VPWR VPWR _01066_ sky130_fd_sc_hd__mux2_1
XFILLER_0_112_613 VGND VGND VPWR VPWR sky130_fd_sc_hd__decap_8
X_06051_ _00998_ _01001_ VGND VGND VPWR VPWR _06051_/X sky130_fd_sc_hd__xor2_2
XFILLER_0_22_471 VGND VGND VPWR VPWR sky130_fd_sc_hd__fill_2
XPHY_EDGE_ROW_99_Right_99 VGND VGND VPWR VPWR sky130_fd_sc_hd__decap_3
X_09810_ _04380_ _04419_ _04420_ VGND VGND VPWR VPWR _04532_ sky130_fd_sc_hd__or3_2
X_06953_ _01794_ _01795_ VGND VGND VPWR VPWR _01796_ sky130_fd_sc_hd__nand2b_2
X_09741_ _04398_ _04399_ _04464_ VGND VGND VPWR VPWR _04465_ sky130_fd_sc_hd__a21o_2
X_05904_ _00848_ _00865_ VGND VGND VPWR VPWR _00866_ sky130_fd_sc_hd__and2_2
XFILLER_0_118_83 VGND VGND VPWR VPWR sky130_fd_sc_hd__fill_1
X_06884_ _01059_ _01765_ VGND VGND VPWR VPWR _01766_ sky130_fd_sc_hd__nor2_2
X_09672_ _04252_ _04254_ _04327_ _04397_ VGND VGND VPWR VPWR _04398_ sky130_fd_sc_hd__a211o_2
XFILLER_0_27_81 VPWR VGND VPWR VGND sky130_ef_sc_hd__decap_12
Xclkbuf_leaf_19_clk clknet_2_3__leaf_clk VGND VGND VPWR VPWR clknet_leaf_19_clk sky130_fd_sc_hd__clkbuf_8
X_08623_ _02052_ _02751_ _02833_ VGND VGND VPWR VPWR _03404_ sky130_fd_sc_hd__a21oi_2
X_05835_ mac_inst.z\[12\] _00798_ VGND VGND VPWR VPWR _00802_ sky130_fd_sc_hd__nand2_2
X_05766_ _00723_ _00728_ _00726_ VGND VGND VPWR VPWR _00739_ sky130_fd_sc_hd__a21oi_2
XFILLER_0_11_3 VPWR VGND VPWR VGND sky130_ef_sc_hd__decap_12
X_08554_ _03335_ _03336_ VGND VGND VPWR VPWR _03337_ sky130_fd_sc_hd__xor2_2
XFILLER_0_49_335 VGND VGND VPWR VPWR sky130_fd_sc_hd__fill_1
X_07505_ _02310_ _02311_ tanh_inst.LOOKUP.index\[2\] VGND VGND VPWR VPWR _02312_ sky130_fd_sc_hd__mux2_1
XTAP_TAPCELL_ROW_53_926 VGND VPWR sky130_fd_sc_hd__tapvpwrvgnd_1
XFILLER_0_92_625 VGND VGND VPWR VPWR sky130_fd_sc_hd__decap_8
XFILLER_0_76_176 VGND VGND VPWR VPWR sky130_fd_sc_hd__fill_1
X_05697_ _00673_ _00674_ VGND VGND VPWR VPWR _05697_/X sky130_fd_sc_hd__and2_2
X_08485_ _03208_ _03217_ _03207_ VGND VGND VPWR VPWR _03270_ sky130_fd_sc_hd__o21ai_2
X_07436_ _02231_ _02232_ _02243_ VGND VGND VPWR VPWR _02244_ sky130_fd_sc_hd__o21ai_2
XTAP_TAPCELL_ROW_81_1269 VGND VPWR sky130_fd_sc_hd__tapvpwrvgnd_1
XFILLER_0_9_476 VGND VGND VPWR VPWR sky130_fd_sc_hd__decap_4
XFILLER_0_18_722 VGND VGND VPWR VPWR sky130_fd_sc_hd__fill_2
XTAP_TAPCELL_ROW_33_672 VGND VPWR sky130_fd_sc_hd__tapvpwrvgnd_1
X_07367_ _04791_ _02174_ _02175_ VGND VGND VPWR VPWR _02176_ sky130_fd_sc_hd__and3_2
X_06318_ tanh_inst.divider.y_\[-12\] _01252_ VGND VGND VPWR VPWR _01253_ sky130_fd_sc_hd__nand2_2
X_09106_ _03795_ _03798_ _03845_ _04791_ VGND VGND VPWR VPWR _03847_ sky130_fd_sc_hd__a31o_2
XFILLER_0_60_533 VGND VGND VPWR VPWR sky130_fd_sc_hd__decap_8
XFILLER_0_32_202 VGND VGND VPWR VPWR sky130_fd_sc_hd__decap_4
X_09037_ tanh_inst.divider.y\[-21\] _02015_ _03756_ _03779_ VGND VGND VPWR VPWR _03780_
+ sky130_fd_sc_hd__a22o_2
X_07298_ tanh_inst.LOOKUP.index\[2\] tanh_inst.LOOKUP.index\[1\] VGND VGND VPWR VPWR
+ _02108_ sky130_fd_sc_hd__and2b_2
X_06249_ tanh_inst.divider.i\[3\] _01188_ _01187_ VGND VGND VPWR VPWR _01189_ sky130_fd_sc_hd__o21a_2
XFILLER_0_102_134 VGND VGND VPWR VPWR sky130_fd_sc_hd__decap_6
XFILLER_0_20_419 VGND VGND VPWR VPWR sky130_fd_sc_hd__fill_1
XFILLER_0_102_189 VGND VGND VPWR VPWR sky130_fd_sc_hd__decap_6
XTAP_TAPCELL_ROW_5_320 VGND VPWR sky130_fd_sc_hd__tapvpwrvgnd_1
X_09939_ _04615_ _04618_ _04655_ VGND VGND VPWR VPWR _04657_ sky130_fd_sc_hd__or3_2
XFILLER_0_99_268 VGND VGND VPWR VPWR sky130_fd_sc_hd__fill_1
XFILLER_0_68_622 VGND VGND VPWR VPWR sky130_fd_sc_hd__decap_6
XFILLER_0_83_603 VPWR VGND VPWR VGND sky130_ef_sc_hd__decap_12
XFILLER_0_23_39 VPWR VGND VPWR VGND sky130_ef_sc_hd__decap_12
XFILLER_0_63_393 VPWR VGND VPWR VGND sky130_ef_sc_hd__decap_12
XTAP_TAPCELL_ROW_11_399 VGND VPWR sky130_fd_sc_hd__tapvpwrvgnd_1
XFILLER_0_51_566 VGND VGND VPWR VPWR sky130_fd_sc_hd__fill_1
XFILLER_0_23_279 VGND VGND VPWR VPWR sky130_fd_sc_hd__fill_1
XFILLER_0_48_58 VGND VGND VPWR VPWR sky130_fd_sc_hd__decap_3
XFILLER_0_3_27 VPWR VGND VPWR VGND sky130_ef_sc_hd__decap_12
XFILLER_0_64_24 VGND VGND VPWR VPWR sky130_fd_sc_hd__decap_4
XTAP_TAPCELL_ROW_108_1615 VGND VPWR sky130_fd_sc_hd__tapvpwrvgnd_1
X_05620_ _00598_ _00605_ VGND VGND VPWR VPWR _05620_/Y sky130_fd_sc_hd__xnor2_2
XFILLER_0_86_441 VGND VGND VPWR VPWR sky130_fd_sc_hd__fill_1
XTAP_TAPCELL_ROW_19_499 VGND VPWR sky130_fd_sc_hd__tapvpwrvgnd_1
XFILLER_0_19_519 VPWR VGND VPWR VGND sky130_ef_sc_hd__decap_12
X_05551_ mac_inst.y\[18\] _00543_ VGND VGND VPWR VPWR _00544_ sky130_fd_sc_hd__nand2_2
XFILLER_0_104_41 VPWR VGND VPWR VGND sky130_ef_sc_hd__decap_12
X_05482_ _04911_ _00477_ _00478_ _00480_ VGND VGND VPWR VPWR _00481_ sky130_fd_sc_hd__a31o_2
X_08270_ _03058_ _03059_ VGND VGND VPWR VPWR _03060_ sky130_fd_sc_hd__and2_2
XFILLER_0_116_215 VGND VGND VPWR VPWR sky130_fd_sc_hd__decap_6
XFILLER_0_104_85 VGND VGND VPWR VPWR sky130_fd_sc_hd__decap_8
X_07221_ tanh_inst.divider.y\[-9\] _02028_ _02029_ VGND VGND VPWR VPWR _02031_ sky130_fd_sc_hd__o21ai_2
XTAP_TAPCELL_ROW_30_631 VGND VPWR sky130_fd_sc_hd__tapvpwrvgnd_1
XTAP_TAPCELL_ROW_119_1744 VGND VPWR sky130_fd_sc_hd__tapvpwrvgnd_1
XFILLER_0_116_248 VGND VGND VPWR VPWR sky130_fd_sc_hd__decap_4
X_07152_ _01968_ _01972_ VGND VGND VPWR VPWR _01974_ sky130_fd_sc_hd__or2_2
XTAP_TAPCELL_ROW_30_642 VGND VPWR sky130_fd_sc_hd__tapvpwrvgnd_1
XTAP_TAPCELL_ROW_119_1755 VGND VPWR sky130_fd_sc_hd__tapvpwrvgnd_1
X_06103_ tanh_inst.divider.y_\[-15\] tanh_inst.divider.y_\[-16\] tanh_inst.divider.y_\[-13\]
+ tanh_inst.divider.y_\[-14\] VGND VGND VPWR VPWR _01050_ sky130_fd_sc_hd__or4_2
XFILLER_0_89_54 VGND VGND VPWR VPWR sky130_fd_sc_hd__fill_2
X_07083_ _01910_ _01911_ VGND VGND VPWR VPWR _01912_ sky130_fd_sc_hd__nand2b_2
Xclkbuf_leaf_8_clk clknet_2_2__leaf_clk VGND VGND VPWR VPWR clknet_leaf_8_clk sky130_fd_sc_hd__clkbuf_8
X_06034_ _00691_ _00759_ _00846_ VGND VGND VPWR VPWR _00986_ sky130_fd_sc_hd__and3b_2
XFILLER_0_100_638 VGND VGND VPWR VPWR sky130_fd_sc_hd__fill_1
XFILLER_0_59_3 VPWR VGND VPWR VGND sky130_ef_sc_hd__decap_12
XFILLER_0_10_496 VGND VGND VPWR VPWR sky130_fd_sc_hd__decap_4
X_07985_ _02740_ _02748_ _02781_ VGND VGND VPWR VPWR _02782_ sky130_fd_sc_hd__a21oi_2
X_06936_ _01779_ _01780_ VGND VGND VPWR VPWR _01781_ sky130_fd_sc_hd__nor2_2
X_09724_ _03138_ _04447_ VGND VGND VPWR VPWR _04448_ sky130_fd_sc_hd__or2_2
X_06867_ _01752_ VGND VGND VPWR VPWR _01753_ sky130_fd_sc_hd__inv_2
XTAP_TAPCELL_ROW_38_731 VGND VPWR sky130_fd_sc_hd__tapvpwrvgnd_1
X_09655_ _04347_ _04348_ _04310_ VGND VGND VPWR VPWR _04381_ sky130_fd_sc_hd__or3b_2
X_08606_ _03375_ _03379_ _03387_ VGND VGND VPWR VPWR _03388_ sky130_fd_sc_hd__a21oi_2
X_05818_ mac_inst.z\[31\] _00785_ VGND VGND VPWR VPWR _00786_ sky130_fd_sc_hd__nor2_2
XTAP_TAPCELL_ROW_38_742 VGND VPWR sky130_fd_sc_hd__tapvpwrvgnd_1
XFILLER_0_96_238 VGND VGND VPWR VPWR sky130_fd_sc_hd__decap_3
X_09586_ _04312_ _04313_ _04310_ VGND VGND VPWR VPWR _04314_ sky130_fd_sc_hd__o21ai_2
X_06798_ _01660_ _01669_ _01691_ VGND VGND VPWR VPWR _01693_ sky130_fd_sc_hd__and3_2
X_05749_ mac_inst.z\[5\] _00720_ VGND VGND VPWR VPWR _00723_ sky130_fd_sc_hd__or2_2
XFILLER_0_49_143 VPWR VGND VPWR VGND sky130_ef_sc_hd__decap_12
X_08537_ _03318_ _03320_ VGND VGND VPWR VPWR _03321_ sky130_fd_sc_hd__or2_2
X_08468_ tanh_inst.divider.y\[1\] tanh_inst.divider.x\[1\] VGND VGND VPWR VPWR _03253_
+ sky130_fd_sc_hd__nand2_2
XFILLER_0_92_477 VGND VGND VPWR VPWR sky130_fd_sc_hd__decap_3
X_07419_ tanh_inst.divider.y\[-22\] _02225_ VGND VGND VPWR VPWR _02227_ sky130_fd_sc_hd__xor2_2
XFILLER_0_9_273 VGND VGND VPWR VPWR sky130_fd_sc_hd__decap_6
XFILLER_0_18_530 VGND VGND VPWR VPWR sky130_fd_sc_hd__fill_2
XFILLER_0_18_585 VGND VGND VPWR VPWR sky130_fd_sc_hd__decap_3
X_10430_ clknet_leaf_35_clk _00287_ _00000_ VGND VGND VPWR VPWR mac_inst.i\[22\] sky130_fd_sc_hd__dfrtp_2
X_08399_ _03150_ _03158_ _03184_ tanh_inst.z_\[7\] VGND VGND VPWR VPWR _03186_ sky130_fd_sc_hd__o31a_2
XFILLER_0_45_382 VGND VGND VPWR VPWR sky130_fd_sc_hd__decap_8
XFILLER_0_72_190 VGND VGND VPWR VPWR sky130_fd_sc_hd__decap_6
XFILLER_0_33_533 VPWR VGND VPWR VGND sky130_ef_sc_hd__decap_12
XFILLER_0_33_555 VGND VGND VPWR VPWR sky130_fd_sc_hd__decap_4
XFILLER_0_45_393 VPWR VGND VPWR VGND sky130_ef_sc_hd__decap_12
X_10361_ clknet_leaf_18_clk _00218_ VGND VGND VPWR VPWR tanh_inst.divider.z_\[-3\]
+ sky130_fd_sc_hd__dfxtp_2
XTAP_TAPCELL_ROW_94_1438 VGND VPWR sky130_fd_sc_hd__tapvpwrvgnd_1
XFILLER_0_60_385 VGND VGND VPWR VPWR sky130_fd_sc_hd__fill_2
X_10292_ clknet_leaf_29_clk _00149_ VGND VGND VPWR VPWR tanh_inst.z_\[-3\] sky130_fd_sc_hd__dfxtp_2
XFILLER_0_0_3 VPWR VGND VPWR VGND sky130_ef_sc_hd__decap_12
XFILLER_0_34_27 VGND VGND VPWR VPWR sky130_fd_sc_hd__fill_1
XTAP_TAPCELL_ROW_103_1545 VGND VPWR sky130_fd_sc_hd__tapvpwrvgnd_1
XFILLER_0_68_474 VGND VGND VPWR VPWR sky130_fd_sc_hd__fill_2
XFILLER_0_55_113 VGND VGND VPWR VPWR sky130_fd_sc_hd__decap_8
XFILLER_0_55_102 VGND VGND VPWR VPWR sky130_fd_sc_hd__decap_8
XTAP_TAPCELL_ROW_16_458 VGND VPWR sky130_fd_sc_hd__tapvpwrvgnd_1
XFILLER_0_83_477 VGND VGND VPWR VPWR sky130_fd_sc_hd__decap_6
XFILLER_0_71_617 VPWR VGND VPWR VGND sky130_ef_sc_hd__decap_12
XFILLER_0_83_488 VPWR VGND VPWR VGND sky130_ef_sc_hd__decap_12
XFILLER_0_113_207 VGND VGND VPWR VPWR sky130_fd_sc_hd__decap_4
XFILLER_0_64_691 VGND VGND VPWR VPWR sky130_fd_sc_hd__decap_8
XFILLER_0_24_533 VPWR VGND VPWR VGND sky130_ef_sc_hd__decap_12
XFILLER_0_11_205 VPWR VGND VPWR VGND sky130_ef_sc_hd__decap_12
XFILLER_0_24_577 VGND VGND VPWR VPWR sky130_fd_sc_hd__decap_8
XFILLER_0_59_68 VGND VGND VPWR VPWR sky130_fd_sc_hd__fill_2
XFILLER_0_59_57 VGND VGND VPWR VPWR sky130_fd_sc_hd__decap_6
XFILLER_0_11_249 VPWR VGND VPWR VGND sky130_ef_sc_hd__decap_12
XTAP_TAPCELL_ROW_114_1685 VGND VPWR sky130_fd_sc_hd__tapvpwrvgnd_1
XFILLER_0_75_45 VGND VGND VPWR VPWR sky130_fd_sc_hd__decap_4
X_07770_ _02570_ _02571_ VGND VGND VPWR VPWR _02572_ sky130_fd_sc_hd__nand2_2
XTAP_TAPCELL_ROW_69_1120 VGND VPWR sky130_fd_sc_hd__tapvpwrvgnd_1
X_06721_ tanh_inst.z_\[-12\] _01622_ VGND VGND VPWR VPWR _01624_ sky130_fd_sc_hd__or2_2
X_09440_ _02022_ _03873_ _03916_ VGND VGND VPWR VPWR _04172_ sky130_fd_sc_hd__o21a_2
X_06652_ mac_y_out[4] _01469_ _01503_ _01562_ VGND VGND VPWR VPWR _00132_ sky130_fd_sc_hd__o2bb2ai_2
XTAP_TAPCELL_ROW_35_701 VGND VPWR sky130_fd_sc_hd__tapvpwrvgnd_1
X_09371_ _04103_ _04104_ VGND VGND VPWR VPWR _04105_ sky130_fd_sc_hd__and2_2
XFILLER_0_115_51 VGND VGND VPWR VPWR sky130_fd_sc_hd__decap_4
XFILLER_0_93_219 VGND VGND VPWR VPWR sky130_fd_sc_hd__decap_4
XFILLER_0_93_208 VGND VGND VPWR VPWR sky130_fd_sc_hd__decap_4
XFILLER_0_19_305 VPWR VGND VPWR VGND sky130_ef_sc_hd__decap_12
X_05603_ mac_inst.y\[23\] _00590_ VGND VGND VPWR VPWR _00591_ sky130_fd_sc_hd__or2_2
X_06583_ tanh_inst.z_\[-11\] tanh_inst.z_\[-12\] tanh_inst.z_\[-9\] tanh_inst.z_\[-10\]
+ VGND VGND VPWR VPWR _01498_ sky130_fd_sc_hd__or4_2
X_08322_ _03110_ VGND VGND VPWR VPWR _03111_ sky130_fd_sc_hd__inv_2
X_05534_ _00501_ _00503_ _00516_ _00517_ VGND VGND VPWR VPWR _00529_ sky130_fd_sc_hd__a31o_2
XFILLER_0_47_625 VGND VGND VPWR VPWR sky130_fd_sc_hd__decap_3
XFILLER_0_74_444 VGND VGND VPWR VPWR sky130_fd_sc_hd__fill_1
XFILLER_0_19_349 VGND VGND VPWR VPWR sky130_fd_sc_hd__decap_8
X_08253_ _02879_ _03039_ _03042_ VGND VGND VPWR VPWR _03043_ sky130_fd_sc_hd__a21o_2
X_07204_ tanh_inst.LOOKUP.index\[2\] tanh_inst.LOOKUP.index\[1\] _01524_ _01501_ VGND
+ VGND VPWR VPWR _02015_ sky130_fd_sc_hd__a31o_2
XFILLER_0_6_221 VPWR VGND VPWR VGND sky130_ef_sc_hd__decap_12
X_05465_ _04836_ _00464_ _00463_ _05021_ VGND VGND VPWR VPWR _00465_ sky130_fd_sc_hd__o211ai_2
XFILLER_0_6_265 VPWR VGND VPWR VGND sky130_ef_sc_hd__decap_12
X_05396_ _05016_ _05022_ _05023_ _05027_ _04781_ _04782_ VGND VGND VPWR VPWR _00401_
+ sky130_fd_sc_hd__mux4_2
XFILLER_0_27_382 VGND VGND VPWR VPWR sky130_fd_sc_hd__decap_4
X_08184_ _02972_ _02974_ VGND VGND VPWR VPWR _02976_ sky130_fd_sc_hd__xor2_2
X_07135_ tanh_inst.divider.z_\[-2\] _01092_ _01958_ _01088_ VGND VGND VPWR VPWR _00219_
+ sky130_fd_sc_hd__a22o_2
XFILLER_0_70_650 VPWR VGND VPWR VGND sky130_ef_sc_hd__decap_12
XFILLER_0_112_251 VGND VGND VPWR VPWR sky130_fd_sc_hd__fill_1
X_07066_ _01896_ VGND VGND VPWR VPWR _01897_ sky130_fd_sc_hd__inv_2
XFILLER_0_112_262 VGND VGND VPWR VPWR sky130_fd_sc_hd__fill_1
X_06017_ mac_inst.i\[29\] mac_inst.i\[30\] _00969_ _04941_ VGND VGND VPWR VPWR _00971_
+ sky130_fd_sc_hd__a31o_2
X_07968_ _02711_ _02720_ _02712_ VGND VGND VPWR VPWR _02765_ sky130_fd_sc_hd__o21ba_2
X_06919_ tanh_inst.div_en tanh_inst.divider.z_\[1\] VGND VGND VPWR VPWR _00190_ sky130_fd_sc_hd__and2b_2
X_09707_ _04431_ VGND VGND VPWR VPWR _04432_ sky130_fd_sc_hd__inv_2
XFILLER_0_97_503 VGND VGND VPWR VPWR sky130_fd_sc_hd__fill_1
X_07899_ _02695_ _02696_ VGND VGND VPWR VPWR _02697_ sky130_fd_sc_hd__nor2_2
X_09638_ _04353_ _04354_ _04163_ _04229_ VGND VGND VPWR VPWR _04364_ sky130_fd_sc_hd__nand4b_2
X_09569_ tanh_inst.LOOKUP.index\[4\] _03705_ _04213_ VGND VGND VPWR VPWR _04297_ sky130_fd_sc_hd__o21a_2
XFILLER_0_37_124 VGND VGND VPWR VPWR sky130_fd_sc_hd__fill_1
XTAP_TAPCELL_ROW_13_428 VGND VPWR sky130_fd_sc_hd__tapvpwrvgnd_1
XFILLER_0_18_382 VGND VGND VPWR VPWR sky130_fd_sc_hd__decap_6
XFILLER_0_18_393 VPWR VGND VPWR VGND sky130_ef_sc_hd__decap_12
XFILLER_0_20_29 VPWR VGND VPWR VGND sky130_ef_sc_hd__decap_12
X_10413_ clknet_leaf_36_clk _00270_ _00000_ VGND VGND VPWR VPWR mac_inst.i\[5\] sky130_fd_sc_hd__dfrtp_2
X_10344_ clknet_leaf_15_clk _00201_ VGND VGND VPWR VPWR tanh_inst.divider.z_\[-20\]
+ sky130_fd_sc_hd__dfxtp_2
XFILLER_0_60_193 VGND VGND VPWR VPWR sky130_fd_sc_hd__decap_3
XFILLER_0_21_558 VGND VGND VPWR VPWR sky130_fd_sc_hd__fill_2
X_10275_ clknet_leaf_21_clk _00132_ VGND VGND VPWR VPWR tanh_inst.z_\[-20\] sky130_fd_sc_hd__dfxtp_2
XFILLER_0_29_27 VPWR VGND VPWR VGND sky130_ef_sc_hd__decap_12
XFILLER_0_45_26 VGND VGND VPWR VPWR sky130_fd_sc_hd__decap_6
XFILLER_0_88_547 VGND VGND VPWR VPWR sky130_fd_sc_hd__fill_2
XFILLER_0_96_580 VGND VGND VPWR VPWR sky130_fd_sc_hd__decap_8
XFILLER_0_68_260 VGND VGND VPWR VPWR sky130_fd_sc_hd__fill_2
XFILLER_0_83_252 VPWR VGND VPWR VGND sky130_ef_sc_hd__decap_12
XTAP_TAPCELL_ROW_64_1061 VGND VPWR sky130_fd_sc_hd__tapvpwrvgnd_1
XFILLER_0_9_15 VPWR VGND VPWR VGND sky130_ef_sc_hd__decap_12
XFILLER_0_117_3 VPWR VGND VPWR VGND sky130_ef_sc_hd__decap_12
X_05250_ mac_inst.i\[16\] _04840_ _04938_ VGND VGND VPWR VPWR _04951_ sky130_fd_sc_hd__nor3_2
XTAP_TAPCELL_ROW_116_1714 VGND VPWR sky130_fd_sc_hd__tapvpwrvgnd_1
XFILLER_0_71_469 VGND VGND VPWR VPWR sky130_fd_sc_hd__decap_4
X_05181_ mac_inst.x\[9\] _04852_ _04853_ VGND VGND VPWR VPWR _04885_ sky130_fd_sc_hd__a21o_2
XFILLER_0_101_75 VPWR VGND VPWR VGND sky130_ef_sc_hd__decap_12
XFILLER_0_52_694 VGND VGND VPWR VPWR sky130_fd_sc_hd__fill_1
XFILLER_0_3_279 VGND VGND VPWR VPWR sky130_fd_sc_hd__fill_1
XFILLER_0_51_193 VGND VGND VPWR VPWR sky130_fd_sc_hd__fill_2
X_08940_ _02053_ _03682_ _03683_ _03674_ VGND VGND VPWR VPWR _03684_ sky130_fd_sc_hd__a31o_2
X_08871_ tanh_inst.divider.x\[-23\] _03614_ _03615_ VGND VGND VPWR VPWR _03616_ sky130_fd_sc_hd__or3_2
X_07822_ _02541_ _02594_ _02595_ VGND VGND VPWR VPWR _02622_ sky130_fd_sc_hd__o21ai_2
XFILLER_0_19_93 VPWR VGND VPWR VGND sky130_ef_sc_hd__decap_12
X_07753_ _02552_ _02553_ VGND VGND VPWR VPWR _02555_ sky130_fd_sc_hd__nand2b_2
XFILLER_0_79_514 VGND VGND VPWR VPWR sky130_fd_sc_hd__decap_6
X_07684_ _02484_ _02485_ _02486_ _02022_ _02053_ VGND VGND VPWR VPWR _02487_ sky130_fd_sc_hd__a221o_2
X_06704_ _01607_ _01608_ VGND VGND VPWR VPWR _01609_ sky130_fd_sc_hd__nand2b_2
X_09423_ _04120_ _04127_ _04155_ VGND VGND VPWR VPWR _04156_ sky130_fd_sc_hd__a21oi_2
X_06635_ _01477_ _01546_ tanh_inst.z_\[7\] VGND VGND VPWR VPWR _01547_ sky130_fd_sc_hd__a21oi_2
X_09354_ _02721_ _04087_ VGND VGND VPWR VPWR _04088_ sky130_fd_sc_hd__nor2_2
XFILLER_0_59_260 VGND VGND VPWR VPWR sky130_fd_sc_hd__decap_4
XFILLER_0_19_113 VPWR VGND VPWR VGND sky130_ef_sc_hd__decap_12
X_06566_ tanh_inst.LOOKUP.index\[4\] tanh_inst.LOOKUP.index\[3\] tanh_inst.LOOKUP.index\[2\]
+ tanh_inst.LOOKUP.index\[1\] VGND VGND VPWR VPWR _01481_ sky130_fd_sc_hd__nor4_2
XFILLER_0_59_293 VGND VGND VPWR VPWR sky130_fd_sc_hd__fill_1
X_08305_ _03037_ _03043_ _03036_ VGND VGND VPWR VPWR _03094_ sky130_fd_sc_hd__a21oi_2
X_06497_ _01415_ _01416_ _01417_ VGND VGND VPWR VPWR _01418_ sky130_fd_sc_hd__or3_2
X_09285_ _02052_ _04018_ _04019_ _04020_ VGND VGND VPWR VPWR _04021_ sky130_fd_sc_hd__o22a_2
XFILLER_0_90_701 VGND VGND VPWR VPWR sky130_fd_sc_hd__decap_6
XFILLER_0_7_541 VGND VGND VPWR VPWR sky130_fd_sc_hd__decap_3
X_05517_ _00497_ _00498_ VGND VGND VPWR VPWR _00513_ sky130_fd_sc_hd__nor2_2
XFILLER_0_62_458 VGND VGND VPWR VPWR sky130_fd_sc_hd__decap_6
XFILLER_0_7_585 VGND VGND VPWR VPWR sky130_fd_sc_hd__fill_1
X_05448_ mac_inst.i\[3\] _05018_ VGND VGND VPWR VPWR _00449_ sky130_fd_sc_hd__nand2_2
X_08236_ _02019_ _03017_ _03025_ _03026_ _02015_ VGND VGND VPWR VPWR _03027_ sky130_fd_sc_hd__a221o_2
X_08167_ _02933_ _02935_ _02958_ VGND VGND VPWR VPWR _02959_ sky130_fd_sc_hd__o21a_2
X_07118_ tanh_inst.divider.z_\[-3\] _01941_ _01942_ VGND VGND VPWR VPWR _01943_ sky130_fd_sc_hd__and3_2
X_05379_ mac_inst.i\[2\] _04992_ _00350_ VGND VGND VPWR VPWR _00385_ sky130_fd_sc_hd__o21a_2
XFILLER_0_30_322 VGND VGND VPWR VPWR sky130_fd_sc_hd__fill_1
XFILLER_0_42_171 VGND VGND VPWR VPWR sky130_fd_sc_hd__decap_4
X_08098_ _02890_ _02891_ VGND VGND VPWR VPWR _02892_ sky130_fd_sc_hd__and2_2
X_07049_ _01880_ _01881_ VGND VGND VPWR VPWR _01882_ sky130_fd_sc_hd__nand2b_2
X_10060_ rst VGND VGND VPWR VPWR _00079_ sky130_fd_sc_hd__inv_2
XFILLER_0_97_333 VGND VGND VPWR VPWR sky130_fd_sc_hd__decap_3
XFILLER_0_97_377 VGND VGND VPWR VPWR sky130_fd_sc_hd__decap_3
XFILLER_0_97_366 VGND VGND VPWR VPWR sky130_fd_sc_hd__fill_1
XFILLER_0_57_219 VGND VGND VPWR VPWR sky130_fd_sc_hd__decap_4
XFILLER_0_38_400 VPWR VGND VPWR VGND sky130_ef_sc_hd__decap_12
XTAP_TAPCELL_ROW_100_1515 VGND VPWR sky130_fd_sc_hd__tapvpwrvgnd_1
XTAP_TAPCELL_ROW_26_586 VGND VPWR sky130_fd_sc_hd__tapvpwrvgnd_1
XFILLER_0_38_433 VGND VGND VPWR VPWR sky130_fd_sc_hd__decap_4
XFILLER_0_93_561 VGND VGND VPWR VPWR sky130_fd_sc_hd__fill_1
XFILLER_0_65_274 VGND VGND VPWR VPWR sky130_fd_sc_hd__decap_6
XFILLER_0_26_628 VPWR VGND VPWR VGND sky130_ef_sc_hd__decap_12
XFILLER_0_38_477 VGND VGND VPWR VPWR sky130_fd_sc_hd__decap_6
XFILLER_0_108_376 VGND VGND VPWR VPWR sky130_fd_sc_hd__decap_6
XFILLER_0_108_365 VGND VGND VPWR VPWR sky130_fd_sc_hd__decap_3
XFILLER_0_93_594 VGND VGND VPWR VPWR sky130_fd_sc_hd__decap_8
XFILLER_0_53_447 VGND VGND VPWR VPWR sky130_fd_sc_hd__fill_1
XFILLER_0_53_458 VPWR VGND VPWR VGND sky130_ef_sc_hd__decap_12
XFILLER_0_80_277 VPWR VGND VPWR VGND sky130_ef_sc_hd__decap_12
XFILLER_0_34_672 VGND VGND VPWR VPWR sky130_fd_sc_hd__decap_6
XFILLER_0_61_491 VPWR VGND VPWR VGND sky130_ef_sc_hd__decap_12
XFILLER_0_33_193 VPWR VGND VPWR VGND sky130_ef_sc_hd__decap_12
X_10327_ clknet_leaf_18_clk _00184_ VGND VGND VPWR VPWR tanh_out[19] sky130_fd_sc_hd__dfxtp_2
XFILLER_0_0_249 VGND VGND VPWR VPWR sky130_fd_sc_hd__decap_3
XTAP_TAPCELL_ROW_111_1655 VGND VPWR sky130_fd_sc_hd__tapvpwrvgnd_1
XTAP_TAPCELL_ROW_111_1644 VGND VPWR sky130_fd_sc_hd__tapvpwrvgnd_1
X_10258_ clknet_leaf_32_clk mac_inst.x\[20\] _00000_ VGND VGND VPWR VPWR mac_x_out[20]
+ sky130_fd_sc_hd__dfrtp_2
X_10189_ x_in[15] _00000_ VGND VGND VPWR VPWR mac_inst.x\[15\] sky130_fd_sc_hd__dlxtn_1
X_06420_ tanh_inst.divider.y_\[-4\] _01344_ VGND VGND VPWR VPWR _01347_ sky130_fd_sc_hd__nor2_2
XFILLER_0_48_219 VGND VGND VPWR VPWR sky130_fd_sc_hd__fill_1
XFILLER_0_29_433 VGND VGND VPWR VPWR sky130_fd_sc_hd__fill_1
X_06351_ _01282_ _01283_ VGND VGND VPWR VPWR _01284_ sky130_fd_sc_hd__and2b_2
XFILLER_0_72_701 VGND VGND VPWR VPWR sky130_fd_sc_hd__decap_4
XFILLER_0_17_606 VGND VGND VPWR VPWR sky130_fd_sc_hd__fill_1
X_06282_ tanh_inst.divider.y_\[-15\] _01219_ VGND VGND VPWR VPWR _01220_ sky130_fd_sc_hd__nor2_2
XFILLER_0_112_41 VPWR VGND VPWR VGND sky130_ef_sc_hd__decap_12
X_09070_ tanh_inst.LOOKUP.index\[4\] _03811_ VGND VGND VPWR VPWR _03812_ sky130_fd_sc_hd__nand2_2
X_05302_ mac_inst.x\[4\] _04852_ _04853_ _04783_ VGND VGND VPWR VPWR _05002_ sky130_fd_sc_hd__a211o_2
XFILLER_0_112_85 VPWR VGND VPWR VGND sky130_ef_sc_hd__decap_12
X_08021_ _02815_ _02816_ _04791_ _02799_ VGND VGND VPWR VPWR _02817_ sky130_fd_sc_hd__o2bb2a_2
X_05233_ _04782_ _04932_ VGND VGND VPWR VPWR _04934_ sky130_fd_sc_hd__nand2_2
XFILLER_0_44_469 VGND VGND VPWR VPWR sky130_fd_sc_hd__decap_6
XTAP_TAPCELL_ROW_77_1230 VGND VPWR sky130_fd_sc_hd__tapvpwrvgnd_1
XFILLER_0_4_555 VGND VGND VPWR VPWR sky130_fd_sc_hd__fill_1
XFILLER_0_24_171 VGND VGND VPWR VPWR sky130_fd_sc_hd__decap_3
XFILLER_0_12_333 VPWR VGND VPWR VGND sky130_ef_sc_hd__decap_12
X_05164_ _04782_ _04867_ VGND VGND VPWR VPWR _04868_ sky130_fd_sc_hd__nor2_2
XFILLER_0_97_98 VGND VGND VPWR VPWR sky130_fd_sc_hd__decap_4
X_09972_ _04687_ _04688_ VGND VGND VPWR VPWR _04689_ sky130_fd_sc_hd__nor2_2
XFILLER_0_12_377 VGND VGND VPWR VPWR sky130_fd_sc_hd__decap_6
X_05095_ tanh_counter\[4\] _04806_ _04813_ VGND VGND VPWR VPWR _00338_ sky130_fd_sc_hd__a21oi_2
XFILLER_0_110_552 VGND VGND VPWR VPWR sky130_fd_sc_hd__decap_8
X_08923_ _03509_ _03519_ _03520_ _03510_ tanh_inst.LOOKUP.index\[1\] tanh_inst.LOOKUP.index\[0\]
+ VGND VGND VPWR VPWR _03667_ sky130_fd_sc_hd__mux4_2
XFILLER_0_41_3 VGND VGND VPWR VPWR sky130_fd_sc_hd__decap_6
X_08854_ _02025_ _03597_ _03598_ _02022_ VGND VGND VPWR VPWR _03599_ sky130_fd_sc_hd__a31o_2
X_08785_ tanh_inst.divider.x\[-20\] _02028_ _03508_ VGND VGND VPWR VPWR _03531_ sky130_fd_sc_hd__o21a_2
XFILLER_0_79_300 VPWR VGND VPWR VGND sky130_ef_sc_hd__decap_12
X_07805_ tanh_inst.divider.x\[-15\] _02604_ VGND VGND VPWR VPWR _02606_ sky130_fd_sc_hd__or2_2
X_05997_ _00940_ _00951_ VGND VGND VPWR VPWR _05997_/Y sky130_fd_sc_hd__xnor2_2
X_07736_ tanh_inst.divider.y\[-16\] _02536_ VGND VGND VPWR VPWR _02538_ sky130_fd_sc_hd__and2_2
XFILLER_0_79_366 VGND VGND VPWR VPWR sky130_fd_sc_hd__decap_4
XFILLER_0_67_517 VGND VGND VPWR VPWR sky130_fd_sc_hd__decap_3
XPHY_EDGE_ROW_9_Left_131 VGND VGND VPWR VPWR sky130_fd_sc_hd__decap_3
XFILLER_0_67_539 VGND VGND VPWR VPWR sky130_fd_sc_hd__decap_3
X_07667_ _02246_ _02249_ tanh_inst.LOOKUP.index\[2\] VGND VGND VPWR VPWR _02471_ sky130_fd_sc_hd__mux2_1
X_09406_ _04137_ _04138_ VGND VGND VPWR VPWR _04139_ sky130_fd_sc_hd__nand2b_2
X_07598_ _02400_ _02401_ _02402_ VGND VGND VPWR VPWR _02403_ sky130_fd_sc_hd__o21ai_2
X_06618_ _01471_ _01522_ VGND VGND VPWR VPWR _01531_ sky130_fd_sc_hd__or2_2
XFILLER_0_1_93 VPWR VGND VPWR VGND sky130_ef_sc_hd__decap_12
X_09337_ _04069_ _04070_ VGND VGND VPWR VPWR _04072_ sky130_fd_sc_hd__xnor2_2
X_06549_ _01463_ _01464_ VGND VGND VPWR VPWR _01465_ sky130_fd_sc_hd__xnor2_2
XFILLER_0_63_723 VGND VGND VPWR VPWR sky130_fd_sc_hd__fill_1
XTAP_TAPCELL_ROW_23_545 VGND VPWR sky130_fd_sc_hd__tapvpwrvgnd_1
XFILLER_0_47_252 VGND VGND VPWR VPWR sky130_fd_sc_hd__decap_6
XFILLER_0_118_652 VGND VGND VPWR VPWR sky130_fd_sc_hd__fill_2
X_09268_ _03994_ _03995_ _04004_ _04791_ VGND VGND VPWR VPWR _04005_ sky130_fd_sc_hd__o2bb2a_2
XFILLER_0_90_520 VGND VGND VPWR VPWR sky130_fd_sc_hd__decap_4
XFILLER_0_35_447 VGND VGND VPWR VPWR sky130_fd_sc_hd__fill_1
XTAP_TAPCELL_ROW_51_898 VGND VPWR sky130_fd_sc_hd__tapvpwrvgnd_1
XFILLER_0_117_184 VGND VGND VPWR VPWR sky130_fd_sc_hd__fill_2
XFILLER_0_105_335 VGND VGND VPWR VPWR sky130_fd_sc_hd__fill_1
XFILLER_0_7_393 VGND VGND VPWR VPWR sky130_fd_sc_hd__decap_3
X_08219_ _03008_ _03009_ VGND VGND VPWR VPWR _03010_ sky130_fd_sc_hd__nand2_2
XFILLER_0_105_346 VGND VGND VPWR VPWR sky130_fd_sc_hd__fill_1
X_09199_ tanh_inst.LOOKUP.index\[3\] _04769_ VGND VGND VPWR VPWR _03938_ sky130_fd_sc_hd__nand2_2
XFILLER_0_15_193 VPWR VGND VPWR VGND sky130_ef_sc_hd__decap_12
XFILLER_0_31_653 VGND VGND VPWR VPWR sky130_fd_sc_hd__decap_4
XFILLER_0_30_141 VPWR VGND VPWR VGND sky130_ef_sc_hd__decap_12
X_10043_ _04753_ _04754_ _01470_ VGND VGND VPWR VPWR _00331_ sky130_fd_sc_hd__o21ai_2
XTAP_TAPCELL_ROW_59_998 VGND VPWR sky130_fd_sc_hd__tapvpwrvgnd_1
XFILLER_0_39_720 VGND VGND VPWR VPWR sky130_fd_sc_hd__decap_4
XTAP_TAPCELL_ROW_61_1020 VGND VPWR sky130_fd_sc_hd__tapvpwrvgnd_1
XFILLER_0_66_594 VGND VGND VPWR VPWR sky130_fd_sc_hd__fill_2
XFILLER_0_26_436 VPWR VGND VPWR VGND sky130_ef_sc_hd__decap_12
XFILLER_0_26_458 VPWR VGND VPWR VGND sky130_ef_sc_hd__decap_12
XFILLER_0_6_27 VGND VGND VPWR VPWR sky130_fd_sc_hd__fill_1
XFILLER_0_1_536 VGND VGND VPWR VPWR sky130_fd_sc_hd__fill_1
XTAP_TAPCELL_ROW_72_1160 VGND VPWR sky130_fd_sc_hd__tapvpwrvgnd_1
X_05920_ _00876_ _00880_ VGND VGND VPWR VPWR _00881_ sky130_fd_sc_hd__nand2_2
X_05851_ mac_inst.z\[13\] _00816_ VGND VGND VPWR VPWR _00817_ sky130_fd_sc_hd__or2_2
X_08570_ _03351_ _03352_ _03286_ _03294_ VGND VGND VPWR VPWR _03353_ sky130_fd_sc_hd__a211o_2
XFILLER_0_88_141 VGND VGND VPWR VPWR sky130_fd_sc_hd__fill_1
X_07521_ tanh_inst.divider.x\[-21\] _02326_ VGND VGND VPWR VPWR _02328_ sky130_fd_sc_hd__xnor2_2
X_05782_ mac_inst.z\[8\] _00749_ VGND VGND VPWR VPWR _00753_ sky130_fd_sc_hd__nand2_2
XFILLER_0_16_83 VGND VGND VPWR VPWR sky130_fd_sc_hd__fill_1
XFILLER_0_76_358 VGND VGND VPWR VPWR sky130_fd_sc_hd__decap_6
X_07452_ _02123_ _02193_ tanh_inst.z_\[7\] VGND VGND VPWR VPWR _02260_ sky130_fd_sc_hd__a21o_2
XFILLER_0_119_449 VGND VGND VPWR VPWR sky130_fd_sc_hd__fill_2
X_06403_ _01088_ _01328_ _01330_ _01331_ VGND VGND VPWR VPWR _00104_ sky130_fd_sc_hd__a31o_2
XFILLER_0_91_306 VPWR VGND VPWR VGND sky130_ef_sc_hd__decap_12
X_07383_ _01525_ _02191_ VGND VGND VPWR VPWR _02192_ sky130_fd_sc_hd__or2_2
X_06334_ _04793_ _01267_ VGND VGND VPWR VPWR _01268_ sky130_fd_sc_hd__nand2_2
X_09122_ tanh_inst.divider.y\[-19\] _03861_ VGND VGND VPWR VPWR _03863_ sky130_fd_sc_hd__nor2_2
XTAP_TAPCELL_ROW_20_515 VGND VPWR sky130_fd_sc_hd__tapvpwrvgnd_1
XFILLER_0_29_296 VGND VGND VPWR VPWR sky130_fd_sc_hd__fill_1
XFILLER_0_114_121 VPWR VGND VPWR VGND sky130_ef_sc_hd__decap_12
X_06265_ tanh_inst.divider.i\[3\] _01025_ _01187_ VGND VGND VPWR VPWR _01204_ sky130_fd_sc_hd__o21ai_2
X_09053_ _03793_ _03794_ VGND VGND VPWR VPWR _03795_ sky130_fd_sc_hd__nand2_2
XFILLER_0_89_3 VPWR VGND VPWR VGND sky130_ef_sc_hd__decap_12
XFILLER_0_114_154 VGND VGND VPWR VPWR sky130_fd_sc_hd__decap_6
X_08004_ tanh_inst.divider.y\[-10\] tanh_inst.divider.x\[-10\] VGND VGND VPWR VPWR
+ _02800_ sky130_fd_sc_hd__or2_2
X_06196_ tanh_inst.divider.i\[2\] _01024_ _01118_ VGND VGND VPWR VPWR _01139_ sky130_fd_sc_hd__o21a_2
XFILLER_0_4_363 VGND VGND VPWR VPWR sky130_fd_sc_hd__fill_1
X_05216_ mac_inst.x\[7\] _04852_ _04853_ VGND VGND VPWR VPWR _04920_ sky130_fd_sc_hd__a21o_2
XFILLER_0_25_491 VPWR VGND VPWR VGND sky130_ef_sc_hd__decap_12
XFILLER_0_12_141 VPWR VGND VPWR VGND sky130_ef_sc_hd__decap_12
X_05147_ _04841_ _04847_ VGND VGND VPWR VPWR _04851_ sky130_fd_sc_hd__or2_2
XFILLER_0_110_382 VPWR VGND VPWR VGND sky130_ef_sc_hd__decap_12
X_09955_ _04669_ _04672_ VGND VGND VPWR VPWR _04673_ sky130_fd_sc_hd__nand2_2
X_05078_ mac_inst.z\[21\] VGND VGND VPWR VPWR _04802_ sky130_fd_sc_hd__inv_2
X_09886_ _04601_ _04605_ VGND VGND VPWR VPWR _04606_ sky130_fd_sc_hd__and2_2
X_08906_ tanh_inst.divider.x\[0\] tanh_inst.divider.x\[1\] tanh_inst.divider.x\[2\]
+ tanh_inst.divider.x\[3\] tanh_inst.LOOKUP.index\[0\] tanh_inst.LOOKUP.index\[1\]
+ VGND VGND VPWR VPWR _03651_ sky130_fd_sc_hd__mux4_2
XFILLER_0_99_417 VGND VGND VPWR VPWR sky130_fd_sc_hd__decap_3
X_08837_ tanh_inst.divider.y\[-24\] _03582_ VGND VGND VPWR VPWR _03583_ sky130_fd_sc_hd__xnor2_2
XFILLER_0_99_439 VGND VGND VPWR VPWR sky130_fd_sc_hd__decap_8
XTAP_TAPCELL_ROW_28_615 VGND VPWR sky130_fd_sc_hd__tapvpwrvgnd_1
X_08768_ _03509_ _03511_ _03512_ _03510_ _04760_ tanh_inst.LOOKUP.index\[0\] VGND
+ VGND VPWR VPWR _03514_ sky130_fd_sc_hd__mux4_2
XTAP_TAPCELL_ROW_56_957 VGND VPWR sky130_fd_sc_hd__tapvpwrvgnd_1
XFILLER_0_95_612 VGND VGND VPWR VPWR sky130_fd_sc_hd__decap_4
X_08699_ _03461_ _03464_ _03476_ VGND VGND VPWR VPWR _03478_ sky130_fd_sc_hd__o21ai_2
X_07719_ _02429_ _02477_ _02479_ _02476_ VGND VGND VPWR VPWR _02522_ sky130_fd_sc_hd__a31o_2
XTAP_TAPCELL_ROW_56_968 VGND VPWR sky130_fd_sc_hd__tapvpwrvgnd_1
XTAP_TAPCELL_ROW_0_251 VGND VPWR sky130_fd_sc_hd__tapvpwrvgnd_1
XTAP_TAPCELL_ROW_0_262 VGND VPWR sky130_fd_sc_hd__tapvpwrvgnd_1
XFILLER_0_36_712 VPWR VGND VPWR VGND sky130_ef_sc_hd__decap_12
XFILLER_0_118_460 VGND VGND VPWR VPWR sky130_fd_sc_hd__fill_2
XFILLER_0_63_553 VGND VGND VPWR VPWR sky130_fd_sc_hd__decap_6
XFILLER_0_23_406 VGND VGND VPWR VPWR sky130_fd_sc_hd__fill_1
XFILLER_0_106_666 VGND VGND VPWR VPWR sky130_fd_sc_hd__fill_2
XFILLER_0_105_121 VGND VGND VPWR VPWR sky130_fd_sc_hd__fill_1
XFILLER_0_63_586 VGND VGND VPWR VPWR sky130_fd_sc_hd__decap_4
XTAP_TAPCELL_ROW_97_1469 VGND VPWR sky130_fd_sc_hd__tapvpwrvgnd_1
XFILLER_0_121_669 VGND VGND VPWR VPWR sky130_fd_sc_hd__decap_3
XTAP_TAPCELL_ROW_8_362 VGND VPWR sky130_fd_sc_hd__tapvpwrvgnd_1
X_10026_ _04735_ _04736_ _04739_ _04740_ VGND VGND VPWR VPWR _04741_ sky130_fd_sc_hd__o22a_2
XFILLER_0_86_601 VPWR VGND VPWR VGND sky130_ef_sc_hd__decap_12
XFILLER_0_53_48 VGND VGND VPWR VPWR sky130_fd_sc_hd__fill_1
XTAP_TAPCELL_ROW_106_1587 VGND VPWR sky130_fd_sc_hd__tapvpwrvgnd_1
XFILLER_0_86_645 VGND VGND VPWR VPWR sky130_fd_sc_hd__decap_4
XFILLER_0_86_689 VGND VGND VPWR VPWR sky130_fd_sc_hd__decap_4
XFILLER_0_39_561 VGND VGND VPWR VPWR sky130_fd_sc_hd__decap_6
XFILLER_0_116_419 VGND VGND VPWR VPWR sky130_fd_sc_hd__fill_1
XFILLER_0_73_328 VGND VGND VPWR VPWR sky130_fd_sc_hd__decap_8
XFILLER_0_54_531 VGND VGND VPWR VPWR sky130_fd_sc_hd__fill_1
XFILLER_0_109_493 VGND VGND VPWR VPWR sky130_fd_sc_hd__fill_1
XFILLER_0_81_350 VGND VGND VPWR VPWR sky130_fd_sc_hd__fill_1
XFILLER_0_5_105 VGND VGND VPWR VPWR sky130_fd_sc_hd__decap_6
XFILLER_0_81_372 VPWR VGND VPWR VGND sky130_ef_sc_hd__decap_12
XFILLER_0_5_149 VPWR VGND VPWR VGND sky130_ef_sc_hd__decap_12
XFILLER_0_14_428 VGND VGND VPWR VPWR sky130_fd_sc_hd__fill_1
XFILLER_0_26_277 VPWR VGND VPWR VGND sky130_ef_sc_hd__decap_12
X_06050_ mac_inst.z\[26\] _00977_ _00990_ _01000_ _00989_ VGND VGND VPWR VPWR _01001_
+ sky130_fd_sc_hd__o311ai_2
XFILLER_0_41_247 VGND VGND VPWR VPWR sky130_fd_sc_hd__decap_8
XFILLER_0_111_113 VPWR VGND VPWR VGND sky130_ef_sc_hd__decap_12
XFILLER_0_78_67 VPWR VGND VPWR VGND sky130_ef_sc_hd__decap_12
XFILLER_0_10_645 VGND VGND VPWR VPWR sky130_fd_sc_hd__decap_6
XFILLER_0_10_634 VGND VGND VPWR VPWR sky130_fd_sc_hd__fill_1
X_06952_ tanh_inst.divider.z_\[-21\] _01793_ VGND VGND VPWR VPWR _01795_ sky130_fd_sc_hd__or2_2
XFILLER_0_10_689 VGND VGND VPWR VPWR sky130_fd_sc_hd__decap_8
X_09740_ _04396_ _04416_ VGND VGND VPWR VPWR _04464_ sky130_fd_sc_hd__nand2_2
.ends
